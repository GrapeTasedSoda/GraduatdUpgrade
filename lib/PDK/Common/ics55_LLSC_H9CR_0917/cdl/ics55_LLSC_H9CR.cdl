.SUBCKT INVX0P5H9R Y VDD VSS A
MI0_MXNA1 Y A VSS VSS nm1p2_svt_lp L=6e-08 W=2.1e-07
MI0_MXPA1 Y A VDD VDD pm1p2_svt_lp L=6e-08 W=2.95e-07
.ENDS

.SUBCKT INVX0P7H9R Y VDD VSS A
MI0_MXNA1 Y A VSS VSS nm1p2_svt_lp L=6e-08 W=2.95e-07
MI0_MXPA1 Y A VDD VDD pm1p2_svt_lp L=6e-08 W=4.15e-07
.ENDS

.SUBCKT INVX1H9R Y VDD VSS A
MI0_MXNA1 Y A VSS VSS nm1p2_svt_lp L=6e-08 W=4.2e-07
MI0_MXPA1 Y A VDD VDD pm1p2_svt_lp L=6e-08 W=5.85e-07
.ENDS

.SUBCKT INVX1P4H9R Y VDD VSS A
MI0_MXNA1 Y A VSS VSS nm1p2_svt_lp L=6e-08 W=2.95e-07
MI0_MXNA1_2 Y A VSS VSS nm1p2_svt_lp L=6e-08 W=2.95e-07
MI0_MXPA1 Y A VDD VDD pm1p2_svt_lp L=6e-08 W=4.15e-07
MI0_MXPA1_2 Y A VDD VDD pm1p2_svt_lp L=6e-08 W=4.15e-07
.ENDS

.SUBCKT INVX1P7H9R Y VDD VSS A
MI0_MXNA1 Y A VSS VSS nm1p2_svt_lp L=6e-08 W=3.5e-07
MI0_MXNA1_2 Y A VSS VSS nm1p2_svt_lp L=6e-08 W=3.5e-07
MI0_MXPA1 Y A VDD VDD pm1p2_svt_lp L=6e-08 W=4.9e-07
MI0_MXPA1_2 Y A VDD VDD pm1p2_svt_lp L=6e-08 W=4.9e-07
.ENDS

.SUBCKT INVX2H9R Y VDD VSS A
MI0_MXNA1 Y A VSS VSS nm1p2_svt_lp L=6e-08 W=4.2e-07
MI0_MXNA1_2 Y A VSS VSS nm1p2_svt_lp L=6e-08 W=4.2e-07
MI0_MXPA1 Y A VDD VDD pm1p2_svt_lp L=6e-08 W=5.85e-07
MI0_MXPA1_2 Y A VDD VDD pm1p2_svt_lp L=6e-08 W=5.85e-07
.ENDS

.SUBCKT INVX2P5H9R Y VDD VSS A
MI0_MXNA1 Y A VSS VSS nm1p2_svt_lp L=6e-08 W=3.5e-07
MI0_MXNA1_2 Y A VSS VSS nm1p2_svt_lp L=6e-08 W=3.5e-07
MI0_MXNA1_3 Y A VSS VSS nm1p2_svt_lp L=6e-08 W=3.5e-07
MI0_MXPA1 Y A VDD VDD pm1p2_svt_lp L=6e-08 W=4.9e-07
MI0_MXPA1_2 Y A VDD VDD pm1p2_svt_lp L=6e-08 W=4.9e-07
MI0_MXPA1_3 Y A VDD VDD pm1p2_svt_lp L=6e-08 W=4.9e-07
.ENDS

.SUBCKT INVX3H9R Y VDD VSS A
MI0_MXNA1 Y A VSS VSS nm1p2_svt_lp L=6e-08 W=4.2e-07
MI0_MXNA1_2 Y A VSS VSS nm1p2_svt_lp L=6e-08 W=4.2e-07
MI0_MXNA1_3 Y A VSS VSS nm1p2_svt_lp L=6e-08 W=4.2e-07
MI0_MXPA1 Y A VDD VDD pm1p2_svt_lp L=6e-08 W=5.85e-07
MI0_MXPA1_2 Y A VDD VDD pm1p2_svt_lp L=6e-08 W=5.85e-07
MI0_MXPA1_3 Y A VDD VDD pm1p2_svt_lp L=6e-08 W=5.85e-07
.ENDS

.SUBCKT INVX3P5H9R Y VDD VSS A
MI0_MXNA1 Y A VSS VSS nm1p2_svt_lp L=6e-08 W=3.65e-07
MI0_MXNA1_2 Y A VSS VSS nm1p2_svt_lp L=6e-08 W=3.65e-07
MI0_MXNA1_3 Y A VSS VSS nm1p2_svt_lp L=6e-08 W=3.65e-07
MI0_MXNA1_4 Y A VSS VSS nm1p2_svt_lp L=6e-08 W=3.65e-07
MI0_MXPA1 Y A VDD VDD pm1p2_svt_lp L=6e-08 W=5.1e-07
MI0_MXPA1_2 Y A VDD VDD pm1p2_svt_lp L=6e-08 W=5.1e-07
MI0_MXPA1_3 Y A VDD VDD pm1p2_svt_lp L=6e-08 W=5.1e-07
MI0_MXPA1_4 Y A VDD VDD pm1p2_svt_lp L=6e-08 W=5.1e-07
.ENDS

.SUBCKT INVX4H9R Y VDD VSS A
MI0_MXNA1 Y A VSS VSS nm1p2_svt_lp L=6e-08 W=4.2e-07
MI0_MXNA1_2 Y A VSS VSS nm1p2_svt_lp L=6e-08 W=4.2e-07
MI0_MXNA1_3 Y A VSS VSS nm1p2_svt_lp L=6e-08 W=4.2e-07
MI0_MXNA1_4 Y A VSS VSS nm1p2_svt_lp L=6e-08 W=4.2e-07
MI0_MXPA1 Y A VDD VDD pm1p2_svt_lp L=6e-08 W=5.85e-07
MI0_MXPA1_2 Y A VDD VDD pm1p2_svt_lp L=6e-08 W=5.85e-07
MI0_MXPA1_3 Y A VDD VDD pm1p2_svt_lp L=6e-08 W=5.85e-07
MI0_MXPA1_4 Y A VDD VDD pm1p2_svt_lp L=6e-08 W=5.85e-07
.ENDS

.SUBCKT INVX5H9R Y VDD VSS A
MI0_MXNA1 Y A VSS VSS nm1p2_svt_lp L=6e-08 W=4.2e-07
MI0_MXNA1_2 Y A VSS VSS nm1p2_svt_lp L=6e-08 W=4.2e-07
MI0_MXNA1_3 Y A VSS VSS nm1p2_svt_lp L=6e-08 W=4.2e-07
MI0_MXNA1_4 Y A VSS VSS nm1p2_svt_lp L=6e-08 W=4.2e-07
MI0_MXNA1_5 Y A VSS VSS nm1p2_svt_lp L=6e-08 W=4.2e-07
MI0_MXPA1 Y A VDD VDD pm1p2_svt_lp L=6e-08 W=5.85e-07
MI0_MXPA1_2 Y A VDD VDD pm1p2_svt_lp L=6e-08 W=5.85e-07
MI0_MXPA1_3 Y A VDD VDD pm1p2_svt_lp L=6e-08 W=5.85e-07
MI0_MXPA1_4 Y A VDD VDD pm1p2_svt_lp L=6e-08 W=5.85e-07
MI0_MXPA1_5 Y A VDD VDD pm1p2_svt_lp L=6e-08 W=5.85e-07
.ENDS

.SUBCKT INVX6H9R Y VDD VSS A
MI0_MXNA1 Y A VSS VSS nm1p2_svt_lp L=6e-08 W=4.2e-07
MI0_MXNA1_2 Y A VSS VSS nm1p2_svt_lp L=6e-08 W=4.2e-07
MI0_MXNA1_3 Y A VSS VSS nm1p2_svt_lp L=6e-08 W=4.2e-07
MI0_MXNA1_4 Y A VSS VSS nm1p2_svt_lp L=6e-08 W=4.2e-07
MI0_MXNA1_5 Y A VSS VSS nm1p2_svt_lp L=6e-08 W=4.2e-07
MI0_MXNA1_6 Y A VSS VSS nm1p2_svt_lp L=6e-08 W=4.2e-07
MI0_MXPA1 Y A VDD VDD pm1p2_svt_lp L=6e-08 W=5.85e-07
MI0_MXPA1_2 Y A VDD VDD pm1p2_svt_lp L=6e-08 W=5.85e-07
MI0_MXPA1_3 Y A VDD VDD pm1p2_svt_lp L=6e-08 W=5.85e-07
MI0_MXPA1_4 Y A VDD VDD pm1p2_svt_lp L=6e-08 W=5.85e-07
MI0_MXPA1_5 Y A VDD VDD pm1p2_svt_lp L=6e-08 W=5.85e-07
MI0_MXPA1_6 Y A VDD VDD pm1p2_svt_lp L=6e-08 W=5.85e-07
.ENDS

.SUBCKT INVX7P5H9R Y VDD VSS A
MI0_MXNA1 Y A VSS VSS nm1p2_svt_lp L=6e-08 W=3.95e-07
MI0_MXNA1_2 Y A VSS VSS nm1p2_svt_lp L=6e-08 W=3.95e-07
MI0_MXNA1_3 Y A VSS VSS nm1p2_svt_lp L=6e-08 W=3.95e-07
MI0_MXNA1_4 Y A VSS VSS nm1p2_svt_lp L=6e-08 W=3.95e-07
MI0_MXNA1_5 Y A VSS VSS nm1p2_svt_lp L=6e-08 W=3.95e-07
MI0_MXNA1_6 Y A VSS VSS nm1p2_svt_lp L=6e-08 W=3.95e-07
MI0_MXNA1_7 Y A VSS VSS nm1p2_svt_lp L=6e-08 W=3.95e-07
MI0_MXNA1_8 Y A VSS VSS nm1p2_svt_lp L=6e-08 W=3.95e-07
MI0_MXPA1 Y A VDD VDD pm1p2_svt_lp L=6e-08 W=5.5e-07
MI0_MXPA1_2 Y A VDD VDD pm1p2_svt_lp L=6e-08 W=5.5e-07
MI0_MXPA1_3 Y A VDD VDD pm1p2_svt_lp L=6e-08 W=5.5e-07
MI0_MXPA1_4 Y A VDD VDD pm1p2_svt_lp L=6e-08 W=5.5e-07
MI0_MXPA1_5 Y A VDD VDD pm1p2_svt_lp L=6e-08 W=5.5e-07
MI0_MXPA1_6 Y A VDD VDD pm1p2_svt_lp L=6e-08 W=5.5e-07
MI0_MXPA1_7 Y A VDD VDD pm1p2_svt_lp L=6e-08 W=5.5e-07
MI0_MXPA1_8 Y A VDD VDD pm1p2_svt_lp L=6e-08 W=5.5e-07
.ENDS

.SUBCKT INVX9H9R Y VDD VSS A
MI0_MXNA1 Y A VSS VSS nm1p2_svt_lp L=6e-08 W=4.2e-07
MI0_MXNA1_2 Y A VSS VSS nm1p2_svt_lp L=6e-08 W=4.2e-07
MI0_MXNA1_3 Y A VSS VSS nm1p2_svt_lp L=6e-08 W=4.2e-07
MI0_MXNA1_4 Y A VSS VSS nm1p2_svt_lp L=6e-08 W=4.2e-07
MI0_MXNA1_5 Y A VSS VSS nm1p2_svt_lp L=6e-08 W=4.2e-07
MI0_MXNA1_6 Y A VSS VSS nm1p2_svt_lp L=6e-08 W=4.2e-07
MI0_MXNA1_7 Y A VSS VSS nm1p2_svt_lp L=6e-08 W=4.2e-07
MI0_MXNA1_8 Y A VSS VSS nm1p2_svt_lp L=6e-08 W=4.2e-07
MI0_MXNA1_9 Y A VSS VSS nm1p2_svt_lp L=6e-08 W=4.2e-07
MI0_MXPA1 Y A VDD VDD pm1p2_svt_lp L=6e-08 W=5.85e-07
MI0_MXPA1_2 Y A VDD VDD pm1p2_svt_lp L=6e-08 W=5.85e-07
MI0_MXPA1_3 Y A VDD VDD pm1p2_svt_lp L=6e-08 W=5.85e-07
MI0_MXPA1_4 Y A VDD VDD pm1p2_svt_lp L=6e-08 W=5.85e-07
MI0_MXPA1_5 Y A VDD VDD pm1p2_svt_lp L=6e-08 W=5.85e-07
MI0_MXPA1_6 Y A VDD VDD pm1p2_svt_lp L=6e-08 W=5.85e-07
MI0_MXPA1_7 Y A VDD VDD pm1p2_svt_lp L=6e-08 W=5.85e-07
MI0_MXPA1_8 Y A VDD VDD pm1p2_svt_lp L=6e-08 W=5.85e-07
MI0_MXPA1_9 Y A VDD VDD pm1p2_svt_lp L=6e-08 W=5.85e-07
.ENDS

.SUBCKT INVX11H9R Y VDD VSS A
MI0_MXNA1 Y A VSS VSS nm1p2_svt_lp L=6e-08 W=4.2e-07
MI0_MXNA1_2 Y A VSS VSS nm1p2_svt_lp L=6e-08 W=4.2e-07
MI0_MXNA1_3 Y A VSS VSS nm1p2_svt_lp L=6e-08 W=4.2e-07
MI0_MXNA1_4 Y A VSS VSS nm1p2_svt_lp L=6e-08 W=4.2e-07
MI0_MXNA1_5 Y A VSS VSS nm1p2_svt_lp L=6e-08 W=4.2e-07
MI0_MXNA1_6 Y A VSS VSS nm1p2_svt_lp L=6e-08 W=4.2e-07
MI0_MXNA1_7 Y A VSS VSS nm1p2_svt_lp L=6e-08 W=4.2e-07
MI0_MXNA1_8 Y A VSS VSS nm1p2_svt_lp L=6e-08 W=4.2e-07
MI0_MXNA1_9 Y A VSS VSS nm1p2_svt_lp L=6e-08 W=4.2e-07
MI0_MXNA1_10 Y A VSS VSS nm1p2_svt_lp L=6e-08 W=4.2e-07
MI0_MXNA1_11 Y A VSS VSS nm1p2_svt_lp L=6e-08 W=4.2e-07
MI0_MXPA1 Y A VDD VDD pm1p2_svt_lp L=6e-08 W=5.85e-07
MI0_MXPA1_2 Y A VDD VDD pm1p2_svt_lp L=6e-08 W=5.85e-07
MI0_MXPA1_3 Y A VDD VDD pm1p2_svt_lp L=6e-08 W=5.85e-07
MI0_MXPA1_4 Y A VDD VDD pm1p2_svt_lp L=6e-08 W=5.85e-07
MI0_MXPA1_5 Y A VDD VDD pm1p2_svt_lp L=6e-08 W=5.85e-07
MI0_MXPA1_6 Y A VDD VDD pm1p2_svt_lp L=6e-08 W=5.85e-07
MI0_MXPA1_7 Y A VDD VDD pm1p2_svt_lp L=6e-08 W=5.85e-07
MI0_MXPA1_8 Y A VDD VDD pm1p2_svt_lp L=6e-08 W=5.85e-07
MI0_MXPA1_9 Y A VDD VDD pm1p2_svt_lp L=6e-08 W=5.85e-07
MI0_MXPA1_10 Y A VDD VDD pm1p2_svt_lp L=6e-08 W=5.85e-07
MI0_MXPA1_11 Y A VDD VDD pm1p2_svt_lp L=6e-08 W=5.85e-07
.ENDS

.SUBCKT INVX13H9R Y VDD VSS A
MI0_MXNA1 Y A VSS VSS nm1p2_svt_lp L=6e-08 W=4.2e-07
MI0_MXNA1_2 Y A VSS VSS nm1p2_svt_lp L=6e-08 W=4.2e-07
MI0_MXNA1_3 Y A VSS VSS nm1p2_svt_lp L=6e-08 W=4.2e-07
MI0_MXNA1_4 Y A VSS VSS nm1p2_svt_lp L=6e-08 W=4.2e-07
MI0_MXNA1_5 Y A VSS VSS nm1p2_svt_lp L=6e-08 W=4.2e-07
MI0_MXNA1_6 Y A VSS VSS nm1p2_svt_lp L=6e-08 W=4.2e-07
MI0_MXNA1_7 Y A VSS VSS nm1p2_svt_lp L=6e-08 W=4.2e-07
MI0_MXNA1_8 Y A VSS VSS nm1p2_svt_lp L=6e-08 W=4.2e-07
MI0_MXNA1_9 Y A VSS VSS nm1p2_svt_lp L=6e-08 W=4.2e-07
MI0_MXNA1_10 Y A VSS VSS nm1p2_svt_lp L=6e-08 W=4.2e-07
MI0_MXNA1_11 Y A VSS VSS nm1p2_svt_lp L=6e-08 W=4.2e-07
MI0_MXNA1_12 Y A VSS VSS nm1p2_svt_lp L=6e-08 W=4.2e-07
MI0_MXNA1_13 Y A VSS VSS nm1p2_svt_lp L=6e-08 W=4.2e-07
MI0_MXPA1 Y A VDD VDD pm1p2_svt_lp L=6e-08 W=5.85e-07
MI0_MXPA1_2 Y A VDD VDD pm1p2_svt_lp L=6e-08 W=5.85e-07
MI0_MXPA1_3 Y A VDD VDD pm1p2_svt_lp L=6e-08 W=5.85e-07
MI0_MXPA1_4 Y A VDD VDD pm1p2_svt_lp L=6e-08 W=5.85e-07
MI0_MXPA1_5 Y A VDD VDD pm1p2_svt_lp L=6e-08 W=5.85e-07
MI0_MXPA1_6 Y A VDD VDD pm1p2_svt_lp L=6e-08 W=5.85e-07
MI0_MXPA1_7 Y A VDD VDD pm1p2_svt_lp L=6e-08 W=5.85e-07
MI0_MXPA1_8 Y A VDD VDD pm1p2_svt_lp L=6e-08 W=5.85e-07
MI0_MXPA1_9 Y A VDD VDD pm1p2_svt_lp L=6e-08 W=5.85e-07
MI0_MXPA1_10 Y A VDD VDD pm1p2_svt_lp L=6e-08 W=5.85e-07
MI0_MXPA1_11 Y A VDD VDD pm1p2_svt_lp L=6e-08 W=5.85e-07
MI0_MXPA1_12 Y A VDD VDD pm1p2_svt_lp L=6e-08 W=5.85e-07
MI0_MXPA1_13 Y A VDD VDD pm1p2_svt_lp L=6e-08 W=5.85e-07
.ENDS

.SUBCKT INVX16H9R Y VDD VSS A
MI0_MXNA1 Y A VSS VSS nm1p2_svt_lp L=6e-08 W=4.2e-07
MI0_MXNA1_2 Y A VSS VSS nm1p2_svt_lp L=6e-08 W=4.2e-07
MI0_MXNA1_3 Y A VSS VSS nm1p2_svt_lp L=6e-08 W=4.2e-07
MI0_MXNA1_4 Y A VSS VSS nm1p2_svt_lp L=6e-08 W=4.2e-07
MI0_MXNA1_5 Y A VSS VSS nm1p2_svt_lp L=6e-08 W=4.2e-07
MI0_MXNA1_6 Y A VSS VSS nm1p2_svt_lp L=6e-08 W=4.2e-07
MI0_MXNA1_7 Y A VSS VSS nm1p2_svt_lp L=6e-08 W=4.2e-07
MI0_MXNA1_8 Y A VSS VSS nm1p2_svt_lp L=6e-08 W=4.2e-07
MI0_MXNA1_9 Y A VSS VSS nm1p2_svt_lp L=6e-08 W=4.2e-07
MI0_MXNA1_10 Y A VSS VSS nm1p2_svt_lp L=6e-08 W=4.2e-07
MI0_MXNA1_11 Y A VSS VSS nm1p2_svt_lp L=6e-08 W=4.2e-07
MI0_MXNA1_12 Y A VSS VSS nm1p2_svt_lp L=6e-08 W=4.2e-07
MI0_MXNA1_13 Y A VSS VSS nm1p2_svt_lp L=6e-08 W=4.2e-07
MI0_MXNA1_14 Y A VSS VSS nm1p2_svt_lp L=6e-08 W=4.2e-07
MI0_MXNA1_15 Y A VSS VSS nm1p2_svt_lp L=6e-08 W=4.2e-07
MI0_MXNA1_16 Y A VSS VSS nm1p2_svt_lp L=6e-08 W=4.2e-07
MI0_MXPA1 Y A VDD VDD pm1p2_svt_lp L=6e-08 W=5.85e-07
MI0_MXPA1_2 Y A VDD VDD pm1p2_svt_lp L=6e-08 W=5.85e-07
MI0_MXPA1_3 Y A VDD VDD pm1p2_svt_lp L=6e-08 W=5.85e-07
MI0_MXPA1_4 Y A VDD VDD pm1p2_svt_lp L=6e-08 W=5.85e-07
MI0_MXPA1_5 Y A VDD VDD pm1p2_svt_lp L=6e-08 W=5.85e-07
MI0_MXPA1_6 Y A VDD VDD pm1p2_svt_lp L=6e-08 W=5.85e-07
MI0_MXPA1_7 Y A VDD VDD pm1p2_svt_lp L=6e-08 W=5.85e-07
MI0_MXPA1_8 Y A VDD VDD pm1p2_svt_lp L=6e-08 W=5.85e-07
MI0_MXPA1_9 Y A VDD VDD pm1p2_svt_lp L=6e-08 W=5.85e-07
MI0_MXPA1_10 Y A VDD VDD pm1p2_svt_lp L=6e-08 W=5.85e-07
MI0_MXPA1_11 Y A VDD VDD pm1p2_svt_lp L=6e-08 W=5.85e-07
MI0_MXPA1_12 Y A VDD VDD pm1p2_svt_lp L=6e-08 W=5.85e-07
MI0_MXPA1_13 Y A VDD VDD pm1p2_svt_lp L=6e-08 W=5.85e-07
MI0_MXPA1_14 Y A VDD VDD pm1p2_svt_lp L=6e-08 W=5.85e-07
MI0_MXPA1_15 Y A VDD VDD pm1p2_svt_lp L=6e-08 W=5.85e-07
MI0_MXPA1_16 Y A VDD VDD pm1p2_svt_lp L=6e-08 W=5.85e-07
.ENDS

.SUBCKT BUFX0P7H9R Y VDD VSS A
MI0_MXNA1 ny A VSS VSS nm1p2_svt_lp L=6e-08 W=2.4e-07
MI1_MXNA1 Y ny VSS VSS nm1p2_svt_lp L=6e-08 W=2.95e-07
MI0_MXPA1 ny A VDD VDD pm1p2_svt_lp L=6e-08 W=3.35e-07
MI1_MXPA1 Y ny VDD VDD pm1p2_svt_lp L=6e-08 W=4.15e-07
.ENDS

.SUBCKT BUFX1H9R Y VDD VSS A
MI0_MXNA1 ny A VSS VSS nm1p2_svt_lp L=6e-08 W=3e-07
MI1_MXNA1 Y ny VSS VSS nm1p2_svt_lp L=6e-08 W=4.2e-07
MI0_MXPA1 ny A VDD VDD pm1p2_svt_lp L=6e-08 W=4.2e-07
MI1_MXPA1 Y ny VDD VDD pm1p2_svt_lp L=6e-08 W=5.85e-07
.ENDS

.SUBCKT BUFX1P4H9R Y VDD VSS A
MI0_MXNA1 ny A VSS VSS nm1p2_svt_lp L=6e-08 W=4.05e-07
MI1_MXNA1 Y ny VSS VSS nm1p2_svt_lp L=6e-08 W=2.95e-07
MI1_MXNA1_2 Y ny VSS VSS nm1p2_svt_lp L=6e-08 W=2.95e-07
MI0_MXPA1 ny A VDD VDD pm1p2_svt_lp L=6e-08 W=5.65e-07
MI1_MXPA1 Y ny VDD VDD pm1p2_svt_lp L=6e-08 W=4.15e-07
MI1_MXPA1_2 Y ny VDD VDD pm1p2_svt_lp L=6e-08 W=4.15e-07
.ENDS

.SUBCKT BUFX1P7H9R Y VDD VSS A
MI0_MXNA1 ny A VSS VSS nm1p2_svt_lp L=6e-08 W=2.45e-07
MI0_MXNA1_2 ny A VSS VSS nm1p2_svt_lp L=6e-08 W=2.45e-07
MI1_MXNA1 Y ny VSS VSS nm1p2_svt_lp L=6e-08 W=3.5e-07
MI1_MXNA1_2 Y ny VSS VSS nm1p2_svt_lp L=6e-08 W=3.5e-07
MI0_MXPA1 ny A VDD VDD pm1p2_svt_lp L=6e-08 W=3.4e-07
MI0_MXPA1_2 ny A VDD VDD pm1p2_svt_lp L=6e-08 W=3.4e-07
MI1_MXPA1 Y ny VDD VDD pm1p2_svt_lp L=6e-08 W=4.9e-07
MI1_MXPA1_2 Y ny VDD VDD pm1p2_svt_lp L=6e-08 W=4.9e-07
.ENDS

.SUBCKT BUFX2H9R Y VDD VSS A
MI0_MXNA1 ny A VSS VSS nm1p2_svt_lp L=6e-08 W=2.8e-07
MI0_MXNA1_2 ny A VSS VSS nm1p2_svt_lp L=6e-08 W=2.8e-07
MI1_MXNA1 Y ny VSS VSS nm1p2_svt_lp L=6e-08 W=4.2e-07
MI1_MXNA1_2 Y ny VSS VSS nm1p2_svt_lp L=6e-08 W=4.2e-07
MI0_MXPA1 ny A VDD VDD pm1p2_svt_lp L=6e-08 W=3.9e-07
MI0_MXPA1_2 ny A VDD VDD pm1p2_svt_lp L=6e-08 W=3.9e-07
MI1_MXPA1 Y ny VDD VDD pm1p2_svt_lp L=6e-08 W=5.85e-07
MI1_MXPA1_2 Y ny VDD VDD pm1p2_svt_lp L=6e-08 W=5.85e-07
.ENDS

.SUBCKT BUFX2P5H9R Y VDD VSS A
MI0_MXNA1 ny A VSS VSS nm1p2_svt_lp L=6e-08 W=3.4e-07
MI0_MXNA1_2 ny A VSS VSS nm1p2_svt_lp L=6e-08 W=3.4e-07
MI1_MXNA1 Y ny VSS VSS nm1p2_svt_lp L=6e-08 W=3.5e-07
MI1_MXNA1_2 Y ny VSS VSS nm1p2_svt_lp L=6e-08 W=3.5e-07
MI1_MXNA1_3 Y ny VSS VSS nm1p2_svt_lp L=6e-08 W=3.5e-07
MI0_MXPA1 ny A VDD VDD pm1p2_svt_lp L=6e-08 W=4.8e-07
MI0_MXPA1_2 ny A VDD VDD pm1p2_svt_lp L=6e-08 W=4.8e-07
MI1_MXPA1 Y ny VDD VDD pm1p2_svt_lp L=6e-08 W=4.9e-07
MI1_MXPA1_2 Y ny VDD VDD pm1p2_svt_lp L=6e-08 W=4.9e-07
MI1_MXPA1_3 Y ny VDD VDD pm1p2_svt_lp L=6e-08 W=4.9e-07
.ENDS

.SUBCKT BUFX3H9R Y VDD VSS A
MI0_MXNA1 ny A VSS VSS nm1p2_svt_lp L=6e-08 W=3.95e-07
MI0_MXNA1_2 ny A VSS VSS nm1p2_svt_lp L=6e-08 W=3.95e-07
MI1_MXNA1 Y ny VSS VSS nm1p2_svt_lp L=6e-08 W=4.2e-07
MI1_MXNA1_2 Y ny VSS VSS nm1p2_svt_lp L=6e-08 W=4.2e-07
MI1_MXNA1_3 Y ny VSS VSS nm1p2_svt_lp L=6e-08 W=4.2e-07
MI0_MXPA1 ny A VDD VDD pm1p2_svt_lp L=6e-08 W=5.5e-07
MI0_MXPA1_2 ny A VDD VDD pm1p2_svt_lp L=6e-08 W=5.5e-07
MI1_MXPA1 Y ny VDD VDD pm1p2_svt_lp L=6e-08 W=5.85e-07
MI1_MXPA1_2 Y ny VDD VDD pm1p2_svt_lp L=6e-08 W=5.85e-07
MI1_MXPA1_3 Y ny VDD VDD pm1p2_svt_lp L=6e-08 W=5.85e-07
.ENDS

.SUBCKT BUFX3P5H9R Y VDD VSS A
MI0_MXNA1 ny A VSS VSS nm1p2_svt_lp L=6e-08 W=3.25e-07
MI0_MXNA1_2 ny A VSS VSS nm1p2_svt_lp L=6e-08 W=3.25e-07
MI0_MXNA1_3 ny A VSS VSS nm1p2_svt_lp L=6e-08 W=3.25e-07
MI1_MXNA1 Y ny VSS VSS nm1p2_svt_lp L=6e-08 W=3.65e-07
MI1_MXNA1_2 Y ny VSS VSS nm1p2_svt_lp L=6e-08 W=3.65e-07
MI1_MXNA1_3 Y ny VSS VSS nm1p2_svt_lp L=6e-08 W=3.65e-07
MI1_MXNA1_4 Y ny VSS VSS nm1p2_svt_lp L=6e-08 W=3.65e-07
MI0_MXPA1 ny A VDD VDD pm1p2_svt_lp L=6e-08 W=4.6e-07
MI0_MXPA1_2 ny A VDD VDD pm1p2_svt_lp L=6e-08 W=4.6e-07
MI0_MXPA1_3 ny A VDD VDD pm1p2_svt_lp L=6e-08 W=4.6e-07
MI1_MXPA1 Y ny VDD VDD pm1p2_svt_lp L=6e-08 W=5.1e-07
MI1_MXPA1_2 Y ny VDD VDD pm1p2_svt_lp L=6e-08 W=5.1e-07
MI1_MXPA1_3 Y ny VDD VDD pm1p2_svt_lp L=6e-08 W=5.1e-07
MI1_MXPA1_4 Y ny VDD VDD pm1p2_svt_lp L=6e-08 W=5.1e-07
.ENDS

.SUBCKT BUFX4H9R Y VDD VSS A
MI0_MXNA1 ny A VSS VSS nm1p2_svt_lp L=6e-08 W=3.65e-07
MI0_MXNA1_2 ny A VSS VSS nm1p2_svt_lp L=6e-08 W=3.65e-07
MI0_MXNA1_3 ny A VSS VSS nm1p2_svt_lp L=6e-08 W=3.65e-07
MI1_MXNA1 Y ny VSS VSS nm1p2_svt_lp L=6e-08 W=4.2e-07
MI1_MXNA1_2 Y ny VSS VSS nm1p2_svt_lp L=6e-08 W=4.2e-07
MI1_MXNA1_3 Y ny VSS VSS nm1p2_svt_lp L=6e-08 W=4.2e-07
MI1_MXNA1_4 Y ny VSS VSS nm1p2_svt_lp L=6e-08 W=4.2e-07
MI0_MXPA1 ny A VDD VDD pm1p2_svt_lp L=6e-08 W=5.1e-07
MI0_MXPA1_2 ny A VDD VDD pm1p2_svt_lp L=6e-08 W=5.1e-07
MI0_MXPA1_3 ny A VDD VDD pm1p2_svt_lp L=6e-08 W=5.1e-07
MI1_MXPA1 Y ny VDD VDD pm1p2_svt_lp L=6e-08 W=5.85e-07
MI1_MXPA1_2 Y ny VDD VDD pm1p2_svt_lp L=6e-08 W=5.85e-07
MI1_MXPA1_3 Y ny VDD VDD pm1p2_svt_lp L=6e-08 W=5.85e-07
MI1_MXPA1_4 Y ny VDD VDD pm1p2_svt_lp L=6e-08 W=5.85e-07
.ENDS

.SUBCKT BUFX5H9R Y VDD VSS A
MI0_MXNA1 ny A VSS VSS nm1p2_svt_lp L=6e-08 W=3.4e-07
MI0_MXNA1_2 ny A VSS VSS nm1p2_svt_lp L=6e-08 W=3.4e-07
MI0_MXNA1_3 ny A VSS VSS nm1p2_svt_lp L=6e-08 W=3.4e-07
MI0_MXNA1_4 ny A VSS VSS nm1p2_svt_lp L=6e-08 W=3.4e-07
MI1_MXNA1 Y ny VSS VSS nm1p2_svt_lp L=6e-08 W=4.2e-07
MI1_MXNA1_2 Y ny VSS VSS nm1p2_svt_lp L=6e-08 W=4.2e-07
MI1_MXNA1_3 Y ny VSS VSS nm1p2_svt_lp L=6e-08 W=4.2e-07
MI1_MXNA1_4 Y ny VSS VSS nm1p2_svt_lp L=6e-08 W=4.2e-07
MI1_MXNA1_5 Y ny VSS VSS nm1p2_svt_lp L=6e-08 W=4.2e-07
MI0_MXPA1 ny A VDD VDD pm1p2_svt_lp L=6e-08 W=4.75e-07
MI0_MXPA1_2 ny A VDD VDD pm1p2_svt_lp L=6e-08 W=4.75e-07
MI0_MXPA1_3 ny A VDD VDD pm1p2_svt_lp L=6e-08 W=4.75e-07
MI0_MXPA1_4 ny A VDD VDD pm1p2_svt_lp L=6e-08 W=4.75e-07
MI1_MXPA1 Y ny VDD VDD pm1p2_svt_lp L=6e-08 W=5.85e-07
MI1_MXPA1_2 Y ny VDD VDD pm1p2_svt_lp L=6e-08 W=5.85e-07
MI1_MXPA1_3 Y ny VDD VDD pm1p2_svt_lp L=6e-08 W=5.85e-07
MI1_MXPA1_4 Y ny VDD VDD pm1p2_svt_lp L=6e-08 W=5.85e-07
MI1_MXPA1_5 Y ny VDD VDD pm1p2_svt_lp L=6e-08 W=5.85e-07
.ENDS

.SUBCKT BUFX6H9R Y VDD VSS A
MI0_MXNA1 ny A VSS VSS nm1p2_svt_lp L=6e-08 W=4e-07
MI0_MXNA1_2 ny A VSS VSS nm1p2_svt_lp L=6e-08 W=4e-07
MI0_MXNA1_3 ny A VSS VSS nm1p2_svt_lp L=6e-08 W=4e-07
MI0_MXNA1_4 ny A VSS VSS nm1p2_svt_lp L=6e-08 W=4e-07
MI1_MXNA1 Y ny VSS VSS nm1p2_svt_lp L=6e-08 W=4.2e-07
MI1_MXNA1_2 Y ny VSS VSS nm1p2_svt_lp L=6e-08 W=4.2e-07
MI1_MXNA1_3 Y ny VSS VSS nm1p2_svt_lp L=6e-08 W=4.2e-07
MI1_MXNA1_4 Y ny VSS VSS nm1p2_svt_lp L=6e-08 W=4.2e-07
MI1_MXNA1_5 Y ny VSS VSS nm1p2_svt_lp L=6e-08 W=4.2e-07
MI1_MXNA1_6 Y ny VSS VSS nm1p2_svt_lp L=6e-08 W=4.2e-07
MI0_MXPA1 ny A VDD VDD pm1p2_svt_lp L=6e-08 W=5.6e-07
MI0_MXPA1_2 ny A VDD VDD pm1p2_svt_lp L=6e-08 W=5.6e-07
MI0_MXPA1_3 ny A VDD VDD pm1p2_svt_lp L=6e-08 W=5.6e-07
MI0_MXPA1_4 ny A VDD VDD pm1p2_svt_lp L=6e-08 W=5.6e-07
MI1_MXPA1 Y ny VDD VDD pm1p2_svt_lp L=6e-08 W=5.85e-07
MI1_MXPA1_2 Y ny VDD VDD pm1p2_svt_lp L=6e-08 W=5.85e-07
MI1_MXPA1_3 Y ny VDD VDD pm1p2_svt_lp L=6e-08 W=5.85e-07
MI1_MXPA1_4 Y ny VDD VDD pm1p2_svt_lp L=6e-08 W=5.85e-07
MI1_MXPA1_5 Y ny VDD VDD pm1p2_svt_lp L=6e-08 W=5.85e-07
MI1_MXPA1_6 Y ny VDD VDD pm1p2_svt_lp L=6e-08 W=5.85e-07
.ENDS

.SUBCKT BUFX7P5H9R Y VDD VSS A
MI0_MXNA1 ny A VSS VSS nm1p2_svt_lp L=6e-08 W=4.05e-07
MI0_MXNA1_2 ny A VSS VSS nm1p2_svt_lp L=6e-08 W=4.05e-07
MI0_MXNA1_3 ny A VSS VSS nm1p2_svt_lp L=6e-08 W=4.05e-07
MI0_MXNA1_4 ny A VSS VSS nm1p2_svt_lp L=6e-08 W=4.05e-07
MI0_MXNA1_5 ny A VSS VSS nm1p2_svt_lp L=6e-08 W=4.05e-07
MI1_MXNA1 Y ny VSS VSS nm1p2_svt_lp L=6e-08 W=3.95e-07
MI1_MXNA1_2 Y ny VSS VSS nm1p2_svt_lp L=6e-08 W=3.95e-07
MI1_MXNA1_3 Y ny VSS VSS nm1p2_svt_lp L=6e-08 W=3.95e-07
MI1_MXNA1_4 Y ny VSS VSS nm1p2_svt_lp L=6e-08 W=3.95e-07
MI1_MXNA1_5 Y ny VSS VSS nm1p2_svt_lp L=6e-08 W=3.95e-07
MI1_MXNA1_6 Y ny VSS VSS nm1p2_svt_lp L=6e-08 W=3.95e-07
MI1_MXNA1_7 Y ny VSS VSS nm1p2_svt_lp L=6e-08 W=3.95e-07
MI1_MXNA1_8 Y ny VSS VSS nm1p2_svt_lp L=6e-08 W=3.95e-07
MI0_MXPA1 ny A VDD VDD pm1p2_svt_lp L=6e-08 W=5.65e-07
MI0_MXPA1_2 ny A VDD VDD pm1p2_svt_lp L=6e-08 W=5.65e-07
MI0_MXPA1_3 ny A VDD VDD pm1p2_svt_lp L=6e-08 W=5.65e-07
MI0_MXPA1_4 ny A VDD VDD pm1p2_svt_lp L=6e-08 W=5.65e-07
MI0_MXPA1_5 ny A VDD VDD pm1p2_svt_lp L=6e-08 W=5.65e-07
MI1_MXPA1 Y ny VDD VDD pm1p2_svt_lp L=6e-08 W=5.5e-07
MI1_MXPA1_2 Y ny VDD VDD pm1p2_svt_lp L=6e-08 W=5.5e-07
MI1_MXPA1_3 Y ny VDD VDD pm1p2_svt_lp L=6e-08 W=5.5e-07
MI1_MXPA1_4 Y ny VDD VDD pm1p2_svt_lp L=6e-08 W=5.5e-07
MI1_MXPA1_5 Y ny VDD VDD pm1p2_svt_lp L=6e-08 W=5.5e-07
MI1_MXPA1_6 Y ny VDD VDD pm1p2_svt_lp L=6e-08 W=5.5e-07
MI1_MXPA1_7 Y ny VDD VDD pm1p2_svt_lp L=6e-08 W=5.5e-07
MI1_MXPA1_8 Y ny VDD VDD pm1p2_svt_lp L=6e-08 W=5.5e-07
.ENDS

.SUBCKT BUFX9H9R Y VDD VSS A
MI0_MXNA1 ny A VSS VSS nm1p2_svt_lp L=6e-08 W=4e-07
MI0_MXNA1_2 ny A VSS VSS nm1p2_svt_lp L=6e-08 W=4e-07
MI0_MXNA1_3 ny A VSS VSS nm1p2_svt_lp L=6e-08 W=4e-07
MI0_MXNA1_4 ny A VSS VSS nm1p2_svt_lp L=6e-08 W=4e-07
MI0_MXNA1_5 ny A VSS VSS nm1p2_svt_lp L=6e-08 W=4e-07
MI0_MXNA1_6 ny A VSS VSS nm1p2_svt_lp L=6e-08 W=4e-07
MI1_MXNA1 Y ny VSS VSS nm1p2_svt_lp L=6e-08 W=4.2e-07
MI1_MXNA1_2 Y ny VSS VSS nm1p2_svt_lp L=6e-08 W=4.2e-07
MI1_MXNA1_3 Y ny VSS VSS nm1p2_svt_lp L=6e-08 W=4.2e-07
MI1_MXNA1_4 Y ny VSS VSS nm1p2_svt_lp L=6e-08 W=4.2e-07
MI1_MXNA1_5 Y ny VSS VSS nm1p2_svt_lp L=6e-08 W=4.2e-07
MI1_MXNA1_6 Y ny VSS VSS nm1p2_svt_lp L=6e-08 W=4.2e-07
MI1_MXNA1_7 Y ny VSS VSS nm1p2_svt_lp L=6e-08 W=4.2e-07
MI1_MXNA1_8 Y ny VSS VSS nm1p2_svt_lp L=6e-08 W=4.2e-07
MI1_MXNA1_9 Y ny VSS VSS nm1p2_svt_lp L=6e-08 W=4.2e-07
MI0_MXPA1 ny A VDD VDD pm1p2_svt_lp L=6e-08 W=5.6e-07
MI0_MXPA1_2 ny A VDD VDD pm1p2_svt_lp L=6e-08 W=5.6e-07
MI0_MXPA1_3 ny A VDD VDD pm1p2_svt_lp L=6e-08 W=5.6e-07
MI0_MXPA1_4 ny A VDD VDD pm1p2_svt_lp L=6e-08 W=5.6e-07
MI0_MXPA1_5 ny A VDD VDD pm1p2_svt_lp L=6e-08 W=5.6e-07
MI0_MXPA1_6 ny A VDD VDD pm1p2_svt_lp L=6e-08 W=5.6e-07
MI1_MXPA1 Y ny VDD VDD pm1p2_svt_lp L=6e-08 W=5.85e-07
MI1_MXPA1_2 Y ny VDD VDD pm1p2_svt_lp L=6e-08 W=5.85e-07
MI1_MXPA1_3 Y ny VDD VDD pm1p2_svt_lp L=6e-08 W=5.85e-07
MI1_MXPA1_4 Y ny VDD VDD pm1p2_svt_lp L=6e-08 W=5.85e-07
MI1_MXPA1_5 Y ny VDD VDD pm1p2_svt_lp L=6e-08 W=5.85e-07
MI1_MXPA1_6 Y ny VDD VDD pm1p2_svt_lp L=6e-08 W=5.85e-07
MI1_MXPA1_7 Y ny VDD VDD pm1p2_svt_lp L=6e-08 W=5.85e-07
MI1_MXPA1_8 Y ny VDD VDD pm1p2_svt_lp L=6e-08 W=5.85e-07
MI1_MXPA1_9 Y ny VDD VDD pm1p2_svt_lp L=6e-08 W=5.85e-07
.ENDS

.SUBCKT BUFX11H9R Y VDD VSS A
MI0_MXNA1 ny A VSS VSS nm1p2_svt_lp L=6e-08 W=4.2e-07
MI0_MXNA1_2 ny A VSS VSS nm1p2_svt_lp L=6e-08 W=4.2e-07
MI0_MXNA1_3 ny A VSS VSS nm1p2_svt_lp L=6e-08 W=4.2e-07
MI0_MXNA1_4 ny A VSS VSS nm1p2_svt_lp L=6e-08 W=4.2e-07
MI0_MXNA1_5 ny A VSS VSS nm1p2_svt_lp L=6e-08 W=4.2e-07
MI0_MXNA1_6 ny A VSS VSS nm1p2_svt_lp L=6e-08 W=4.2e-07
MI0_MXNA1_7 ny A VSS VSS nm1p2_svt_lp L=6e-08 W=4.2e-07
MI1_MXNA1 Y ny VSS VSS nm1p2_svt_lp L=6e-08 W=4.2e-07
MI1_MXNA1_2 Y ny VSS VSS nm1p2_svt_lp L=6e-08 W=4.2e-07
MI1_MXNA1_3 Y ny VSS VSS nm1p2_svt_lp L=6e-08 W=4.2e-07
MI1_MXNA1_4 Y ny VSS VSS nm1p2_svt_lp L=6e-08 W=4.2e-07
MI1_MXNA1_5 Y ny VSS VSS nm1p2_svt_lp L=6e-08 W=4.2e-07
MI1_MXNA1_6 Y ny VSS VSS nm1p2_svt_lp L=6e-08 W=4.2e-07
MI1_MXNA1_7 Y ny VSS VSS nm1p2_svt_lp L=6e-08 W=4.2e-07
MI1_MXNA1_8 Y ny VSS VSS nm1p2_svt_lp L=6e-08 W=4.2e-07
MI1_MXNA1_9 Y ny VSS VSS nm1p2_svt_lp L=6e-08 W=4.2e-07
MI1_MXNA1_10 Y ny VSS VSS nm1p2_svt_lp L=6e-08 W=4.2e-07
MI1_MXNA1_11 Y ny VSS VSS nm1p2_svt_lp L=6e-08 W=4.2e-07
MI0_MXPA1 ny A VDD VDD pm1p2_svt_lp L=6e-08 W=5.85e-07
MI0_MXPA1_2 ny A VDD VDD pm1p2_svt_lp L=6e-08 W=5.85e-07
MI0_MXPA1_3 ny A VDD VDD pm1p2_svt_lp L=6e-08 W=5.85e-07
MI0_MXPA1_4 ny A VDD VDD pm1p2_svt_lp L=6e-08 W=5.85e-07
MI0_MXPA1_5 ny A VDD VDD pm1p2_svt_lp L=6e-08 W=5.85e-07
MI0_MXPA1_6 ny A VDD VDD pm1p2_svt_lp L=6e-08 W=5.85e-07
MI0_MXPA1_7 ny A VDD VDD pm1p2_svt_lp L=6e-08 W=5.85e-07
MI1_MXPA1 Y ny VDD VDD pm1p2_svt_lp L=6e-08 W=5.85e-07
MI1_MXPA1_2 Y ny VDD VDD pm1p2_svt_lp L=6e-08 W=5.85e-07
MI1_MXPA1_3 Y ny VDD VDD pm1p2_svt_lp L=6e-08 W=5.85e-07
MI1_MXPA1_4 Y ny VDD VDD pm1p2_svt_lp L=6e-08 W=5.85e-07
MI1_MXPA1_5 Y ny VDD VDD pm1p2_svt_lp L=6e-08 W=5.85e-07
MI1_MXPA1_6 Y ny VDD VDD pm1p2_svt_lp L=6e-08 W=5.85e-07
MI1_MXPA1_7 Y ny VDD VDD pm1p2_svt_lp L=6e-08 W=5.85e-07
MI1_MXPA1_8 Y ny VDD VDD pm1p2_svt_lp L=6e-08 W=5.85e-07
MI1_MXPA1_9 Y ny VDD VDD pm1p2_svt_lp L=6e-08 W=5.85e-07
MI1_MXPA1_10 Y ny VDD VDD pm1p2_svt_lp L=6e-08 W=5.85e-07
MI1_MXPA1_11 Y ny VDD VDD pm1p2_svt_lp L=6e-08 W=5.85e-07
.ENDS

.SUBCKT BUFX13H9R Y VDD VSS A
MI0_MXNA1 ny A VSS VSS nm1p2_svt_lp L=6e-08 W=4.2e-07
MI0_MXNA1_2 ny A VSS VSS nm1p2_svt_lp L=6e-08 W=4.2e-07
MI0_MXNA1_3 ny A VSS VSS nm1p2_svt_lp L=6e-08 W=4.2e-07
MI0_MXNA1_4 ny A VSS VSS nm1p2_svt_lp L=6e-08 W=4.2e-07
MI0_MXNA1_5 ny A VSS VSS nm1p2_svt_lp L=6e-08 W=4.2e-07
MI0_MXNA1_6 ny A VSS VSS nm1p2_svt_lp L=6e-08 W=4.2e-07
MI0_MXNA1_7 ny A VSS VSS nm1p2_svt_lp L=6e-08 W=4.2e-07
MI0_MXNA1_8 ny A VSS VSS nm1p2_svt_lp L=6e-08 W=4.2e-07
MI1_MXNA1 Y ny VSS VSS nm1p2_svt_lp L=6e-08 W=4.2e-07
MI1_MXNA1_2 Y ny VSS VSS nm1p2_svt_lp L=6e-08 W=4.2e-07
MI1_MXNA1_3 Y ny VSS VSS nm1p2_svt_lp L=6e-08 W=4.2e-07
MI1_MXNA1_4 Y ny VSS VSS nm1p2_svt_lp L=6e-08 W=4.2e-07
MI1_MXNA1_5 Y ny VSS VSS nm1p2_svt_lp L=6e-08 W=4.2e-07
MI1_MXNA1_6 Y ny VSS VSS nm1p2_svt_lp L=6e-08 W=4.2e-07
MI1_MXNA1_7 Y ny VSS VSS nm1p2_svt_lp L=6e-08 W=4.2e-07
MI1_MXNA1_8 Y ny VSS VSS nm1p2_svt_lp L=6e-08 W=4.2e-07
MI1_MXNA1_9 Y ny VSS VSS nm1p2_svt_lp L=6e-08 W=4.2e-07
MI1_MXNA1_10 Y ny VSS VSS nm1p2_svt_lp L=6e-08 W=4.2e-07
MI1_MXNA1_11 Y ny VSS VSS nm1p2_svt_lp L=6e-08 W=4.2e-07
MI1_MXNA1_12 Y ny VSS VSS nm1p2_svt_lp L=6e-08 W=4.2e-07
MI1_MXNA1_13 Y ny VSS VSS nm1p2_svt_lp L=6e-08 W=4.2e-07
MI0_MXPA1 ny A VDD VDD pm1p2_svt_lp L=6e-08 W=5.85e-07
MI0_MXPA1_2 ny A VDD VDD pm1p2_svt_lp L=6e-08 W=5.85e-07
MI0_MXPA1_3 ny A VDD VDD pm1p2_svt_lp L=6e-08 W=5.85e-07
MI0_MXPA1_4 ny A VDD VDD pm1p2_svt_lp L=6e-08 W=5.85e-07
MI0_MXPA1_5 ny A VDD VDD pm1p2_svt_lp L=6e-08 W=5.85e-07
MI0_MXPA1_6 ny A VDD VDD pm1p2_svt_lp L=6e-08 W=5.85e-07
MI0_MXPA1_7 ny A VDD VDD pm1p2_svt_lp L=6e-08 W=5.85e-07
MI0_MXPA1_8 ny A VDD VDD pm1p2_svt_lp L=6e-08 W=5.85e-07
MI1_MXPA1 Y ny VDD VDD pm1p2_svt_lp L=6e-08 W=5.85e-07
MI1_MXPA1_2 Y ny VDD VDD pm1p2_svt_lp L=6e-08 W=5.85e-07
MI1_MXPA1_3 Y ny VDD VDD pm1p2_svt_lp L=6e-08 W=5.85e-07
MI1_MXPA1_4 Y ny VDD VDD pm1p2_svt_lp L=6e-08 W=5.85e-07
MI1_MXPA1_5 Y ny VDD VDD pm1p2_svt_lp L=6e-08 W=5.85e-07
MI1_MXPA1_6 Y ny VDD VDD pm1p2_svt_lp L=6e-08 W=5.85e-07
MI1_MXPA1_7 Y ny VDD VDD pm1p2_svt_lp L=6e-08 W=5.85e-07
MI1_MXPA1_8 Y ny VDD VDD pm1p2_svt_lp L=6e-08 W=5.85e-07
MI1_MXPA1_9 Y ny VDD VDD pm1p2_svt_lp L=6e-08 W=5.85e-07
MI1_MXPA1_10 Y ny VDD VDD pm1p2_svt_lp L=6e-08 W=5.85e-07
MI1_MXPA1_11 Y ny VDD VDD pm1p2_svt_lp L=6e-08 W=5.85e-07
MI1_MXPA1_12 Y ny VDD VDD pm1p2_svt_lp L=6e-08 W=5.85e-07
MI1_MXPA1_13 Y ny VDD VDD pm1p2_svt_lp L=6e-08 W=5.85e-07
.ENDS

.SUBCKT BUFX16H9R Y VDD VSS A
MI0_MXNA1 ny A VSS VSS nm1p2_svt_lp L=6e-08 W=4.2e-07
MI0_MXNA1_2 ny A VSS VSS nm1p2_svt_lp L=6e-08 W=4.2e-07
MI0_MXNA1_3 ny A VSS VSS nm1p2_svt_lp L=6e-08 W=4.2e-07
MI0_MXNA1_4 ny A VSS VSS nm1p2_svt_lp L=6e-08 W=4.2e-07
MI0_MXNA1_5 ny A VSS VSS nm1p2_svt_lp L=6e-08 W=4.2e-07
MI0_MXNA1_6 ny A VSS VSS nm1p2_svt_lp L=6e-08 W=4.2e-07
MI0_MXNA1_7 ny A VSS VSS nm1p2_svt_lp L=6e-08 W=4.2e-07
MI0_MXNA1_8 ny A VSS VSS nm1p2_svt_lp L=6e-08 W=4.2e-07
MI0_MXNA1_9 ny A VSS VSS nm1p2_svt_lp L=6e-08 W=4.2e-07
MI0_MXNA1_10 ny A VSS VSS nm1p2_svt_lp L=6e-08 W=4.2e-07
MI1_MXNA1 Y ny VSS VSS nm1p2_svt_lp L=6e-08 W=4.2e-07
MI1_MXNA1_2 Y ny VSS VSS nm1p2_svt_lp L=6e-08 W=4.2e-07
MI1_MXNA1_3 Y ny VSS VSS nm1p2_svt_lp L=6e-08 W=4.2e-07
MI1_MXNA1_4 Y ny VSS VSS nm1p2_svt_lp L=6e-08 W=4.2e-07
MI1_MXNA1_5 Y ny VSS VSS nm1p2_svt_lp L=6e-08 W=4.2e-07
MI1_MXNA1_6 Y ny VSS VSS nm1p2_svt_lp L=6e-08 W=4.2e-07
MI1_MXNA1_7 Y ny VSS VSS nm1p2_svt_lp L=6e-08 W=4.2e-07
MI1_MXNA1_8 Y ny VSS VSS nm1p2_svt_lp L=6e-08 W=4.2e-07
MI1_MXNA1_9 Y ny VSS VSS nm1p2_svt_lp L=6e-08 W=4.2e-07
MI1_MXNA1_10 Y ny VSS VSS nm1p2_svt_lp L=6e-08 W=4.2e-07
MI1_MXNA1_11 Y ny VSS VSS nm1p2_svt_lp L=6e-08 W=4.2e-07
MI1_MXNA1_12 Y ny VSS VSS nm1p2_svt_lp L=6e-08 W=4.2e-07
MI1_MXNA1_13 Y ny VSS VSS nm1p2_svt_lp L=6e-08 W=4.2e-07
MI1_MXNA1_14 Y ny VSS VSS nm1p2_svt_lp L=6e-08 W=4.2e-07
MI1_MXNA1_15 Y ny VSS VSS nm1p2_svt_lp L=6e-08 W=4.2e-07
MI1_MXNA1_16 Y ny VSS VSS nm1p2_svt_lp L=6e-08 W=4.2e-07
MI0_MXPA1 ny A VDD VDD pm1p2_svt_lp L=6e-08 W=5.85e-07
MI0_MXPA1_2 ny A VDD VDD pm1p2_svt_lp L=6e-08 W=5.85e-07
MI0_MXPA1_3 ny A VDD VDD pm1p2_svt_lp L=6e-08 W=5.85e-07
MI0_MXPA1_4 ny A VDD VDD pm1p2_svt_lp L=6e-08 W=5.85e-07
MI0_MXPA1_5 ny A VDD VDD pm1p2_svt_lp L=6e-08 W=5.85e-07
MI0_MXPA1_6 ny A VDD VDD pm1p2_svt_lp L=6e-08 W=5.85e-07
MI0_MXPA1_7 ny A VDD VDD pm1p2_svt_lp L=6e-08 W=5.85e-07
MI0_MXPA1_8 ny A VDD VDD pm1p2_svt_lp L=6e-08 W=5.85e-07
MI0_MXPA1_9 ny A VDD VDD pm1p2_svt_lp L=6e-08 W=5.85e-07
MI0_MXPA1_10 ny A VDD VDD pm1p2_svt_lp L=6e-08 W=5.85e-07
MI1_MXPA1 Y ny VDD VDD pm1p2_svt_lp L=6e-08 W=5.85e-07
MI1_MXPA1_2 Y ny VDD VDD pm1p2_svt_lp L=6e-08 W=5.85e-07
MI1_MXPA1_3 Y ny VDD VDD pm1p2_svt_lp L=6e-08 W=5.85e-07
MI1_MXPA1_4 Y ny VDD VDD pm1p2_svt_lp L=6e-08 W=5.85e-07
MI1_MXPA1_5 Y ny VDD VDD pm1p2_svt_lp L=6e-08 W=5.85e-07
MI1_MXPA1_6 Y ny VDD VDD pm1p2_svt_lp L=6e-08 W=5.85e-07
MI1_MXPA1_7 Y ny VDD VDD pm1p2_svt_lp L=6e-08 W=5.85e-07
MI1_MXPA1_8 Y ny VDD VDD pm1p2_svt_lp L=6e-08 W=5.85e-07
MI1_MXPA1_9 Y ny VDD VDD pm1p2_svt_lp L=6e-08 W=5.85e-07
MI1_MXPA1_10 Y ny VDD VDD pm1p2_svt_lp L=6e-08 W=5.85e-07
MI1_MXPA1_11 Y ny VDD VDD pm1p2_svt_lp L=6e-08 W=5.85e-07
MI1_MXPA1_12 Y ny VDD VDD pm1p2_svt_lp L=6e-08 W=5.85e-07
MI1_MXPA1_13 Y ny VDD VDD pm1p2_svt_lp L=6e-08 W=5.85e-07
MI1_MXPA1_14 Y ny VDD VDD pm1p2_svt_lp L=6e-08 W=5.85e-07
MI1_MXPA1_15 Y ny VDD VDD pm1p2_svt_lp L=6e-08 W=5.85e-07
MI1_MXPA1_16 Y ny VDD VDD pm1p2_svt_lp L=6e-08 W=5.85e-07
.ENDS

.SUBCKT TBUFX1H9R Y VDD VSS A OE
MXN4 p1 OE n1 VSS nm1p2_svt_lp L=6e-08 W=1.5e-07
MXN2 n1 A VSS VSS nm1p2_svt_lp L=6e-08 W=1.85e-07
MI13_MXNA1 noe OE VSS VSS nm1p2_svt_lp L=6e-08 W=2.2e-07
MXN1 n1 noe VSS VSS nm1p2_svt_lp L=6e-08 W=1.5e-07
MXN3 Y n1 VSS VSS nm1p2_svt_lp L=6e-08 W=3.7e-07
MXP6 n1 noe p1 VDD pm1p2_svt_lp L=6e-08 W=1.5e-07
MXP3 p1 A VDD VDD pm1p2_svt_lp L=6e-08 W=2.6e-07
MI13_MXPA1 noe OE VDD VDD pm1p2_svt_lp L=6e-08 W=3.1e-07
MXP1 p1 OE VDD VDD pm1p2_svt_lp L=6e-08 W=1.5e-07
MXP2 Y p1 VDD VDD pm1p2_svt_lp L=6e-08 W=5.2e-07
.ENDS

.SUBCKT TBUFX1P4H9R Y VDD VSS A OE
MXN4 p1 OE n1 VSS nm1p2_svt_lp L=6e-08 W=1.5e-07
MXN2 n1 A VSS VSS nm1p2_svt_lp L=6e-08 W=2.65e-07
MI13_MXNA1 noe OE VSS VSS nm1p2_svt_lp L=6e-08 W=2.35e-07
MXN1 n1 noe VSS VSS nm1p2_svt_lp L=6e-08 W=1.5e-07
MXN3 Y n1 VSS VSS nm1p2_svt_lp L=6e-08 W=2.65e-07
MXN3_2 Y n1 VSS VSS nm1p2_svt_lp L=6e-08 W=2.65e-07
MXP6 n1 noe p1 VDD pm1p2_svt_lp L=6e-08 W=1.85e-07
MXP3 p1 A VDD VDD pm1p2_svt_lp L=6e-08 W=3.7e-07
MI13_MXPA1 noe OE VDD VDD pm1p2_svt_lp L=6e-08 W=3.3e-07
MXP1 p1 OE VDD VDD pm1p2_svt_lp L=6e-08 W=1.85e-07
MXP2 Y p1 VDD VDD pm1p2_svt_lp L=6e-08 W=3.7e-07
MXP2_2 Y p1 VDD VDD pm1p2_svt_lp L=6e-08 W=3.7e-07
.ENDS

.SUBCKT TBUFX2H9R Y VDD VSS A OE
MXN4 p1 OE n1 VSS nm1p2_svt_lp L=6e-08 W=1.85e-07
MXN2 n1 A VSS VSS nm1p2_svt_lp L=6e-08 W=3.7e-07
MI13_MXNA1 noe OE VSS VSS nm1p2_svt_lp L=6e-08 W=2.45e-07
MXN1 n1 noe VSS VSS nm1p2_svt_lp L=6e-08 W=1.85e-07
MXN3 Y n1 VSS VSS nm1p2_svt_lp L=6e-08 W=3.7e-07
MXN3_2 Y n1 VSS VSS nm1p2_svt_lp L=6e-08 W=3.7e-07
MXP6 n1 noe p1 VDD pm1p2_svt_lp L=6e-08 W=2.6e-07
MXP3 p1 A VDD VDD pm1p2_svt_lp L=6e-08 W=5.2e-07
MI13_MXPA1 noe OE VDD VDD pm1p2_svt_lp L=6e-08 W=3.4e-07
MXP1 p1 OE VDD VDD pm1p2_svt_lp L=6e-08 W=2.6e-07
MXP2 Y p1 VDD VDD pm1p2_svt_lp L=6e-08 W=5.2e-07
MXP2_2 Y p1 VDD VDD pm1p2_svt_lp L=6e-08 W=5.2e-07
.ENDS

.SUBCKT TBUFX3H9R Y VDD VSS A OE
MXN4 p1 OE n1 VSS nm1p2_svt_lp L=6e-08 W=2.8e-07
MXN2 n1 A VSS VSS nm1p2_svt_lp L=6e-08 W=2.8e-07
MXN2_2 n1 A VSS VSS nm1p2_svt_lp L=6e-08 W=2.8e-07
MI13_MXNA1 noe OE VSS VSS nm1p2_svt_lp L=6e-08 W=3.35e-07
MXN1 n1 noe VSS VSS nm1p2_svt_lp L=6e-08 W=2.8e-07
MXN3 Y n1 VSS VSS nm1p2_svt_lp L=6e-08 W=3.7e-07
MXN3_2 Y n1 VSS VSS nm1p2_svt_lp L=6e-08 W=3.7e-07
MXN3_3 Y n1 VSS VSS nm1p2_svt_lp L=6e-08 W=3.7e-07
MXP6 n1 noe p1 VDD pm1p2_svt_lp L=6e-08 W=3.9e-07
MXP3 p1 A VDD VDD pm1p2_svt_lp L=6e-08 W=3.9e-07
MXP3_2 p1 A VDD VDD pm1p2_svt_lp L=6e-08 W=3.9e-07
MI13_MXPA1 noe OE VDD VDD pm1p2_svt_lp L=6e-08 W=4.7e-07
MXP1 p1 OE VDD VDD pm1p2_svt_lp L=6e-08 W=3.9e-07
MXP2 Y p1 VDD VDD pm1p2_svt_lp L=6e-08 W=5.2e-07
MXP2_2 Y p1 VDD VDD pm1p2_svt_lp L=6e-08 W=5.2e-07
MXP2_3 Y p1 VDD VDD pm1p2_svt_lp L=6e-08 W=5.2e-07
.ENDS

.SUBCKT TBUFX4H9R Y VDD VSS A OE
MXN4 p1 OE n1 VSS nm1p2_svt_lp L=6e-08 W=3.7e-07
MXN2 n1 A VSS VSS nm1p2_svt_lp L=6e-08 W=3.7e-07
MXN2_2 n1 A VSS VSS nm1p2_svt_lp L=6e-08 W=3.7e-07
MI13_MXNA1 noe OE VSS VSS nm1p2_svt_lp L=6e-08 W=3.8e-07
MXN1 n1 noe VSS VSS nm1p2_svt_lp L=6e-08 W=3.7e-07
MXN3 Y n1 VSS VSS nm1p2_svt_lp L=6e-08 W=3.7e-07
MXN3_2 Y n1 VSS VSS nm1p2_svt_lp L=6e-08 W=3.7e-07
MXN3_3 Y n1 VSS VSS nm1p2_svt_lp L=6e-08 W=3.7e-07
MXN3_4 Y n1 VSS VSS nm1p2_svt_lp L=6e-08 W=3.7e-07
MXP6 n1 noe p1 VDD pm1p2_svt_lp L=6e-08 W=5.2e-07
MXP3 p1 A VDD VDD pm1p2_svt_lp L=6e-08 W=5.2e-07
MXP3_2 p1 A VDD VDD pm1p2_svt_lp L=6e-08 W=5.2e-07
MI13_MXPA1 noe OE VDD VDD pm1p2_svt_lp L=6e-08 W=5.2e-07
MXP1 p1 OE VDD VDD pm1p2_svt_lp L=6e-08 W=5.2e-07
MXP2 Y p1 VDD VDD pm1p2_svt_lp L=6e-08 W=5.2e-07
MXP2_2 Y p1 VDD VDD pm1p2_svt_lp L=6e-08 W=5.2e-07
MXP2_3 Y p1 VDD VDD pm1p2_svt_lp L=6e-08 W=5.2e-07
MXP2_4 Y p1 VDD VDD pm1p2_svt_lp L=6e-08 W=5.2e-07
.ENDS

.SUBCKT TBUFX6H9R Y VDD VSS A OE
MXN4 p1 OE n1 VSS nm1p2_svt_lp L=6e-08 W=2.8e-07
MXN4_2 p1 OE n1 VSS nm1p2_svt_lp L=6e-08 W=2.8e-07
MXN2 n1 A VSS VSS nm1p2_svt_lp L=6e-08 W=3.7e-07
MXN2_2 n1 A VSS VSS nm1p2_svt_lp L=6e-08 W=3.7e-07
MXN2_3 n1 A VSS VSS nm1p2_svt_lp L=6e-08 W=3.7e-07
MI13_MXNA1 noe OE VSS VSS nm1p2_svt_lp L=6e-08 W=2.65e-07
MI13_MXNA1_2 noe OE VSS VSS nm1p2_svt_lp L=6e-08 W=2.65e-07
MXN1 n1 noe VSS VSS nm1p2_svt_lp L=6e-08 W=2.8e-07
MXN1_2 n1 noe VSS VSS nm1p2_svt_lp L=6e-08 W=2.8e-07
MXN3 Y n1 VSS VSS nm1p2_svt_lp L=6e-08 W=3.7e-07
MXN3_2 Y n1 VSS VSS nm1p2_svt_lp L=6e-08 W=3.7e-07
MXN3_3 Y n1 VSS VSS nm1p2_svt_lp L=6e-08 W=3.7e-07
MXN3_4 Y n1 VSS VSS nm1p2_svt_lp L=6e-08 W=3.7e-07
MXN3_5 Y n1 VSS VSS nm1p2_svt_lp L=6e-08 W=3.7e-07
MXN3_6 Y n1 VSS VSS nm1p2_svt_lp L=6e-08 W=3.7e-07
MXP6 n1 noe p1 VDD pm1p2_svt_lp L=6e-08 W=3.9e-07
MXP6_2 n1 noe p1 VDD pm1p2_svt_lp L=6e-08 W=3.9e-07
MXP3 p1 A VDD VDD pm1p2_svt_lp L=6e-08 W=5.2e-07
MXP3_2 p1 A VDD VDD pm1p2_svt_lp L=6e-08 W=5.2e-07
MXP3_3 p1 A VDD VDD pm1p2_svt_lp L=6e-08 W=5.2e-07
MI13_MXPA1 noe OE VDD VDD pm1p2_svt_lp L=6e-08 W=3.7e-07
MI13_MXPA1_2 noe OE VDD VDD pm1p2_svt_lp L=6e-08 W=3.7e-07
MXP1 p1 OE VDD VDD pm1p2_svt_lp L=6e-08 W=3.9e-07
MXP1_2 p1 OE VDD VDD pm1p2_svt_lp L=6e-08 W=3.9e-07
MXP2 Y p1 VDD VDD pm1p2_svt_lp L=6e-08 W=5.2e-07
MXP2_2 Y p1 VDD VDD pm1p2_svt_lp L=6e-08 W=5.2e-07
MXP2_3 Y p1 VDD VDD pm1p2_svt_lp L=6e-08 W=5.2e-07
MXP2_4 Y p1 VDD VDD pm1p2_svt_lp L=6e-08 W=5.2e-07
MXP2_5 Y p1 VDD VDD pm1p2_svt_lp L=6e-08 W=5.2e-07
MXP2_6 Y p1 VDD VDD pm1p2_svt_lp L=6e-08 W=5.2e-07
.ENDS

.SUBCKT TBUFX8H9R Y VDD VSS A OE
MXN4 p1 OE n1 VSS nm1p2_svt_lp L=6e-08 W=3.7e-07
MXN4_2 p1 OE n1 VSS nm1p2_svt_lp L=6e-08 W=3.7e-07
MXN2 n1 A VSS VSS nm1p2_svt_lp L=6e-08 W=3.7e-07
MXN2_2 n1 A VSS VSS nm1p2_svt_lp L=6e-08 W=3.7e-07
MXN2_3 n1 A VSS VSS nm1p2_svt_lp L=6e-08 W=3.7e-07
MXN2_4 n1 A VSS VSS nm1p2_svt_lp L=6e-08 W=3.7e-07
MI13_MXNA1 noe OE VSS VSS nm1p2_svt_lp L=6e-08 W=3.2e-07
MI13_MXNA1_2 noe OE VSS VSS nm1p2_svt_lp L=6e-08 W=3.2e-07
MXN1 n1 noe VSS VSS nm1p2_svt_lp L=6e-08 W=3.7e-07
MXN1_2 n1 noe VSS VSS nm1p2_svt_lp L=6e-08 W=3.7e-07
MXN3 Y n1 VSS VSS nm1p2_svt_lp L=6e-08 W=3.7e-07
MXN3_2 Y n1 VSS VSS nm1p2_svt_lp L=6e-08 W=3.7e-07
MXN3_3 Y n1 VSS VSS nm1p2_svt_lp L=6e-08 W=3.7e-07
MXN3_4 Y n1 VSS VSS nm1p2_svt_lp L=6e-08 W=3.7e-07
MXN3_5 Y n1 VSS VSS nm1p2_svt_lp L=6e-08 W=3.7e-07
MXN3_6 Y n1 VSS VSS nm1p2_svt_lp L=6e-08 W=3.7e-07
MXN3_7 Y n1 VSS VSS nm1p2_svt_lp L=6e-08 W=3.7e-07
MXN3_8 Y n1 VSS VSS nm1p2_svt_lp L=6e-08 W=3.7e-07
MXP6 n1 noe p1 VDD pm1p2_svt_lp L=6e-08 W=5.2e-07
MXP6_2 n1 noe p1 VDD pm1p2_svt_lp L=6e-08 W=5.2e-07
MXP3 p1 A VDD VDD pm1p2_svt_lp L=6e-08 W=5.2e-07
MXP3_2 p1 A VDD VDD pm1p2_svt_lp L=6e-08 W=5.2e-07
MXP3_3 p1 A VDD VDD pm1p2_svt_lp L=6e-08 W=5.2e-07
MXP3_4 p1 A VDD VDD pm1p2_svt_lp L=6e-08 W=5.2e-07
MI13_MXPA1 noe OE VDD VDD pm1p2_svt_lp L=6e-08 W=4.5e-07
MI13_MXPA1_2 noe OE VDD VDD pm1p2_svt_lp L=6e-08 W=4.5e-07
MXP1 p1 OE VDD VDD pm1p2_svt_lp L=6e-08 W=5.2e-07
MXP1_2 p1 OE VDD VDD pm1p2_svt_lp L=6e-08 W=5.2e-07
MXP2 Y p1 VDD VDD pm1p2_svt_lp L=6e-08 W=5.2e-07
MXP2_2 Y p1 VDD VDD pm1p2_svt_lp L=6e-08 W=5.2e-07
MXP2_3 Y p1 VDD VDD pm1p2_svt_lp L=6e-08 W=5.2e-07
MXP2_4 Y p1 VDD VDD pm1p2_svt_lp L=6e-08 W=5.2e-07
MXP2_5 Y p1 VDD VDD pm1p2_svt_lp L=6e-08 W=5.2e-07
MXP2_6 Y p1 VDD VDD pm1p2_svt_lp L=6e-08 W=5.2e-07
MXP2_7 Y p1 VDD VDD pm1p2_svt_lp L=6e-08 W=5.2e-07
MXP2_8 Y p1 VDD VDD pm1p2_svt_lp L=6e-08 W=5.2e-07
.ENDS

.SUBCKT TBUFX11H9R Y VDD VSS A OE
MXN4 p1 OE n1 VSS nm1p2_svt_lp L=6e-08 W=3.4e-07
MXN4_2 p1 OE n1 VSS nm1p2_svt_lp L=6e-08 W=3.4e-07
MXN4_3 p1 OE n1 VSS nm1p2_svt_lp L=6e-08 W=3.4e-07
MXN2 n1 A VSS VSS nm1p2_svt_lp L=6e-08 W=3.4e-07
MXN2_2 n1 A VSS VSS nm1p2_svt_lp L=6e-08 W=3.4e-07
MXN2_3 n1 A VSS VSS nm1p2_svt_lp L=6e-08 W=3.4e-07
MXN2_4 n1 A VSS VSS nm1p2_svt_lp L=6e-08 W=3.4e-07
MXN2_5 n1 A VSS VSS nm1p2_svt_lp L=6e-08 W=3.4e-07
MXN2_6 n1 A VSS VSS nm1p2_svt_lp L=6e-08 W=3.4e-07
MI13_MXNA1 noe OE VSS VSS nm1p2_svt_lp L=6e-08 W=4.5e-07
MI13_MXNA1_2 noe OE VSS VSS nm1p2_svt_lp L=6e-08 W=4.5e-07
MXN1 n1 noe VSS VSS nm1p2_svt_lp L=6e-08 W=3.4e-07
MXN1_2 n1 noe VSS VSS nm1p2_svt_lp L=6e-08 W=3.4e-07
MXN1_3 n1 noe VSS VSS nm1p2_svt_lp L=6e-08 W=3.4e-07
MXN3 Y n1 VSS VSS nm1p2_svt_lp L=6e-08 W=3.7e-07
MXN3_2 Y n1 VSS VSS nm1p2_svt_lp L=6e-08 W=3.7e-07
MXN3_3 Y n1 VSS VSS nm1p2_svt_lp L=6e-08 W=3.7e-07
MXN3_4 Y n1 VSS VSS nm1p2_svt_lp L=6e-08 W=3.7e-07
MXN3_5 Y n1 VSS VSS nm1p2_svt_lp L=6e-08 W=3.7e-07
MXN3_6 Y n1 VSS VSS nm1p2_svt_lp L=6e-08 W=3.7e-07
MXN3_7 Y n1 VSS VSS nm1p2_svt_lp L=6e-08 W=3.7e-07
MXN3_8 Y n1 VSS VSS nm1p2_svt_lp L=6e-08 W=3.7e-07
MXN3_9 Y n1 VSS VSS nm1p2_svt_lp L=6e-08 W=3.7e-07
MXN3_10 Y n1 VSS VSS nm1p2_svt_lp L=6e-08 W=3.7e-07
MXN3_11 Y n1 VSS VSS nm1p2_svt_lp L=6e-08 W=3.7e-07
MXP6 n1 noe p1 VDD pm1p2_svt_lp L=6e-08 W=4.75e-07
MXP6_2 n1 noe p1 VDD pm1p2_svt_lp L=6e-08 W=4.75e-07
MXP6_3 n1 noe p1 VDD pm1p2_svt_lp L=6e-08 W=4.75e-07
MXP3 p1 A VDD VDD pm1p2_svt_lp L=6e-08 W=4.75e-07
MXP3_2 p1 A VDD VDD pm1p2_svt_lp L=6e-08 W=4.75e-07
MXP3_3 p1 A VDD VDD pm1p2_svt_lp L=6e-08 W=4.75e-07
MXP3_4 p1 A VDD VDD pm1p2_svt_lp L=6e-08 W=4.75e-07
MXP3_5 p1 A VDD VDD pm1p2_svt_lp L=6e-08 W=4.75e-07
MXP3_6 p1 A VDD VDD pm1p2_svt_lp L=6e-08 W=4.75e-07
MI13_MXPA1 noe OE VDD VDD pm1p2_svt_lp L=6e-08 W=4.2e-07
MI13_MXPA1_2 noe OE VDD VDD pm1p2_svt_lp L=6e-08 W=4.2e-07
MI13_MXPA1_3 noe OE VDD VDD pm1p2_svt_lp L=6e-08 W=4.2e-07
MXP1 p1 OE VDD VDD pm1p2_svt_lp L=6e-08 W=4.75e-07
MXP1_2 p1 OE VDD VDD pm1p2_svt_lp L=6e-08 W=4.75e-07
MXP1_3 p1 OE VDD VDD pm1p2_svt_lp L=6e-08 W=4.75e-07
MXP2 Y p1 VDD VDD pm1p2_svt_lp L=6e-08 W=5.2e-07
MXP2_2 Y p1 VDD VDD pm1p2_svt_lp L=6e-08 W=5.2e-07
MXP2_3 Y p1 VDD VDD pm1p2_svt_lp L=6e-08 W=5.2e-07
MXP2_4 Y p1 VDD VDD pm1p2_svt_lp L=6e-08 W=5.2e-07
MXP2_5 Y p1 VDD VDD pm1p2_svt_lp L=6e-08 W=5.2e-07
MXP2_6 Y p1 VDD VDD pm1p2_svt_lp L=6e-08 W=5.2e-07
MXP2_7 Y p1 VDD VDD pm1p2_svt_lp L=6e-08 W=5.2e-07
MXP2_8 Y p1 VDD VDD pm1p2_svt_lp L=6e-08 W=5.2e-07
MXP2_9 Y p1 VDD VDD pm1p2_svt_lp L=6e-08 W=5.2e-07
MXP2_10 Y p1 VDD VDD pm1p2_svt_lp L=6e-08 W=5.2e-07
MXP2_11 Y p1 VDD VDD pm1p2_svt_lp L=6e-08 W=5.2e-07
.ENDS

.SUBCKT TBUFX16H9R Y VDD VSS A OE
MXN4 p1 OE n1 VSS nm1p2_svt_lp L=6e-08 W=3.7e-07
MXN4_2 p1 OE n1 VSS nm1p2_svt_lp L=6e-08 W=3.7e-07
MXN4_3 p1 OE n1 VSS nm1p2_svt_lp L=6e-08 W=3.7e-07
MXN4_4 p1 OE n1 VSS nm1p2_svt_lp L=6e-08 W=3.7e-07
MXN2 n1 A VSS VSS nm1p2_svt_lp L=6e-08 W=3.7e-07
MXN2_2 n1 A VSS VSS nm1p2_svt_lp L=6e-08 W=3.7e-07
MXN2_3 n1 A VSS VSS nm1p2_svt_lp L=6e-08 W=3.7e-07
MXN2_4 n1 A VSS VSS nm1p2_svt_lp L=6e-08 W=3.7e-07
MXN2_5 n1 A VSS VSS nm1p2_svt_lp L=6e-08 W=3.7e-07
MXN2_6 n1 A VSS VSS nm1p2_svt_lp L=6e-08 W=3.7e-07
MXN2_7 n1 A VSS VSS nm1p2_svt_lp L=6e-08 W=3.7e-07
MXN2_8 n1 A VSS VSS nm1p2_svt_lp L=6e-08 W=3.7e-07
MI13_MXNA1 noe OE VSS VSS nm1p2_svt_lp L=6e-08 W=4.1e-07
MI13_MXNA1_2 noe OE VSS VSS nm1p2_svt_lp L=6e-08 W=4.1e-07
MI13_MXNA1_3 noe OE VSS VSS nm1p2_svt_lp L=6e-08 W=4.1e-07
MXN1 n1 noe VSS VSS nm1p2_svt_lp L=6e-08 W=3.7e-07
MXN1_2 n1 noe VSS VSS nm1p2_svt_lp L=6e-08 W=3.7e-07
MXN1_3 n1 noe VSS VSS nm1p2_svt_lp L=6e-08 W=3.7e-07
MXN1_4 n1 noe VSS VSS nm1p2_svt_lp L=6e-08 W=3.7e-07
MXN3 Y n1 VSS VSS nm1p2_svt_lp L=6e-08 W=3.7e-07
MXN3_2 Y n1 VSS VSS nm1p2_svt_lp L=6e-08 W=3.7e-07
MXN3_3 Y n1 VSS VSS nm1p2_svt_lp L=6e-08 W=3.7e-07
MXN3_4 Y n1 VSS VSS nm1p2_svt_lp L=6e-08 W=3.7e-07
MXN3_5 Y n1 VSS VSS nm1p2_svt_lp L=6e-08 W=3.7e-07
MXN3_6 Y n1 VSS VSS nm1p2_svt_lp L=6e-08 W=3.7e-07
MXN3_7 Y n1 VSS VSS nm1p2_svt_lp L=6e-08 W=3.7e-07
MXN3_8 Y n1 VSS VSS nm1p2_svt_lp L=6e-08 W=3.7e-07
MXN3_9 Y n1 VSS VSS nm1p2_svt_lp L=6e-08 W=3.7e-07
MXN3_10 Y n1 VSS VSS nm1p2_svt_lp L=6e-08 W=3.7e-07
MXN3_11 Y n1 VSS VSS nm1p2_svt_lp L=6e-08 W=3.7e-07
MXN3_12 Y n1 VSS VSS nm1p2_svt_lp L=6e-08 W=3.7e-07
MXN3_13 Y n1 VSS VSS nm1p2_svt_lp L=6e-08 W=3.7e-07
MXN3_14 Y n1 VSS VSS nm1p2_svt_lp L=6e-08 W=3.7e-07
MXN3_15 Y n1 VSS VSS nm1p2_svt_lp L=6e-08 W=3.7e-07
MXN3_16 Y n1 VSS VSS nm1p2_svt_lp L=6e-08 W=3.7e-07
MXP6 n1 noe p1 VDD pm1p2_svt_lp L=6e-08 W=5.2e-07
MXP6_2 n1 noe p1 VDD pm1p2_svt_lp L=6e-08 W=5.2e-07
MXP6_3 n1 noe p1 VDD pm1p2_svt_lp L=6e-08 W=5.2e-07
MXP6_4 n1 noe p1 VDD pm1p2_svt_lp L=6e-08 W=5.2e-07
MXP3 p1 A VDD VDD pm1p2_svt_lp L=6e-08 W=5.2e-07
MXP3_2 p1 A VDD VDD pm1p2_svt_lp L=6e-08 W=5.2e-07
MXP3_3 p1 A VDD VDD pm1p2_svt_lp L=6e-08 W=5.2e-07
MXP3_4 p1 A VDD VDD pm1p2_svt_lp L=6e-08 W=5.2e-07
MXP3_5 p1 A VDD VDD pm1p2_svt_lp L=6e-08 W=5.2e-07
MXP3_6 p1 A VDD VDD pm1p2_svt_lp L=6e-08 W=5.2e-07
MXP3_7 p1 A VDD VDD pm1p2_svt_lp L=6e-08 W=5.2e-07
MXP3_8 p1 A VDD VDD pm1p2_svt_lp L=6e-08 W=5.2e-07
MI13_MXPA1 noe OE VDD VDD pm1p2_svt_lp L=6e-08 W=5.75e-07
MI13_MXPA1_2 noe OE VDD VDD pm1p2_svt_lp L=6e-08 W=5.75e-07
MI13_MXPA1_3 noe OE VDD VDD pm1p2_svt_lp L=6e-08 W=5.75e-07
MXP1 p1 OE VDD VDD pm1p2_svt_lp L=6e-08 W=5.2e-07
MXP1_2 p1 OE VDD VDD pm1p2_svt_lp L=6e-08 W=5.2e-07
MXP1_3 p1 OE VDD VDD pm1p2_svt_lp L=6e-08 W=5.2e-07
MXP1_4 p1 OE VDD VDD pm1p2_svt_lp L=6e-08 W=5.2e-07
MXP2 Y p1 VDD VDD pm1p2_svt_lp L=6e-08 W=5.2e-07
MXP2_2 Y p1 VDD VDD pm1p2_svt_lp L=6e-08 W=5.2e-07
MXP2_3 Y p1 VDD VDD pm1p2_svt_lp L=6e-08 W=5.2e-07
MXP2_4 Y p1 VDD VDD pm1p2_svt_lp L=6e-08 W=5.2e-07
MXP2_5 Y p1 VDD VDD pm1p2_svt_lp L=6e-08 W=5.2e-07
MXP2_6 Y p1 VDD VDD pm1p2_svt_lp L=6e-08 W=5.2e-07
MXP2_7 Y p1 VDD VDD pm1p2_svt_lp L=6e-08 W=5.2e-07
MXP2_8 Y p1 VDD VDD pm1p2_svt_lp L=6e-08 W=5.2e-07
MXP2_9 Y p1 VDD VDD pm1p2_svt_lp L=6e-08 W=5.2e-07
MXP2_10 Y p1 VDD VDD pm1p2_svt_lp L=6e-08 W=5.2e-07
MXP2_11 Y p1 VDD VDD pm1p2_svt_lp L=6e-08 W=5.2e-07
MXP2_12 Y p1 VDD VDD pm1p2_svt_lp L=6e-08 W=5.2e-07
MXP2_13 Y p1 VDD VDD pm1p2_svt_lp L=6e-08 W=5.2e-07
MXP2_14 Y p1 VDD VDD pm1p2_svt_lp L=6e-08 W=5.2e-07
MXP2_15 Y p1 VDD VDD pm1p2_svt_lp L=6e-08 W=5.2e-07
MXP2_16 Y p1 VDD VDD pm1p2_svt_lp L=6e-08 W=5.2e-07
.ENDS

.SUBCKT NAND2X0P5H9R Y VDD VSS A B
MI0_MXNA2 XI0_n1 B VSS VSS nm1p2_svt_lp L=6e-08 W=2.5e-07
MI0_MXNA1 Y A XI0_n1 VSS nm1p2_svt_lp L=6e-08 W=2.5e-07
MI0_MXPA2 Y B VDD VDD pm1p2_svt_lp L=6e-08 W=2e-07
MI0_MXPA1 Y A VDD VDD pm1p2_svt_lp L=6e-08 W=2e-07
.ENDS

.SUBCKT NAND2X0P7H9R Y VDD VSS A B
MI0_MXNA2 XI0_n1 B VSS VSS nm1p2_svt_lp L=6e-08 W=3.5e-07
MI0_MXNA1 Y A XI0_n1 VSS nm1p2_svt_lp L=6e-08 W=3.5e-07
MI0_MXPA2 Y B VDD VDD pm1p2_svt_lp L=6e-08 W=2.8e-07
MI0_MXPA1 Y A VDD VDD pm1p2_svt_lp L=6e-08 W=2.8e-07
.ENDS

.SUBCKT NAND2X1H9R Y VDD VSS A B
MI0_MXNA2 XI0_n1 B VSS VSS nm1p2_svt_lp L=6e-08 W=4.95e-07
MI0_MXNA1 Y A XI0_n1 VSS nm1p2_svt_lp L=6e-08 W=4.95e-07
MI0_MXPA2 Y B VDD VDD pm1p2_svt_lp L=6e-08 W=3.95e-07
MI0_MXPA1 Y A VDD VDD pm1p2_svt_lp L=6e-08 W=3.95e-07
.ENDS

.SUBCKT NAND2X1P4H9R Y VDD VSS A B
MI0_MXNA2_2 XI0_n1__2 B VSS VSS nm1p2_svt_lp L=6e-08 W=3.5e-07
MI0_MXNA1_2 Y A XI0_n1__2 VSS nm1p2_svt_lp L=6e-08 W=3.5e-07
MI0_MXNA1 Y A XI0_n1 VSS nm1p2_svt_lp L=6e-08 W=3.5e-07
MI0_MXNA2 XI0_n1 B VSS VSS nm1p2_svt_lp L=6e-08 W=3.5e-07
MI0_MXPA1 Y A VDD VDD pm1p2_svt_lp L=6e-08 W=5.6e-07
MI0_MXPA2 Y B VDD VDD pm1p2_svt_lp L=6e-08 W=5.6e-07
.ENDS

.SUBCKT NAND2X2H9R Y VDD VSS A B
MI0_MXNA2_2 XI0_n1__2 B VSS VSS nm1p2_svt_lp L=6e-08 W=4.95e-07
MI0_MXNA1_2 Y A XI0_n1__2 VSS nm1p2_svt_lp L=6e-08 W=4.95e-07
MI0_MXNA1 Y A XI0_n1 VSS nm1p2_svt_lp L=6e-08 W=4.95e-07
MI0_MXNA2 XI0_n1 B VSS VSS nm1p2_svt_lp L=6e-08 W=4.95e-07
MI0_MXPA2 Y B VDD VDD pm1p2_svt_lp L=6e-08 W=3.95e-07
MI0_MXPA1 Y A VDD VDD pm1p2_svt_lp L=6e-08 W=3.95e-07
MI0_MXPA1_2 Y A VDD VDD pm1p2_svt_lp L=6e-08 W=3.95e-07
MI0_MXPA2_2 Y B VDD VDD pm1p2_svt_lp L=6e-08 W=3.95e-07
.ENDS

.SUBCKT NAND2X3H9R Y VDD VSS A B
MI0_MXNA2_2 XI0_n1__2 B VSS VSS nm1p2_svt_lp L=6e-08 W=4.95e-07
MI0_MXNA1_2 Y A XI0_n1__2 VSS nm1p2_svt_lp L=6e-08 W=4.95e-07
MI0_MXNA1_3 Y A XI0_n1__3 VSS nm1p2_svt_lp L=6e-08 W=4.95e-07
MI0_MXNA2_3 XI0_n1__3 B VSS VSS nm1p2_svt_lp L=6e-08 W=4.95e-07
MI0_MXNA2 XI0_n1 B VSS VSS nm1p2_svt_lp L=6e-08 W=4.95e-07
MI0_MXNA1 Y A XI0_n1 VSS nm1p2_svt_lp L=6e-08 W=4.95e-07
MI0_MXPA2 Y B VDD VDD pm1p2_svt_lp L=6e-08 W=3.95e-07
MI0_MXPA1 Y A VDD VDD pm1p2_svt_lp L=6e-08 W=3.95e-07
MI0_MXPA1_2 Y A VDD VDD pm1p2_svt_lp L=6e-08 W=3.95e-07
MI0_MXPA2_2 Y B VDD VDD pm1p2_svt_lp L=6e-08 W=3.95e-07
MI0_MXPA2_3 Y B VDD VDD pm1p2_svt_lp L=6e-08 W=3.95e-07
MI0_MXPA1_3 Y A VDD VDD pm1p2_svt_lp L=6e-08 W=3.95e-07
.ENDS

.SUBCKT NAND2X4H9R Y VDD VSS A B
MI0_MXNA2_2 XI0_n1__2 B VSS VSS nm1p2_svt_lp L=6e-08 W=4.95e-07
MI0_MXNA1_2 Y A XI0_n1__2 VSS nm1p2_svt_lp L=6e-08 W=4.95e-07
MI0_MXNA1_3 Y A XI0_n1__3 VSS nm1p2_svt_lp L=6e-08 W=4.95e-07
MI0_MXNA2_3 XI0_n1__3 B VSS VSS nm1p2_svt_lp L=6e-08 W=4.95e-07
MI0_MXNA2_4 XI0_n1__4 B VSS VSS nm1p2_svt_lp L=6e-08 W=4.95e-07
MI0_MXNA1_4 Y A XI0_n1__4 VSS nm1p2_svt_lp L=6e-08 W=4.95e-07
MI0_MXNA1 Y A XI0_n1 VSS nm1p2_svt_lp L=6e-08 W=4.95e-07
MI0_MXNA2 XI0_n1 B VSS VSS nm1p2_svt_lp L=6e-08 W=4.95e-07
MI0_MXPA1 Y A VDD VDD pm1p2_svt_lp L=6e-08 W=5.3e-07
MI0_MXPA2 Y B VDD VDD pm1p2_svt_lp L=6e-08 W=5.3e-07
MI0_MXPA2_2 Y B VDD VDD pm1p2_svt_lp L=6e-08 W=5.3e-07
MI0_MXPA1_2 Y A VDD VDD pm1p2_svt_lp L=6e-08 W=5.3e-07
MI0_MXPA1_3 Y A VDD VDD pm1p2_svt_lp L=6e-08 W=5.3e-07
MI0_MXPA2_3 Y B VDD VDD pm1p2_svt_lp L=6e-08 W=5.3e-07
.ENDS

.SUBCKT NAND2X6H9R Y VDD VSS A B
MI0_MXNA2 XI0_n1 B VSS VSS nm1p2_svt_lp L=6e-08 W=4.95e-07
MI0_MXNA2_2 XI0_n1 B VSS VSS nm1p2_svt_lp L=6e-08 W=4.95e-07
MI0_MXNA2_3 XI0_n1 B VSS VSS nm1p2_svt_lp L=6e-08 W=4.95e-07
MI0_MXNA2_4 XI0_n1 B VSS VSS nm1p2_svt_lp L=6e-08 W=4.95e-07
MI0_MXNA2_5 XI0_n1 B VSS VSS nm1p2_svt_lp L=6e-08 W=4.95e-07
MI0_MXNA2_6 XI0_n1 B VSS VSS nm1p2_svt_lp L=6e-08 W=4.95e-07
MI0_MXNA1 Y A XI0_n1 VSS nm1p2_svt_lp L=6e-08 W=4.95e-07
MI0_MXNA1_2 Y A XI0_n1 VSS nm1p2_svt_lp L=6e-08 W=4.95e-07
MI0_MXNA1_3 Y A XI0_n1 VSS nm1p2_svt_lp L=6e-08 W=4.95e-07
MI0_MXNA1_4 Y A XI0_n1 VSS nm1p2_svt_lp L=6e-08 W=4.95e-07
MI0_MXNA1_5 Y A XI0_n1 VSS nm1p2_svt_lp L=6e-08 W=4.95e-07
MI0_MXNA1_6 Y A XI0_n1 VSS nm1p2_svt_lp L=6e-08 W=4.95e-07
MI0_MXPA2 Y B VDD VDD pm1p2_svt_lp L=6e-08 W=4.75e-07
MI0_MXPA2_2 Y B VDD VDD pm1p2_svt_lp L=6e-08 W=4.75e-07
MI0_MXPA2_3 Y B VDD VDD pm1p2_svt_lp L=6e-08 W=4.75e-07
MI0_MXPA2_4 Y B VDD VDD pm1p2_svt_lp L=6e-08 W=4.75e-07
MI0_MXPA2_5 Y B VDD VDD pm1p2_svt_lp L=6e-08 W=4.75e-07
MI0_MXPA1 Y A VDD VDD pm1p2_svt_lp L=6e-08 W=4.75e-07
MI0_MXPA1_2 Y A VDD VDD pm1p2_svt_lp L=6e-08 W=4.75e-07
MI0_MXPA1_3 Y A VDD VDD pm1p2_svt_lp L=6e-08 W=4.75e-07
MI0_MXPA1_4 Y A VDD VDD pm1p2_svt_lp L=6e-08 W=4.75e-07
MI0_MXPA1_5 Y A VDD VDD pm1p2_svt_lp L=6e-08 W=4.75e-07
.ENDS

.SUBCKT NAND2X8H9R Y VDD VSS A B
MI0_MXNA2_2 XI0_n1__2 B VSS VSS nm1p2_svt_lp L=6e-08 W=4.95e-07
MI0_MXNA1_2 Y A XI0_n1__2 VSS nm1p2_svt_lp L=6e-08 W=4.95e-07
MI0_MXNA1_3 Y A XI0_n1__3 VSS nm1p2_svt_lp L=6e-08 W=4.95e-07
MI0_MXNA2_3 XI0_n1__3 B VSS VSS nm1p2_svt_lp L=6e-08 W=4.95e-07
MI0_MXNA2_4 XI0_n1__4 B VSS VSS nm1p2_svt_lp L=6e-08 W=4.95e-07
MI0_MXNA1_4 Y A XI0_n1__4 VSS nm1p2_svt_lp L=6e-08 W=4.95e-07
MI0_MXNA1_5 Y A XI0_n1__5 VSS nm1p2_svt_lp L=6e-08 W=4.95e-07
MI0_MXNA2_5 XI0_n1__5 B VSS VSS nm1p2_svt_lp L=6e-08 W=4.95e-07
MI0_MXNA2_6 XI0_n1__6 B VSS VSS nm1p2_svt_lp L=6e-08 W=4.95e-07
MI0_MXNA1_6 Y A XI0_n1__6 VSS nm1p2_svt_lp L=6e-08 W=4.95e-07
MI0_MXNA1_7 Y A XI0_n1__7 VSS nm1p2_svt_lp L=6e-08 W=4.95e-07
MI0_MXNA2_7 XI0_n1__7 B VSS VSS nm1p2_svt_lp L=6e-08 W=4.95e-07
MI0_MXNA2_8 XI0_n1__8 B VSS VSS nm1p2_svt_lp L=6e-08 W=4.95e-07
MI0_MXNA1_8 Y A XI0_n1__8 VSS nm1p2_svt_lp L=6e-08 W=4.95e-07
MI0_MXNA1 Y A XI0_n1 VSS nm1p2_svt_lp L=6e-08 W=4.95e-07
MI0_MXNA2 XI0_n1 B VSS VSS nm1p2_svt_lp L=6e-08 W=4.95e-07
MI0_MXPA2 Y B VDD VDD pm1p2_svt_lp L=6e-08 W=5.3e-07
MI0_MXPA1 Y A VDD VDD pm1p2_svt_lp L=6e-08 W=5.3e-07
MI0_MXPA1_2 Y A VDD VDD pm1p2_svt_lp L=6e-08 W=5.3e-07
MI0_MXPA2_2 Y B VDD VDD pm1p2_svt_lp L=6e-08 W=5.3e-07
MI0_MXPA2_3 Y B VDD VDD pm1p2_svt_lp L=6e-08 W=5.3e-07
MI0_MXPA1_3 Y A VDD VDD pm1p2_svt_lp L=6e-08 W=5.3e-07
MI0_MXPA1_4 Y A VDD VDD pm1p2_svt_lp L=6e-08 W=5.3e-07
MI0_MXPA2_4 Y B VDD VDD pm1p2_svt_lp L=6e-08 W=5.3e-07
MI0_MXPA2_5 Y B VDD VDD pm1p2_svt_lp L=6e-08 W=5.3e-07
MI0_MXPA1_5 Y A VDD VDD pm1p2_svt_lp L=6e-08 W=5.3e-07
MI0_MXPA1_6 Y A VDD VDD pm1p2_svt_lp L=6e-08 W=5.3e-07
MI0_MXPA2_6 Y B VDD VDD pm1p2_svt_lp L=6e-08 W=5.3e-07
.ENDS

.SUBCKT NAND2BX0P5H9R Y VDD VSS AN B
MI0_MXNA1 a AN VSS VSS nm1p2_svt_lp L=6e-08 W=1.5e-07
MI1_MXNA2 XI1_n1 B VSS VSS nm1p2_svt_lp L=6e-08 W=2.5e-07
MI1_MXNA1 Y a XI1_n1 VSS nm1p2_svt_lp L=6e-08 W=2.5e-07
MI0_MXPA1 a AN VDD VDD pm1p2_svt_lp L=6e-08 W=2.1e-07
MI1_MXPA2 Y B VDD VDD pm1p2_svt_lp L=6e-08 W=2e-07
MI1_MXPA1 Y a VDD VDD pm1p2_svt_lp L=6e-08 W=2e-07
.ENDS

.SUBCKT NAND2BX0P7H9R Y VDD VSS AN B
MI0_MXNA1 a AN VSS VSS nm1p2_svt_lp L=6e-08 W=1.5e-07
MI1_MXNA2 XI1_n1 B VSS VSS nm1p2_svt_lp L=6e-08 W=3.5e-07
MI1_MXNA1 Y a XI1_n1 VSS nm1p2_svt_lp L=6e-08 W=3.5e-07
MI0_MXPA1 a AN VDD VDD pm1p2_svt_lp L=6e-08 W=2.1e-07
MI1_MXPA2 Y B VDD VDD pm1p2_svt_lp L=6e-08 W=2.8e-07
MI1_MXPA1 Y a VDD VDD pm1p2_svt_lp L=6e-08 W=2.8e-07
.ENDS

.SUBCKT NAND2BX1H9R Y VDD VSS AN B
MI0_MXNA1 a AN VSS VSS nm1p2_svt_lp L=6e-08 W=1.5e-07
MI1_MXNA2 XI1_n1 B VSS VSS nm1p2_svt_lp L=6e-08 W=4.95e-07
MI1_MXNA1 Y a XI1_n1 VSS nm1p2_svt_lp L=6e-08 W=4.95e-07
MI0_MXPA1 a AN VDD VDD pm1p2_svt_lp L=6e-08 W=2.1e-07
MI1_MXPA2 Y B VDD VDD pm1p2_svt_lp L=6e-08 W=3.95e-07
MI1_MXPA1 Y a VDD VDD pm1p2_svt_lp L=6e-08 W=3.95e-07
.ENDS

.SUBCKT NAND2BX1P4H9R Y VDD VSS AN B
MI0_MXNA1 a AN VSS VSS nm1p2_svt_lp L=6e-08 W=1.85e-07
MI1_MXNA2_2 XI1_n1__2 B VSS VSS nm1p2_svt_lp L=6e-08 W=3.5e-07
MI1_MXNA1_2 Y a XI1_n1__2 VSS nm1p2_svt_lp L=6e-08 W=3.5e-07
MI1_MXNA1 Y a XI1_n1 VSS nm1p2_svt_lp L=6e-08 W=3.5e-07
MI1_MXNA2 XI1_n1 B VSS VSS nm1p2_svt_lp L=6e-08 W=3.5e-07
MI0_MXPA1 a AN VDD VDD pm1p2_svt_lp L=6e-08 W=2.6e-07
MI1_MXPA2 Y B VDD VDD pm1p2_svt_lp L=6e-08 W=2.8e-07
MI1_MXPA1 Y a VDD VDD pm1p2_svt_lp L=6e-08 W=2.8e-07
MI1_MXPA1_2 Y a VDD VDD pm1p2_svt_lp L=6e-08 W=2.8e-07
MI1_MXPA2_2 Y B VDD VDD pm1p2_svt_lp L=6e-08 W=2.8e-07
.ENDS

.SUBCKT NAND2BX2H9R Y VDD VSS AN B
MI0_MXNA1 a AN VSS VSS nm1p2_svt_lp L=6e-08 W=2.4e-07
MI1_MXNA2_2 XI1_n1__2 B VSS VSS nm1p2_svt_lp L=6e-08 W=4.95e-07
MI1_MXNA1_2 Y a XI1_n1__2 VSS nm1p2_svt_lp L=6e-08 W=4.95e-07
MI1_MXNA1 Y a XI1_n1 VSS nm1p2_svt_lp L=6e-08 W=4.95e-07
MI1_MXNA2 XI1_n1 B VSS VSS nm1p2_svt_lp L=6e-08 W=4.95e-07
MI0_MXPA1 a AN VDD VDD pm1p2_svt_lp L=6e-08 W=3.35e-07
MI1_MXPA2 Y B VDD VDD pm1p2_svt_lp L=6e-08 W=3.95e-07
MI1_MXPA1 Y a VDD VDD pm1p2_svt_lp L=6e-08 W=3.95e-07
MI1_MXPA1_2 Y a VDD VDD pm1p2_svt_lp L=6e-08 W=3.95e-07
MI1_MXPA2_2 Y B VDD VDD pm1p2_svt_lp L=6e-08 W=3.95e-07
.ENDS

.SUBCKT NAND2BX3H9R Y VDD VSS AN B
MI0_MXNA1 a AN VSS VSS nm1p2_svt_lp L=6e-08 W=3.45e-07
MI1_MXNA2 XI1_n1 B VSS VSS nm1p2_svt_lp L=6e-08 W=4.95e-07
MI1_MXNA2_2 XI1_n1 B VSS VSS nm1p2_svt_lp L=6e-08 W=4.95e-07
MI1_MXNA2_3 XI1_n1 B VSS VSS nm1p2_svt_lp L=6e-08 W=4.95e-07
MI1_MXNA1 Y a XI1_n1 VSS nm1p2_svt_lp L=6e-08 W=4.95e-07
MI1_MXNA1_2 Y a XI1_n1 VSS nm1p2_svt_lp L=6e-08 W=4.95e-07
MI1_MXNA1_3 Y a XI1_n1 VSS nm1p2_svt_lp L=6e-08 W=4.95e-07
MI0_MXPA1 a AN VDD VDD pm1p2_svt_lp L=6e-08 W=4.8e-07
MI1_MXPA2 Y B VDD VDD pm1p2_svt_lp L=6e-08 W=3.95e-07
MI1_MXPA2_2 Y B VDD VDD pm1p2_svt_lp L=6e-08 W=3.95e-07
MI1_MXPA2_3 Y B VDD VDD pm1p2_svt_lp L=6e-08 W=3.95e-07
MI1_MXPA1 Y a VDD VDD pm1p2_svt_lp L=6e-08 W=3.95e-07
MI1_MXPA1_2 Y a VDD VDD pm1p2_svt_lp L=6e-08 W=3.95e-07
MI1_MXPA1_3 Y a VDD VDD pm1p2_svt_lp L=6e-08 W=3.95e-07
.ENDS

.SUBCKT NAND2BX4H9R Y VDD VSS AN B
MI0_MXNA1 a AN VSS VSS nm1p2_svt_lp L=6e-08 W=4.7e-07
MI1_MXNA2_2 XI1_n1__2 B VSS VSS nm1p2_svt_lp L=6e-08 W=4.95e-07
MI1_MXNA1_2 Y a XI1_n1__2 VSS nm1p2_svt_lp L=6e-08 W=4.95e-07
MI1_MXNA1_3 Y a XI1_n1__3 VSS nm1p2_svt_lp L=6e-08 W=4.95e-07
MI1_MXNA2_3 XI1_n1__3 B VSS VSS nm1p2_svt_lp L=6e-08 W=4.95e-07
MI1_MXNA2_4 XI1_n1__4 B VSS VSS nm1p2_svt_lp L=6e-08 W=4.95e-07
MI1_MXNA1_4 Y a XI1_n1__4 VSS nm1p2_svt_lp L=6e-08 W=4.95e-07
MI1_MXNA1 Y a XI1_n1 VSS nm1p2_svt_lp L=6e-08 W=4.95e-07
MI1_MXNA2 XI1_n1 B VSS VSS nm1p2_svt_lp L=6e-08 W=4.95e-07
MI0_MXPA1 a AN VDD VDD pm1p2_svt_lp L=6e-08 W=3.25e-07
MI0_MXPA1_2 a AN VDD VDD pm1p2_svt_lp L=6e-08 W=3.25e-07
MI1_MXPA1 Y a VDD VDD pm1p2_svt_lp L=6e-08 W=5.3e-07
MI1_MXPA2 Y B VDD VDD pm1p2_svt_lp L=6e-08 W=5.3e-07
MI1_MXPA2_2 Y B VDD VDD pm1p2_svt_lp L=6e-08 W=5.3e-07
MI1_MXPA1_2 Y a VDD VDD pm1p2_svt_lp L=6e-08 W=5.3e-07
MI1_MXPA1_3 Y a VDD VDD pm1p2_svt_lp L=6e-08 W=5.3e-07
MI1_MXPA2_3 Y B VDD VDD pm1p2_svt_lp L=6e-08 W=5.3e-07
.ENDS

.SUBCKT NAND2BX6H9R Y VDD VSS AN B
MI0_MXNA1 a AN VSS VSS nm1p2_svt_lp L=6e-08 W=3.4e-07
MI0_MXNA1_2 a AN VSS VSS nm1p2_svt_lp L=6e-08 W=3.4e-07
MI1_MXNA2_2 XI1_n1__2 B VSS VSS nm1p2_svt_lp L=6e-08 W=5.95e-07
MI1_MXNA1_2 Y a XI1_n1__2 VSS nm1p2_svt_lp L=6e-08 W=5.95e-07
MI1_MXNA1_3 Y a XI1_n1__3 VSS nm1p2_svt_lp L=6e-08 W=5.95e-07
MI1_MXNA2_3 XI1_n1__3 B VSS VSS nm1p2_svt_lp L=6e-08 W=5.95e-07
MI1_MXNA2_4 XI1_n1__4 B VSS VSS nm1p2_svt_lp L=6e-08 W=5.95e-07
MI1_MXNA1_4 Y a XI1_n1__4 VSS nm1p2_svt_lp L=6e-08 W=5.95e-07
MI1_MXNA1_5 Y a XI1_n1__5 VSS nm1p2_svt_lp L=6e-08 W=5.95e-07
MI1_MXNA2_5 XI1_n1__5 B VSS VSS nm1p2_svt_lp L=6e-08 W=5.95e-07
MI1_MXNA2 XI1_n1 B VSS VSS nm1p2_svt_lp L=6e-08 W=5.95e-07
MI1_MXNA1 Y a XI1_n1 VSS nm1p2_svt_lp L=6e-08 W=5.95e-07
MI0_MXPA1 a AN VDD VDD pm1p2_svt_lp L=6e-08 W=4.75e-07
MI0_MXPA1_2 a AN VDD VDD pm1p2_svt_lp L=6e-08 W=4.75e-07
MI1_MXPA2 Y B VDD VDD pm1p2_svt_lp L=6e-08 W=4.75e-07
MI1_MXPA1 Y a VDD VDD pm1p2_svt_lp L=6e-08 W=4.75e-07
MI1_MXPA1_2 Y a VDD VDD pm1p2_svt_lp L=6e-08 W=4.75e-07
MI1_MXPA2_2 Y B VDD VDD pm1p2_svt_lp L=6e-08 W=4.75e-07
MI1_MXPA2_3 Y B VDD VDD pm1p2_svt_lp L=6e-08 W=4.75e-07
MI1_MXPA1_3 Y a VDD VDD pm1p2_svt_lp L=6e-08 W=4.75e-07
MI1_MXPA1_4 Y a VDD VDD pm1p2_svt_lp L=6e-08 W=4.75e-07
MI1_MXPA2_4 Y B VDD VDD pm1p2_svt_lp L=6e-08 W=4.75e-07
MI1_MXPA2_5 Y B VDD VDD pm1p2_svt_lp L=6e-08 W=4.75e-07
MI1_MXPA1_5 Y a VDD VDD pm1p2_svt_lp L=6e-08 W=4.75e-07
.ENDS

.SUBCKT NAND2BX8H9R Y VDD VSS AN B
MI0_MXNA1 a AN VSS VSS nm1p2_svt_lp L=6e-08 W=4.65e-07
MI0_MXNA1_2 a AN VSS VSS nm1p2_svt_lp L=6e-08 W=4.65e-07
MI1_MXNA2_2 XI1_n1__2 B VSS VSS nm1p2_svt_lp L=6e-08 W=4.95e-07
MI1_MXNA1_2 Y a XI1_n1__2 VSS nm1p2_svt_lp L=6e-08 W=4.95e-07
MI1_MXNA1_3 Y a XI1_n1__3 VSS nm1p2_svt_lp L=6e-08 W=4.95e-07
MI1_MXNA2_3 XI1_n1__3 B VSS VSS nm1p2_svt_lp L=6e-08 W=4.95e-07
MI1_MXNA2_4 XI1_n1__4 B VSS VSS nm1p2_svt_lp L=6e-08 W=4.95e-07
MI1_MXNA1_4 Y a XI1_n1__4 VSS nm1p2_svt_lp L=6e-08 W=4.95e-07
MI1_MXNA1_5 Y a XI1_n1__5 VSS nm1p2_svt_lp L=6e-08 W=4.95e-07
MI1_MXNA2_5 XI1_n1__5 B VSS VSS nm1p2_svt_lp L=6e-08 W=4.95e-07
MI1_MXNA2_6 XI1_n1__6 B VSS VSS nm1p2_svt_lp L=6e-08 W=4.95e-07
MI1_MXNA1_6 Y a XI1_n1__6 VSS nm1p2_svt_lp L=6e-08 W=4.95e-07
MI1_MXNA1_7 Y a XI1_n1__7 VSS nm1p2_svt_lp L=6e-08 W=4.95e-07
MI1_MXNA2_7 XI1_n1__7 B VSS VSS nm1p2_svt_lp L=6e-08 W=4.95e-07
MI1_MXNA2_8 XI1_n1__8 B VSS VSS nm1p2_svt_lp L=6e-08 W=4.95e-07
MI1_MXNA1_8 Y a XI1_n1__8 VSS nm1p2_svt_lp L=6e-08 W=4.95e-07
MI1_MXNA1 Y a XI1_n1 VSS nm1p2_svt_lp L=6e-08 W=4.95e-07
MI1_MXNA2 XI1_n1 B VSS VSS nm1p2_svt_lp L=6e-08 W=4.95e-07
MI0_MXPA1 a AN VDD VDD pm1p2_svt_lp L=6e-08 W=3.3e-07
MI0_MXPA1_2 a AN VDD VDD pm1p2_svt_lp L=6e-08 W=3.3e-07
MI0_MXPA1_3 a AN VDD VDD pm1p2_svt_lp L=6e-08 W=3.3e-07
MI0_MXPA1_4 a AN VDD VDD pm1p2_svt_lp L=6e-08 W=3.3e-07
MI1_MXPA2 Y B VDD VDD pm1p2_svt_lp L=6e-08 W=5.3e-07
MI1_MXPA1 Y a VDD VDD pm1p2_svt_lp L=6e-08 W=5.3e-07
MI1_MXPA1_2 Y a VDD VDD pm1p2_svt_lp L=6e-08 W=5.3e-07
MI1_MXPA2_2 Y B VDD VDD pm1p2_svt_lp L=6e-08 W=5.3e-07
MI1_MXPA2_3 Y B VDD VDD pm1p2_svt_lp L=6e-08 W=5.3e-07
MI1_MXPA1_3 Y a VDD VDD pm1p2_svt_lp L=6e-08 W=5.3e-07
MI1_MXPA1_4 Y a VDD VDD pm1p2_svt_lp L=6e-08 W=5.3e-07
MI1_MXPA2_4 Y B VDD VDD pm1p2_svt_lp L=6e-08 W=5.3e-07
MI1_MXPA2_5 Y B VDD VDD pm1p2_svt_lp L=6e-08 W=5.3e-07
MI1_MXPA1_5 Y a VDD VDD pm1p2_svt_lp L=6e-08 W=5.3e-07
MI1_MXPA1_6 Y a VDD VDD pm1p2_svt_lp L=6e-08 W=5.3e-07
MI1_MXPA2_6 Y B VDD VDD pm1p2_svt_lp L=6e-08 W=5.3e-07
.ENDS

.SUBCKT NAND2XBX0P5H9R Y VDD VSS A BN
MI0_MXNA1 b BN VSS VSS nm1p2_svt_lp L=6e-08 W=1.5e-07
MI1_MXNA2 XI1_n1 b VSS VSS nm1p2_svt_lp L=6e-08 W=2.5e-07
MI1_MXNA1 Y A XI1_n1 VSS nm1p2_svt_lp L=6e-08 W=2.5e-07
MI0_MXPA1 b BN VDD VDD pm1p2_svt_lp L=6e-08 W=2.1e-07
MI1_MXPA2 Y b VDD VDD pm1p2_svt_lp L=6e-08 W=2e-07
MI1_MXPA1 Y A VDD VDD pm1p2_svt_lp L=6e-08 W=2e-07
.ENDS

.SUBCKT NAND2XBX0P7H9R Y VDD VSS A BN
MI0_MXNA1 b BN VSS VSS nm1p2_svt_lp L=6e-08 W=1.5e-07
MI1_MXNA2 XI1_n1 b VSS VSS nm1p2_svt_lp L=6e-08 W=3.5e-07
MI1_MXNA1 Y A XI1_n1 VSS nm1p2_svt_lp L=6e-08 W=3.5e-07
MI0_MXPA1 b BN VDD VDD pm1p2_svt_lp L=6e-08 W=2.1e-07
MI1_MXPA2 Y b VDD VDD pm1p2_svt_lp L=6e-08 W=2.8e-07
MI1_MXPA1 Y A VDD VDD pm1p2_svt_lp L=6e-08 W=2.8e-07
.ENDS

.SUBCKT NAND2XBX1H9R Y VDD VSS A BN
MI0_MXNA1 b BN VSS VSS nm1p2_svt_lp L=6e-08 W=1.5e-07
MI1_MXNA2 XI1_n1 b VSS VSS nm1p2_svt_lp L=6e-08 W=4.95e-07
MI1_MXNA1 Y A XI1_n1 VSS nm1p2_svt_lp L=6e-08 W=4.95e-07
MI0_MXPA1 b BN VDD VDD pm1p2_svt_lp L=6e-08 W=2.1e-07
MI1_MXPA2 Y b VDD VDD pm1p2_svt_lp L=6e-08 W=3.95e-07
MI1_MXPA1 Y A VDD VDD pm1p2_svt_lp L=6e-08 W=3.95e-07
.ENDS

.SUBCKT NAND2XBX1P4H9R Y VDD VSS A BN
MI0_MXNA1 b BN VSS VSS nm1p2_svt_lp L=6e-08 W=1.85e-07
MI1_MXNA2_2 XI1_n1__2 b VSS VSS nm1p2_svt_lp L=6e-08 W=3.5e-07
MI1_MXNA1_2 Y A XI1_n1__2 VSS nm1p2_svt_lp L=6e-08 W=3.5e-07
MI1_MXNA1 Y A XI1_n1 VSS nm1p2_svt_lp L=6e-08 W=3.5e-07
MI1_MXNA2 XI1_n1 b VSS VSS nm1p2_svt_lp L=6e-08 W=3.5e-07
MI0_MXPA1 b BN VDD VDD pm1p2_svt_lp L=6e-08 W=2.6e-07
MI1_MXPA2 Y b VDD VDD pm1p2_svt_lp L=6e-08 W=2.8e-07
MI1_MXPA1 Y A VDD VDD pm1p2_svt_lp L=6e-08 W=2.8e-07
MI1_MXPA1_2 Y A VDD VDD pm1p2_svt_lp L=6e-08 W=2.8e-07
MI1_MXPA2_2 Y b VDD VDD pm1p2_svt_lp L=6e-08 W=2.8e-07
.ENDS

.SUBCKT NAND2XBX2H9R Y VDD VSS A BN
MI0_MXNA1 b BN VSS VSS nm1p2_svt_lp L=6e-08 W=2.4e-07
MI1_MXNA2_2 XI1_n1__2 b VSS VSS nm1p2_svt_lp L=6e-08 W=4.95e-07
MI1_MXNA1_2 Y A XI1_n1__2 VSS nm1p2_svt_lp L=6e-08 W=4.95e-07
MI1_MXNA1 Y A XI1_n1 VSS nm1p2_svt_lp L=6e-08 W=4.95e-07
MI1_MXNA2 XI1_n1 b VSS VSS nm1p2_svt_lp L=6e-08 W=4.95e-07
MI0_MXPA1 b BN VDD VDD pm1p2_svt_lp L=6e-08 W=3.35e-07
MI1_MXPA2 Y b VDD VDD pm1p2_svt_lp L=6e-08 W=3.95e-07
MI1_MXPA1 Y A VDD VDD pm1p2_svt_lp L=6e-08 W=3.95e-07
MI1_MXPA1_2 Y A VDD VDD pm1p2_svt_lp L=6e-08 W=3.95e-07
MI1_MXPA2_2 Y b VDD VDD pm1p2_svt_lp L=6e-08 W=3.95e-07
.ENDS

.SUBCKT NAND2XBX3H9R Y VDD VSS A BN
MI0_MXNA1 b BN VSS VSS nm1p2_svt_lp L=6e-08 W=3.45e-07
MI1_MXNA2_2 XI1_n1__2 b VSS VSS nm1p2_svt_lp L=6e-08 W=4.95e-07
MI1_MXNA1_2 Y A XI1_n1__2 VSS nm1p2_svt_lp L=6e-08 W=4.95e-07
MI1_MXNA1_3 Y A XI1_n1__3 VSS nm1p2_svt_lp L=6e-08 W=4.95e-07
MI1_MXNA2_3 XI1_n1__3 b VSS VSS nm1p2_svt_lp L=6e-08 W=4.95e-07
MI1_MXNA2 XI1_n1 b VSS VSS nm1p2_svt_lp L=6e-08 W=4.95e-07
MI1_MXNA1 Y A XI1_n1 VSS nm1p2_svt_lp L=6e-08 W=4.95e-07
MI0_MXPA1 b BN VDD VDD pm1p2_svt_lp L=6e-08 W=4.8e-07
MI1_MXPA2 Y b VDD VDD pm1p2_svt_lp L=6e-08 W=3.95e-07
MI1_MXPA1 Y A VDD VDD pm1p2_svt_lp L=6e-08 W=3.95e-07
MI1_MXPA1_2 Y A VDD VDD pm1p2_svt_lp L=6e-08 W=3.95e-07
MI1_MXPA2_2 Y b VDD VDD pm1p2_svt_lp L=6e-08 W=3.95e-07
MI1_MXPA2_3 Y b VDD VDD pm1p2_svt_lp L=6e-08 W=3.95e-07
MI1_MXPA1_3 Y A VDD VDD pm1p2_svt_lp L=6e-08 W=3.95e-07
.ENDS

.SUBCKT NAND2XBX4H9R Y VDD VSS A BN
MI0_MXNA1 b BN VSS VSS nm1p2_svt_lp L=6e-08 W=4.7e-07
MI1_MXNA2_2 XI1_n1__2 b VSS VSS nm1p2_svt_lp L=6e-08 W=4.95e-07
MI1_MXNA1_2 Y A XI1_n1__2 VSS nm1p2_svt_lp L=6e-08 W=4.95e-07
MI1_MXNA1_3 Y A XI1_n1__3 VSS nm1p2_svt_lp L=6e-08 W=4.95e-07
MI1_MXNA2_3 XI1_n1__3 b VSS VSS nm1p2_svt_lp L=6e-08 W=4.95e-07
MI1_MXNA2_4 XI1_n1__4 b VSS VSS nm1p2_svt_lp L=6e-08 W=4.95e-07
MI1_MXNA1_4 Y A XI1_n1__4 VSS nm1p2_svt_lp L=6e-08 W=4.95e-07
MI1_MXNA1 Y A XI1_n1 VSS nm1p2_svt_lp L=6e-08 W=4.95e-07
MI1_MXNA2 XI1_n1 b VSS VSS nm1p2_svt_lp L=6e-08 W=4.95e-07
MI0_MXPA1 b BN VDD VDD pm1p2_svt_lp L=6e-08 W=3.25e-07
MI0_MXPA1_2 b BN VDD VDD pm1p2_svt_lp L=6e-08 W=3.25e-07
MI1_MXPA1 Y A VDD VDD pm1p2_svt_lp L=6e-08 W=5.3e-07
MI1_MXPA2 Y b VDD VDD pm1p2_svt_lp L=6e-08 W=5.3e-07
MI1_MXPA2_2 Y b VDD VDD pm1p2_svt_lp L=6e-08 W=5.3e-07
MI1_MXPA1_2 Y A VDD VDD pm1p2_svt_lp L=6e-08 W=5.3e-07
MI1_MXPA1_3 Y A VDD VDD pm1p2_svt_lp L=6e-08 W=5.3e-07
MI1_MXPA2_3 Y b VDD VDD pm1p2_svt_lp L=6e-08 W=5.3e-07
.ENDS

.SUBCKT NAND2XBX6H9R Y VDD VSS A BN
MI0_MXNA1 b BN VSS VSS nm1p2_svt_lp L=6e-08 W=3.4e-07
MI0_MXNA1_2 b BN VSS VSS nm1p2_svt_lp L=6e-08 W=3.4e-07
MI1_MXNA2 XI1_n1 b VSS VSS nm1p2_svt_lp L=6e-08 W=5.95e-07
MI1_MXNA2_2 XI1_n1 b VSS VSS nm1p2_svt_lp L=6e-08 W=5.95e-07
MI1_MXNA2_3 XI1_n1 b VSS VSS nm1p2_svt_lp L=6e-08 W=5.95e-07
MI1_MXNA2_4 XI1_n1 b VSS VSS nm1p2_svt_lp L=6e-08 W=5.95e-07
MI1_MXNA2_5 XI1_n1 b VSS VSS nm1p2_svt_lp L=6e-08 W=5.95e-07
MI1_MXNA1 Y A XI1_n1 VSS nm1p2_svt_lp L=6e-08 W=5.95e-07
MI1_MXNA1_2 Y A XI1_n1 VSS nm1p2_svt_lp L=6e-08 W=5.95e-07
MI1_MXNA1_3 Y A XI1_n1 VSS nm1p2_svt_lp L=6e-08 W=5.95e-07
MI1_MXNA1_4 Y A XI1_n1 VSS nm1p2_svt_lp L=6e-08 W=5.95e-07
MI1_MXNA1_5 Y A XI1_n1 VSS nm1p2_svt_lp L=6e-08 W=5.95e-07
MI0_MXPA1 b BN VDD VDD pm1p2_svt_lp L=6e-08 W=4.75e-07
MI0_MXPA1_2 b BN VDD VDD pm1p2_svt_lp L=6e-08 W=4.75e-07
MI1_MXPA2 Y b VDD VDD pm1p2_svt_lp L=6e-08 W=4.75e-07
MI1_MXPA2_2 Y b VDD VDD pm1p2_svt_lp L=6e-08 W=4.75e-07
MI1_MXPA2_3 Y b VDD VDD pm1p2_svt_lp L=6e-08 W=4.75e-07
MI1_MXPA2_4 Y b VDD VDD pm1p2_svt_lp L=6e-08 W=4.75e-07
MI1_MXPA2_5 Y b VDD VDD pm1p2_svt_lp L=6e-08 W=4.75e-07
MI1_MXPA1 Y A VDD VDD pm1p2_svt_lp L=6e-08 W=4.75e-07
MI1_MXPA1_2 Y A VDD VDD pm1p2_svt_lp L=6e-08 W=4.75e-07
MI1_MXPA1_3 Y A VDD VDD pm1p2_svt_lp L=6e-08 W=4.75e-07
MI1_MXPA1_4 Y A VDD VDD pm1p2_svt_lp L=6e-08 W=4.75e-07
MI1_MXPA1_5 Y A VDD VDD pm1p2_svt_lp L=6e-08 W=4.75e-07
.ENDS

.SUBCKT NAND2XBX8H9R Y VDD VSS A BN
MI0_MXNA1 b BN VSS VSS nm1p2_svt_lp L=6e-08 W=4.65e-07
MI0_MXNA1_2 b BN VSS VSS nm1p2_svt_lp L=6e-08 W=4.65e-07
MI1_MXNA2_2 XI1_n1__2 b VSS VSS nm1p2_svt_lp L=6e-08 W=4.95e-07
MI1_MXNA1_2 Y A XI1_n1__2 VSS nm1p2_svt_lp L=6e-08 W=4.95e-07
MI1_MXNA1_3 Y A XI1_n1__3 VSS nm1p2_svt_lp L=6e-08 W=4.95e-07
MI1_MXNA2_3 XI1_n1__3 b VSS VSS nm1p2_svt_lp L=6e-08 W=4.95e-07
MI1_MXNA2_4 XI1_n1__4 b VSS VSS nm1p2_svt_lp L=6e-08 W=4.95e-07
MI1_MXNA1_4 Y A XI1_n1__4 VSS nm1p2_svt_lp L=6e-08 W=4.95e-07
MI1_MXNA1_5 Y A XI1_n1__5 VSS nm1p2_svt_lp L=6e-08 W=4.95e-07
MI1_MXNA2_5 XI1_n1__5 b VSS VSS nm1p2_svt_lp L=6e-08 W=4.95e-07
MI1_MXNA2_6 XI1_n1__6 b VSS VSS nm1p2_svt_lp L=6e-08 W=4.95e-07
MI1_MXNA1_6 Y A XI1_n1__6 VSS nm1p2_svt_lp L=6e-08 W=4.95e-07
MI1_MXNA1_7 Y A XI1_n1__7 VSS nm1p2_svt_lp L=6e-08 W=4.95e-07
MI1_MXNA2_7 XI1_n1__7 b VSS VSS nm1p2_svt_lp L=6e-08 W=4.95e-07
MI1_MXNA2_8 XI1_n1__8 b VSS VSS nm1p2_svt_lp L=6e-08 W=4.95e-07
MI1_MXNA1_8 Y A XI1_n1__8 VSS nm1p2_svt_lp L=6e-08 W=4.95e-07
MI1_MXNA1 Y A XI1_n1 VSS nm1p2_svt_lp L=6e-08 W=4.95e-07
MI1_MXNA2 XI1_n1 b VSS VSS nm1p2_svt_lp L=6e-08 W=4.95e-07
MI0_MXPA1 b BN VDD VDD pm1p2_svt_lp L=6e-08 W=3.3e-07
MI0_MXPA1_2 b BN VDD VDD pm1p2_svt_lp L=6e-08 W=3.3e-07
MI0_MXPA1_3 b BN VDD VDD pm1p2_svt_lp L=6e-08 W=3.3e-07
MI0_MXPA1_4 b BN VDD VDD pm1p2_svt_lp L=6e-08 W=3.3e-07
MI1_MXPA2 Y b VDD VDD pm1p2_svt_lp L=6e-08 W=5.3e-07
MI1_MXPA1 Y A VDD VDD pm1p2_svt_lp L=6e-08 W=5.3e-07
MI1_MXPA1_2 Y A VDD VDD pm1p2_svt_lp L=6e-08 W=5.3e-07
MI1_MXPA2_2 Y b VDD VDD pm1p2_svt_lp L=6e-08 W=5.3e-07
MI1_MXPA2_3 Y b VDD VDD pm1p2_svt_lp L=6e-08 W=5.3e-07
MI1_MXPA1_3 Y A VDD VDD pm1p2_svt_lp L=6e-08 W=5.3e-07
MI1_MXPA1_4 Y A VDD VDD pm1p2_svt_lp L=6e-08 W=5.3e-07
MI1_MXPA2_4 Y b VDD VDD pm1p2_svt_lp L=6e-08 W=5.3e-07
MI1_MXPA2_5 Y b VDD VDD pm1p2_svt_lp L=6e-08 W=5.3e-07
MI1_MXPA1_5 Y A VDD VDD pm1p2_svt_lp L=6e-08 W=5.3e-07
MI1_MXPA1_6 Y A VDD VDD pm1p2_svt_lp L=6e-08 W=5.3e-07
MI1_MXPA2_6 Y b VDD VDD pm1p2_svt_lp L=6e-08 W=5.3e-07
.ENDS

.SUBCKT NAND3X0P5H9R Y VDD VSS A B C
MI0_MXNA3 XI0_n1 C VSS VSS nm1p2_svt_lp L=6e-08 W=2.5e-07
MI0_MXNA2 XI0_n2 B XI0_n1 VSS nm1p2_svt_lp L=6e-08 W=2.5e-07
MI0_MXNA1 Y A XI0_n2 VSS nm1p2_svt_lp L=6e-08 W=2.5e-07
MI0_MXPA3 Y C VDD VDD pm1p2_svt_lp L=6e-08 W=1.55e-07
MI0_MXPA2 Y B VDD VDD pm1p2_svt_lp L=6e-08 W=1.55e-07
MI0_MXPA1 Y A VDD VDD pm1p2_svt_lp L=6e-08 W=1.55e-07
.ENDS

.SUBCKT NAND3X0P7H9R Y VDD VSS A B C
MI0_MXNA3 XI0_n1 C VSS VSS nm1p2_svt_lp L=6e-08 W=3.5e-07
MI0_MXNA2 XI0_n2 B XI0_n1 VSS nm1p2_svt_lp L=6e-08 W=3.5e-07
MI0_MXNA1 Y A XI0_n2 VSS nm1p2_svt_lp L=6e-08 W=3.5e-07
MI0_MXPA3 Y C VDD VDD pm1p2_svt_lp L=6e-08 W=2.15e-07
MI0_MXPA2 Y B VDD VDD pm1p2_svt_lp L=6e-08 W=2.15e-07
MI0_MXPA1 Y A VDD VDD pm1p2_svt_lp L=6e-08 W=2.15e-07
.ENDS

.SUBCKT NAND3X1H9R Y VDD VSS A B C
MI0_MXNA3 XI0_n1 C VSS VSS nm1p2_svt_lp L=6e-08 W=4.95e-07
MI0_MXNA2 XI0_n2 B XI0_n1 VSS nm1p2_svt_lp L=6e-08 W=4.95e-07
MI0_MXNA1 Y A XI0_n2 VSS nm1p2_svt_lp L=6e-08 W=4.95e-07
MI0_MXPA3 Y C VDD VDD pm1p2_svt_lp L=6e-08 W=3.05e-07
MI0_MXPA2 Y B VDD VDD pm1p2_svt_lp L=6e-08 W=3.05e-07
MI0_MXPA1 Y A VDD VDD pm1p2_svt_lp L=6e-08 W=3.05e-07
.ENDS

.SUBCKT NAND3X1P4H9R Y VDD VSS A B C
MI0_MXNA3 XI0_n1 C VSS VSS nm1p2_svt_lp L=6e-08 W=3.5e-07
MI0_MXNA3_2 XI0_n1 C VSS VSS nm1p2_svt_lp L=6e-08 W=3.5e-07
MI0_MXNA2_2 XI0_n2__2 B XI0_n1 VSS nm1p2_svt_lp L=6e-08 W=3.5e-07
MI0_MXNA1_2 Y A XI0_n2__2 VSS nm1p2_svt_lp L=6e-08 W=3.5e-07
MI0_MXNA1 Y A XI0_n2 VSS nm1p2_svt_lp L=6e-08 W=3.5e-07
MI0_MXNA2 XI0_n2 B XI0_n1 VSS nm1p2_svt_lp L=6e-08 W=3.5e-07
MI0_MXPA3 Y C VDD VDD pm1p2_svt_lp L=6e-08 W=4.3e-07
MI0_MXPA2 Y B VDD VDD pm1p2_svt_lp L=6e-08 W=4.3e-07
MI0_MXPA1 Y A VDD VDD pm1p2_svt_lp L=6e-08 W=4.3e-07
.ENDS

.SUBCKT NAND3X2H9R Y VDD VSS A B C
MI0_MXNA3_2 XI0_n1__2 C VSS VSS nm1p2_svt_lp L=6e-08 W=4.95e-07
MI0_MXNA2_2 XI0_n2__2 B XI0_n1__2 VSS nm1p2_svt_lp L=6e-08 W=4.95e-07
MI0_MXNA1_2 Y A XI0_n2__2 VSS nm1p2_svt_lp L=6e-08 W=4.95e-07
MI0_MXNA1 Y A XI0_n2 VSS nm1p2_svt_lp L=6e-08 W=4.95e-07
MI0_MXNA2 XI0_n2 B XI0_n1 VSS nm1p2_svt_lp L=6e-08 W=4.95e-07
MI0_MXNA3 XI0_n1 C VSS VSS nm1p2_svt_lp L=6e-08 W=4.95e-07
MI0_MXPA3 Y C VDD VDD pm1p2_svt_lp L=6e-08 W=3.05e-07
MI0_MXPA2 Y B VDD VDD pm1p2_svt_lp L=6e-08 W=3.05e-07
MI0_MXPA1 Y A VDD VDD pm1p2_svt_lp L=6e-08 W=3.05e-07
MI0_MXPA1_2 Y A VDD VDD pm1p2_svt_lp L=6e-08 W=3.05e-07
MI0_MXPA2_2 Y B VDD VDD pm1p2_svt_lp L=6e-08 W=3.05e-07
MI0_MXPA3_2 Y C VDD VDD pm1p2_svt_lp L=6e-08 W=3.05e-07
.ENDS

.SUBCKT NAND3X3H9R Y VDD VSS A B C
MI0_MXNA3 XI0_n1 C VSS VSS nm1p2_svt_lp L=6e-08 W=4.95e-07
MI0_MXNA3_2 XI0_n1 C VSS VSS nm1p2_svt_lp L=6e-08 W=4.95e-07
MI0_MXNA3_3 XI0_n1 C VSS VSS nm1p2_svt_lp L=6e-08 W=4.95e-07
MI0_MXNA2_2 XI0_n2__2 B XI0_n1 VSS nm1p2_svt_lp L=6e-08 W=4.95e-07
MI0_MXNA1_2 Y A XI0_n2__2 VSS nm1p2_svt_lp L=6e-08 W=4.95e-07
MI0_MXNA1_3 Y A XI0_n2__3 VSS nm1p2_svt_lp L=6e-08 W=4.95e-07
MI0_MXNA2_3 XI0_n2__3 B XI0_n1 VSS nm1p2_svt_lp L=6e-08 W=4.95e-07
MI0_MXNA2 XI0_n2 B XI0_n1 VSS nm1p2_svt_lp L=6e-08 W=4.95e-07
MI0_MXNA1 Y A XI0_n2 VSS nm1p2_svt_lp L=6e-08 W=4.95e-07
MI0_MXPA3 Y C VDD VDD pm1p2_svt_lp L=6e-08 W=4.6e-07
MI0_MXPA3_2 Y C VDD VDD pm1p2_svt_lp L=6e-08 W=4.6e-07
MI0_MXPA2 Y B VDD VDD pm1p2_svt_lp L=6e-08 W=4.6e-07
MI0_MXPA1 Y A VDD VDD pm1p2_svt_lp L=6e-08 W=4.6e-07
MI0_MXPA1_2 Y A VDD VDD pm1p2_svt_lp L=6e-08 W=4.6e-07
MI0_MXPA2_2 Y B VDD VDD pm1p2_svt_lp L=6e-08 W=4.6e-07
.ENDS

.SUBCKT NAND3X4H9R Y VDD VSS A B C
MI0_MXNA2_2 XI0_n2__2 B XI0_n1 VSS nm1p2_svt_lp L=6e-08 W=4.95e-07
MI0_MXNA1_2 Y A XI0_n2__2 VSS nm1p2_svt_lp L=6e-08 W=4.95e-07
MI0_MXNA1_3 Y A XI0_n2__3 VSS nm1p2_svt_lp L=6e-08 W=4.95e-07
MI0_MXNA2_3 XI0_n2__3 B XI0_n1 VSS nm1p2_svt_lp L=6e-08 W=4.95e-07
MI0_MXNA2_4 XI0_n2__4 B XI0_n1 VSS nm1p2_svt_lp L=6e-08 W=4.95e-07
MI0_MXNA1_4 Y A XI0_n2__4 VSS nm1p2_svt_lp L=6e-08 W=4.95e-07
MI0_MXNA1 Y A XI0_n2 VSS nm1p2_svt_lp L=6e-08 W=4.95e-07
MI0_MXNA2 XI0_n2 B XI0_n1 VSS nm1p2_svt_lp L=6e-08 W=4.95e-07
MI0_MXNA3 XI0_n1 C VSS VSS nm1p2_svt_lp L=6e-08 W=4.95e-07
MI0_MXNA3_2 XI0_n1 C VSS VSS nm1p2_svt_lp L=6e-08 W=4.95e-07
MI0_MXNA3_3 XI0_n1 C VSS VSS nm1p2_svt_lp L=6e-08 W=4.95e-07
MI0_MXNA3_4 XI0_n1 C VSS VSS nm1p2_svt_lp L=6e-08 W=4.95e-07
MI0_MXPA1 Y A VDD VDD pm1p2_svt_lp L=6e-08 W=4.1e-07
MI0_MXPA2 Y B VDD VDD pm1p2_svt_lp L=6e-08 W=4.1e-07
MI0_MXPA2_2 Y B VDD VDD pm1p2_svt_lp L=6e-08 W=4.1e-07
MI0_MXPA1_2 Y A VDD VDD pm1p2_svt_lp L=6e-08 W=4.1e-07
MI0_MXPA1_3 Y A VDD VDD pm1p2_svt_lp L=6e-08 W=4.1e-07
MI0_MXPA2_3 Y B VDD VDD pm1p2_svt_lp L=6e-08 W=4.1e-07
MI0_MXPA3 Y C VDD VDD pm1p2_svt_lp L=6e-08 W=4.1e-07
MI0_MXPA3_2 Y C VDD VDD pm1p2_svt_lp L=6e-08 W=4.1e-07
MI0_MXPA3_3 Y C VDD VDD pm1p2_svt_lp L=6e-08 W=4.1e-07
.ENDS

.SUBCKT NAND3X6H9R Y VDD VSS A B C
MI0_MXNA3 XI0_n1 C VSS VSS nm1p2_svt_lp L=6e-08 W=4.95e-07
MI0_MXNA3_2 XI0_n1 C VSS VSS nm1p2_svt_lp L=6e-08 W=4.95e-07
MI0_MXNA3_3 XI0_n1 C VSS VSS nm1p2_svt_lp L=6e-08 W=4.95e-07
MI0_MXNA3_4 XI0_n1 C VSS VSS nm1p2_svt_lp L=6e-08 W=4.95e-07
MI0_MXNA3_5 XI0_n1 C VSS VSS nm1p2_svt_lp L=6e-08 W=4.95e-07
MI0_MXNA3_6 XI0_n1 C VSS VSS nm1p2_svt_lp L=6e-08 W=4.95e-07
MI0_MXNA2_2 XI0_n2__2 B XI0_n1 VSS nm1p2_svt_lp L=6e-08 W=4.95e-07
MI0_MXNA1_2 Y A XI0_n2__2 VSS nm1p2_svt_lp L=6e-08 W=4.95e-07
MI0_MXNA1_3 Y A XI0_n2__3 VSS nm1p2_svt_lp L=6e-08 W=4.95e-07
MI0_MXNA2_3 XI0_n2__3 B XI0_n1 VSS nm1p2_svt_lp L=6e-08 W=4.95e-07
MI0_MXNA2_4 XI0_n2__4 B XI0_n1 VSS nm1p2_svt_lp L=6e-08 W=4.95e-07
MI0_MXNA1_4 Y A XI0_n2__4 VSS nm1p2_svt_lp L=6e-08 W=4.95e-07
MI0_MXNA1_5 Y A XI0_n2__5 VSS nm1p2_svt_lp L=6e-08 W=4.95e-07
MI0_MXNA2_5 XI0_n2__5 B XI0_n1 VSS nm1p2_svt_lp L=6e-08 W=4.95e-07
MI0_MXNA2_6 XI0_n2__6 B XI0_n1 VSS nm1p2_svt_lp L=6e-08 W=4.95e-07
MI0_MXNA1_6 Y A XI0_n2__6 VSS nm1p2_svt_lp L=6e-08 W=4.95e-07
MI0_MXNA1 Y A XI0_n2 VSS nm1p2_svt_lp L=6e-08 W=4.95e-07
MI0_MXNA2 XI0_n2 B XI0_n1 VSS nm1p2_svt_lp L=6e-08 W=4.95e-07
MI0_MXPA3 Y C VDD VDD pm1p2_svt_lp L=6e-08 W=4.6e-07
MI0_MXPA3_2 Y C VDD VDD pm1p2_svt_lp L=6e-08 W=4.6e-07
MI0_MXPA3_3 Y C VDD VDD pm1p2_svt_lp L=6e-08 W=4.6e-07
MI0_MXPA3_4 Y C VDD VDD pm1p2_svt_lp L=6e-08 W=4.6e-07
MI0_MXPA2 Y B VDD VDD pm1p2_svt_lp L=6e-08 W=4.6e-07
MI0_MXPA1 Y A VDD VDD pm1p2_svt_lp L=6e-08 W=4.6e-07
MI0_MXPA1_2 Y A VDD VDD pm1p2_svt_lp L=6e-08 W=4.6e-07
MI0_MXPA2_2 Y B VDD VDD pm1p2_svt_lp L=6e-08 W=4.6e-07
MI0_MXPA2_3 Y B VDD VDD pm1p2_svt_lp L=6e-08 W=4.6e-07
MI0_MXPA1_3 Y A VDD VDD pm1p2_svt_lp L=6e-08 W=4.6e-07
MI0_MXPA1_4 Y A VDD VDD pm1p2_svt_lp L=6e-08 W=4.6e-07
MI0_MXPA2_4 Y B VDD VDD pm1p2_svt_lp L=6e-08 W=4.6e-07
.ENDS

.SUBCKT NAND3BX0P5H9R Y VDD VSS AN B C
MI0_MXNA1 a AN VSS VSS nm1p2_svt_lp L=6e-08 W=1.5e-07
MI1_MXNA3 XI1_n1 C VSS VSS nm1p2_svt_lp L=6e-08 W=2.5e-07
MI1_MXNA2 XI1_n2 B XI1_n1 VSS nm1p2_svt_lp L=6e-08 W=2.5e-07
MI1_MXNA1 Y a XI1_n2 VSS nm1p2_svt_lp L=6e-08 W=2.5e-07
MI0_MXPA1 a AN VDD VDD pm1p2_svt_lp L=6e-08 W=2.1e-07
MI1_MXPA3 Y C VDD VDD pm1p2_svt_lp L=6e-08 W=1.55e-07
MI1_MXPA2 Y B VDD VDD pm1p2_svt_lp L=6e-08 W=1.55e-07
MI1_MXPA1 Y a VDD VDD pm1p2_svt_lp L=6e-08 W=1.55e-07
.ENDS

.SUBCKT NAND3BX0P7H9R Y VDD VSS AN B C
MI0_MXNA1 a AN VSS VSS nm1p2_svt_lp L=6e-08 W=1.5e-07
MI1_MXNA3 XI1_n1 C VSS VSS nm1p2_svt_lp L=6e-08 W=3.5e-07
MI1_MXNA2 XI1_n2 B XI1_n1 VSS nm1p2_svt_lp L=6e-08 W=3.5e-07
MI1_MXNA1 Y a XI1_n2 VSS nm1p2_svt_lp L=6e-08 W=3.5e-07
MI0_MXPA1 a AN VDD VDD pm1p2_svt_lp L=6e-08 W=2.1e-07
MI1_MXPA3 Y C VDD VDD pm1p2_svt_lp L=6e-08 W=2.15e-07
MI1_MXPA2 Y B VDD VDD pm1p2_svt_lp L=6e-08 W=2.15e-07
MI1_MXPA1 Y a VDD VDD pm1p2_svt_lp L=6e-08 W=2.15e-07
.ENDS

.SUBCKT NAND3BX1H9R Y VDD VSS AN B C
MI0_MXNA1 a AN VSS VSS nm1p2_svt_lp L=6e-08 W=1.5e-07
MI1_MXNA3 XI1_n1 C VSS VSS nm1p2_svt_lp L=6e-08 W=4.95e-07
MI1_MXNA2 XI1_n2 B XI1_n1 VSS nm1p2_svt_lp L=6e-08 W=4.95e-07
MI1_MXNA1 Y a XI1_n2 VSS nm1p2_svt_lp L=6e-08 W=4.95e-07
MI0_MXPA1 a AN VDD VDD pm1p2_svt_lp L=6e-08 W=2.1e-07
MI1_MXPA3 Y C VDD VDD pm1p2_svt_lp L=6e-08 W=3.05e-07
MI1_MXPA2 Y B VDD VDD pm1p2_svt_lp L=6e-08 W=3.05e-07
MI1_MXPA1 Y a VDD VDD pm1p2_svt_lp L=6e-08 W=3.05e-07
.ENDS

.SUBCKT NAND3BX1P4H9R Y VDD VSS AN B C
MI0_MXNA1 a AN VSS VSS nm1p2_svt_lp L=6e-08 W=1.7e-07
MI1_MXNA3_2 XI1_n1__2 C VSS VSS nm1p2_svt_lp L=6e-08 W=3.5e-07
MI1_MXNA2_2 XI1_n2__2 B XI1_n1__2 VSS nm1p2_svt_lp L=6e-08 W=3.5e-07
MI1_MXNA1_2 Y a XI1_n2__2 VSS nm1p2_svt_lp L=6e-08 W=3.5e-07
MI1_MXNA1 Y a XI1_n2 VSS nm1p2_svt_lp L=6e-08 W=3.5e-07
MI1_MXNA2 XI1_n2 B XI1_n1 VSS nm1p2_svt_lp L=6e-08 W=3.5e-07
MI1_MXNA3 XI1_n1 C VSS VSS nm1p2_svt_lp L=6e-08 W=3.5e-07
MI0_MXPA1 a AN VDD VDD pm1p2_svt_lp L=6e-08 W=2.4e-07
MI1_MXPA3 Y C VDD VDD pm1p2_svt_lp L=6e-08 W=2.15e-07
MI1_MXPA2 Y B VDD VDD pm1p2_svt_lp L=6e-08 W=2.15e-07
MI1_MXPA1 Y a VDD VDD pm1p2_svt_lp L=6e-08 W=2.15e-07
MI1_MXPA1_2 Y a VDD VDD pm1p2_svt_lp L=6e-08 W=2.15e-07
MI1_MXPA2_2 Y B VDD VDD pm1p2_svt_lp L=6e-08 W=2.15e-07
MI1_MXPA3_2 Y C VDD VDD pm1p2_svt_lp L=6e-08 W=2.15e-07
.ENDS

.SUBCKT NAND3BX2H9R Y VDD VSS AN B C
MI0_MXNA1 a AN VSS VSS nm1p2_svt_lp L=6e-08 W=2.2e-07
MI1_MXNA3_2 XI1_n1__2 C VSS VSS nm1p2_svt_lp L=6e-08 W=4.95e-07
MI1_MXNA2_2 XI1_n2__2 B XI1_n1__2 VSS nm1p2_svt_lp L=6e-08 W=4.95e-07
MI1_MXNA1_2 Y a XI1_n2__2 VSS nm1p2_svt_lp L=6e-08 W=4.95e-07
MI1_MXNA1 Y a XI1_n2 VSS nm1p2_svt_lp L=6e-08 W=4.95e-07
MI1_MXNA2 XI1_n2 B XI1_n1 VSS nm1p2_svt_lp L=6e-08 W=4.95e-07
MI1_MXNA3 XI1_n1 C VSS VSS nm1p2_svt_lp L=6e-08 W=4.95e-07
MI0_MXPA1 a AN VDD VDD pm1p2_svt_lp L=6e-08 W=3.1e-07
MI1_MXPA3 Y C VDD VDD pm1p2_svt_lp L=6e-08 W=3.05e-07
MI1_MXPA2 Y B VDD VDD pm1p2_svt_lp L=6e-08 W=3.05e-07
MI1_MXPA1 Y a VDD VDD pm1p2_svt_lp L=6e-08 W=3.05e-07
MI1_MXPA1_2 Y a VDD VDD pm1p2_svt_lp L=6e-08 W=3.05e-07
MI1_MXPA2_2 Y B VDD VDD pm1p2_svt_lp L=6e-08 W=3.05e-07
MI1_MXPA3_2 Y C VDD VDD pm1p2_svt_lp L=6e-08 W=3.05e-07
.ENDS

.SUBCKT NAND3BX3H9R Y VDD VSS AN B C
MI0_MXNA1 a AN VSS VSS nm1p2_svt_lp L=6e-08 W=3.15e-07
MI1_MXNA3 XI1_n1 C VSS VSS nm1p2_svt_lp L=6e-08 W=4.95e-07
MI1_MXNA3_2 XI1_n1 C VSS VSS nm1p2_svt_lp L=6e-08 W=4.95e-07
MI1_MXNA3_3 XI1_n1 C VSS VSS nm1p2_svt_lp L=6e-08 W=4.95e-07
MI1_MXNA2_2 XI1_n2__2 B XI1_n1 VSS nm1p2_svt_lp L=6e-08 W=4.95e-07
MI1_MXNA1_2 Y a XI1_n2__2 VSS nm1p2_svt_lp L=6e-08 W=4.95e-07
MI1_MXNA1_3 Y a XI1_n2__3 VSS nm1p2_svt_lp L=6e-08 W=4.95e-07
MI1_MXNA2_3 XI1_n2__3 B XI1_n1 VSS nm1p2_svt_lp L=6e-08 W=4.95e-07
MI1_MXNA2 XI1_n2 B XI1_n1 VSS nm1p2_svt_lp L=6e-08 W=4.95e-07
MI1_MXNA1 Y a XI1_n2 VSS nm1p2_svt_lp L=6e-08 W=4.95e-07
MI0_MXPA1 a AN VDD VDD pm1p2_svt_lp L=6e-08 W=4.4e-07
MI1_MXPA3 Y C VDD VDD pm1p2_svt_lp L=6e-08 W=4.6e-07
MI1_MXPA3_2 Y C VDD VDD pm1p2_svt_lp L=6e-08 W=4.6e-07
MI1_MXPA2 Y B VDD VDD pm1p2_svt_lp L=6e-08 W=4.6e-07
MI1_MXPA1 Y a VDD VDD pm1p2_svt_lp L=6e-08 W=4.6e-07
MI1_MXPA1_2 Y a VDD VDD pm1p2_svt_lp L=6e-08 W=4.6e-07
MI1_MXPA2_2 Y B VDD VDD pm1p2_svt_lp L=6e-08 W=4.6e-07
.ENDS

.SUBCKT NAND3BX4H9R Y VDD VSS AN B C
MI0_MXNA1 a AN VSS VSS nm1p2_svt_lp L=6e-08 W=4.15e-07
MI1_MXNA3 XI1_n1 C VSS VSS nm1p2_svt_lp L=6e-08 W=6.6e-07
MI1_MXNA3_2 XI1_n1 C VSS VSS nm1p2_svt_lp L=6e-08 W=6.6e-07
MI1_MXNA3_3 XI1_n1 C VSS VSS nm1p2_svt_lp L=6e-08 W=6.6e-07
MI1_MXNA2_2 XI1_n2__2 B XI1_n1 VSS nm1p2_svt_lp L=6e-08 W=6.6e-07
MI1_MXNA1_2 Y a XI1_n2__2 VSS nm1p2_svt_lp L=6e-08 W=6.6e-07
MI1_MXNA1_3 Y a XI1_n2__3 VSS nm1p2_svt_lp L=6e-08 W=6.6e-07
MI1_MXNA2_3 XI1_n2__3 B XI1_n1 VSS nm1p2_svt_lp L=6e-08 W=6.6e-07
MI1_MXNA2 XI1_n2 B XI1_n1 VSS nm1p2_svt_lp L=6e-08 W=6.6e-07
MI1_MXNA1 Y a XI1_n2 VSS nm1p2_svt_lp L=6e-08 W=6.6e-07
MI0_MXPA1 a AN VDD VDD pm1p2_svt_lp L=6e-08 W=2.9e-07
MI0_MXPA1_2 a AN VDD VDD pm1p2_svt_lp L=6e-08 W=2.9e-07
MI1_MXPA3 Y C VDD VDD pm1p2_svt_lp L=6e-08 W=4.1e-07
MI1_MXPA3_2 Y C VDD VDD pm1p2_svt_lp L=6e-08 W=4.1e-07
MI1_MXPA3_3 Y C VDD VDD pm1p2_svt_lp L=6e-08 W=4.1e-07
MI1_MXPA2 Y B VDD VDD pm1p2_svt_lp L=6e-08 W=4.1e-07
MI1_MXPA1 Y a VDD VDD pm1p2_svt_lp L=6e-08 W=4.1e-07
MI1_MXPA1_2 Y a VDD VDD pm1p2_svt_lp L=6e-08 W=4.1e-07
MI1_MXPA2_2 Y B VDD VDD pm1p2_svt_lp L=6e-08 W=4.1e-07
MI1_MXPA2_3 Y B VDD VDD pm1p2_svt_lp L=6e-08 W=4.1e-07
MI1_MXPA1_3 Y a VDD VDD pm1p2_svt_lp L=6e-08 W=4.1e-07
.ENDS

.SUBCKT NAND3BX6H9R Y VDD VSS AN B C
MI0_MXNA1 a AN VSS VSS nm1p2_svt_lp L=6e-08 W=6.2e-07
MI1_MXNA3 XI1_n1 C VSS VSS nm1p2_svt_lp L=6e-08 W=5.95e-07
MI1_MXNA3_2 XI1_n1 C VSS VSS nm1p2_svt_lp L=6e-08 W=5.95e-07
MI1_MXNA3_3 XI1_n1 C VSS VSS nm1p2_svt_lp L=6e-08 W=5.95e-07
MI1_MXNA3_4 XI1_n1 C VSS VSS nm1p2_svt_lp L=6e-08 W=5.95e-07
MI1_MXNA3_5 XI1_n1 C VSS VSS nm1p2_svt_lp L=6e-08 W=5.95e-07
MI1_MXNA2_2 XI1_n2__2 B XI1_n1 VSS nm1p2_svt_lp L=6e-08 W=5.95e-07
MI1_MXNA1_2 Y a XI1_n2__2 VSS nm1p2_svt_lp L=6e-08 W=5.95e-07
MI1_MXNA1_3 Y a XI1_n2__3 VSS nm1p2_svt_lp L=6e-08 W=5.95e-07
MI1_MXNA2_3 XI1_n2__3 B XI1_n1 VSS nm1p2_svt_lp L=6e-08 W=5.95e-07
MI1_MXNA2_4 XI1_n2__4 B XI1_n1 VSS nm1p2_svt_lp L=6e-08 W=5.95e-07
MI1_MXNA1_4 Y a XI1_n2__4 VSS nm1p2_svt_lp L=6e-08 W=5.95e-07
MI1_MXNA1_5 Y a XI1_n2__5 VSS nm1p2_svt_lp L=6e-08 W=5.95e-07
MI1_MXNA2_5 XI1_n2__5 B XI1_n1 VSS nm1p2_svt_lp L=6e-08 W=5.95e-07
MI1_MXNA2 XI1_n2 B XI1_n1 VSS nm1p2_svt_lp L=6e-08 W=5.95e-07
MI1_MXNA1 Y a XI1_n2 VSS nm1p2_svt_lp L=6e-08 W=5.95e-07
MI0_MXPA1 a AN VDD VDD pm1p2_svt_lp L=6e-08 W=4.35e-07
MI0_MXPA1_2 a AN VDD VDD pm1p2_svt_lp L=6e-08 W=4.35e-07
MI1_MXPA3 Y C VDD VDD pm1p2_svt_lp L=6e-08 W=3.7e-07
MI1_MXPA3_2 Y C VDD VDD pm1p2_svt_lp L=6e-08 W=3.7e-07
MI1_MXPA3_3 Y C VDD VDD pm1p2_svt_lp L=6e-08 W=3.7e-07
MI1_MXPA3_4 Y C VDD VDD pm1p2_svt_lp L=6e-08 W=3.7e-07
MI1_MXPA3_5 Y C VDD VDD pm1p2_svt_lp L=6e-08 W=3.7e-07
MI1_MXPA2 Y B VDD VDD pm1p2_svt_lp L=6e-08 W=3.7e-07
MI1_MXPA1 Y a VDD VDD pm1p2_svt_lp L=6e-08 W=3.7e-07
MI1_MXPA1_2 Y a VDD VDD pm1p2_svt_lp L=6e-08 W=3.7e-07
MI1_MXPA2_2 Y B VDD VDD pm1p2_svt_lp L=6e-08 W=3.7e-07
MI1_MXPA2_3 Y B VDD VDD pm1p2_svt_lp L=6e-08 W=3.7e-07
MI1_MXPA1_3 Y a VDD VDD pm1p2_svt_lp L=6e-08 W=3.7e-07
MI1_MXPA1_4 Y a VDD VDD pm1p2_svt_lp L=6e-08 W=3.7e-07
MI1_MXPA2_4 Y B VDD VDD pm1p2_svt_lp L=6e-08 W=3.7e-07
MI1_MXPA2_5 Y B VDD VDD pm1p2_svt_lp L=6e-08 W=3.7e-07
MI1_MXPA1_5 Y a VDD VDD pm1p2_svt_lp L=6e-08 W=3.7e-07
.ENDS

.SUBCKT NAND3XXBX0P5H9R Y VDD VSS A B CN
MI0_MXNA1 c CN VSS VSS nm1p2_svt_lp L=6e-08 W=1.5e-07
MI1_MXNA3 XI1_n1 c VSS VSS nm1p2_svt_lp L=6e-08 W=2.5e-07
MI1_MXNA2 XI1_n2 B XI1_n1 VSS nm1p2_svt_lp L=6e-08 W=2.5e-07
MI1_MXNA1 Y A XI1_n2 VSS nm1p2_svt_lp L=6e-08 W=2.5e-07
MI0_MXPA1 c CN VDD VDD pm1p2_svt_lp L=6e-08 W=2.1e-07
MI1_MXPA3 Y c VDD VDD pm1p2_svt_lp L=6e-08 W=1.55e-07
MI1_MXPA2 Y B VDD VDD pm1p2_svt_lp L=6e-08 W=1.55e-07
MI1_MXPA1 Y A VDD VDD pm1p2_svt_lp L=6e-08 W=1.55e-07
.ENDS

.SUBCKT NAND3XXBX0P7H9R Y VDD VSS A B CN
MI0_MXNA1 c CN VSS VSS nm1p2_svt_lp L=6e-08 W=1.5e-07
MI1_MXNA3 XI1_n1 c VSS VSS nm1p2_svt_lp L=6e-08 W=3.5e-07
MI1_MXNA2 XI1_n2 B XI1_n1 VSS nm1p2_svt_lp L=6e-08 W=3.5e-07
MI1_MXNA1 Y A XI1_n2 VSS nm1p2_svt_lp L=6e-08 W=3.5e-07
MI0_MXPA1 c CN VDD VDD pm1p2_svt_lp L=6e-08 W=2.1e-07
MI1_MXPA3 Y c VDD VDD pm1p2_svt_lp L=6e-08 W=2.15e-07
MI1_MXPA2 Y B VDD VDD pm1p2_svt_lp L=6e-08 W=2.15e-07
MI1_MXPA1 Y A VDD VDD pm1p2_svt_lp L=6e-08 W=2.15e-07
.ENDS

.SUBCKT NAND3XXBX1H9R Y VDD VSS A B CN
MI0_MXNA1 c CN VSS VSS nm1p2_svt_lp L=6e-08 W=1.5e-07
MI1_MXNA3 XI1_n1 c VSS VSS nm1p2_svt_lp L=6e-08 W=4.95e-07
MI1_MXNA2 XI1_n2 B XI1_n1 VSS nm1p2_svt_lp L=6e-08 W=4.95e-07
MI1_MXNA1 Y A XI1_n2 VSS nm1p2_svt_lp L=6e-08 W=4.95e-07
MI0_MXPA1 c CN VDD VDD pm1p2_svt_lp L=6e-08 W=2.1e-07
MI1_MXPA3 Y c VDD VDD pm1p2_svt_lp L=6e-08 W=3.05e-07
MI1_MXPA2 Y B VDD VDD pm1p2_svt_lp L=6e-08 W=3.05e-07
MI1_MXPA1 Y A VDD VDD pm1p2_svt_lp L=6e-08 W=3.05e-07
.ENDS

.SUBCKT NAND3XXBX1P4H9R Y VDD VSS A B CN
MI0_MXNA1 c CN VSS VSS nm1p2_svt_lp L=6e-08 W=1.7e-07
MI1_MXNA3_2 XI1_n1__2 c VSS VSS nm1p2_svt_lp L=6e-08 W=3.5e-07
MI1_MXNA2_2 XI1_n2__2 B XI1_n1__2 VSS nm1p2_svt_lp L=6e-08 W=3.5e-07
MI1_MXNA1_2 Y A XI1_n2__2 VSS nm1p2_svt_lp L=6e-08 W=3.5e-07
MI1_MXNA1 Y A XI1_n2 VSS nm1p2_svt_lp L=6e-08 W=3.5e-07
MI1_MXNA2 XI1_n2 B XI1_n1 VSS nm1p2_svt_lp L=6e-08 W=3.5e-07
MI1_MXNA3 XI1_n1 c VSS VSS nm1p2_svt_lp L=6e-08 W=3.5e-07
MI0_MXPA1 c CN VDD VDD pm1p2_svt_lp L=6e-08 W=2.4e-07
MI1_MXPA3 Y c VDD VDD pm1p2_svt_lp L=6e-08 W=4.3e-07
MI1_MXPA2 Y B VDD VDD pm1p2_svt_lp L=6e-08 W=4.3e-07
MI1_MXPA1 Y A VDD VDD pm1p2_svt_lp L=6e-08 W=2.15e-07
MI1_MXPA1_2 Y A VDD VDD pm1p2_svt_lp L=6e-08 W=2.15e-07
.ENDS

.SUBCKT NAND3XXBX2H9R Y VDD VSS A B CN
MI0_MXNA1 c CN VSS VSS nm1p2_svt_lp L=6e-08 W=2.2e-07
MI1_MXNA3_2 XI1_n1__2 c VSS VSS nm1p2_svt_lp L=6e-08 W=4.95e-07
MI1_MXNA2_2 XI1_n2__2 B XI1_n1__2 VSS nm1p2_svt_lp L=6e-08 W=4.95e-07
MI1_MXNA1_2 Y A XI1_n2__2 VSS nm1p2_svt_lp L=6e-08 W=4.95e-07
MI1_MXNA1 Y A XI1_n2 VSS nm1p2_svt_lp L=6e-08 W=4.95e-07
MI1_MXNA2 XI1_n2 B XI1_n1 VSS nm1p2_svt_lp L=6e-08 W=4.95e-07
MI1_MXNA3 XI1_n1 c VSS VSS nm1p2_svt_lp L=6e-08 W=4.95e-07
MI0_MXPA1 c CN VDD VDD pm1p2_svt_lp L=6e-08 W=3.1e-07
MI1_MXPA3 Y c VDD VDD pm1p2_svt_lp L=6e-08 W=3.05e-07
MI1_MXPA2 Y B VDD VDD pm1p2_svt_lp L=6e-08 W=3.05e-07
MI1_MXPA1 Y A VDD VDD pm1p2_svt_lp L=6e-08 W=3.05e-07
MI1_MXPA1_2 Y A VDD VDD pm1p2_svt_lp L=6e-08 W=3.05e-07
MI1_MXPA2_2 Y B VDD VDD pm1p2_svt_lp L=6e-08 W=3.05e-07
MI1_MXPA3_2 Y c VDD VDD pm1p2_svt_lp L=6e-08 W=3.05e-07
.ENDS

.SUBCKT NAND3XXBX3H9R Y VDD VSS A B CN
MI0_MXNA1 c CN VSS VSS nm1p2_svt_lp L=6e-08 W=3.15e-07
MI1_MXNA3 XI1_n1 c VSS VSS nm1p2_svt_lp L=6e-08 W=4.95e-07
MI1_MXNA3_2 XI1_n1 c VSS VSS nm1p2_svt_lp L=6e-08 W=4.95e-07
MI1_MXNA3_3 XI1_n1 c VSS VSS nm1p2_svt_lp L=6e-08 W=4.95e-07
MI1_MXNA2_2 XI1_n2__2 B XI1_n1 VSS nm1p2_svt_lp L=6e-08 W=4.95e-07
MI1_MXNA1_2 Y A XI1_n2__2 VSS nm1p2_svt_lp L=6e-08 W=4.95e-07
MI1_MXNA1_3 Y A XI1_n2__3 VSS nm1p2_svt_lp L=6e-08 W=4.95e-07
MI1_MXNA2_3 XI1_n2__3 B XI1_n1 VSS nm1p2_svt_lp L=6e-08 W=4.95e-07
MI1_MXNA2 XI1_n2 B XI1_n1 VSS nm1p2_svt_lp L=6e-08 W=4.95e-07
MI1_MXNA1 Y A XI1_n2 VSS nm1p2_svt_lp L=6e-08 W=4.95e-07
MI0_MXPA1 c CN VDD VDD pm1p2_svt_lp L=6e-08 W=4.4e-07
MI1_MXPA3 Y c VDD VDD pm1p2_svt_lp L=6e-08 W=4.6e-07
MI1_MXPA3_2 Y c VDD VDD pm1p2_svt_lp L=6e-08 W=4.6e-07
MI1_MXPA2 Y B VDD VDD pm1p2_svt_lp L=6e-08 W=4.6e-07
MI1_MXPA1 Y A VDD VDD pm1p2_svt_lp L=6e-08 W=4.6e-07
MI1_MXPA1_2 Y A VDD VDD pm1p2_svt_lp L=6e-08 W=4.6e-07
MI1_MXPA2_2 Y B VDD VDD pm1p2_svt_lp L=6e-08 W=2.3e-07
MI1_MXPA2_3 Y B VDD VDD pm1p2_svt_lp L=6e-08 W=2.3e-07
.ENDS

.SUBCKT NAND3XXBX4H9R Y VDD VSS A B CN
MI0_MXNA1 c CN VSS VSS nm1p2_svt_lp L=6e-08 W=4.15e-07
MI1_MXNA3 XI1_n1 c VSS VSS nm1p2_svt_lp L=6e-08 W=6.6e-07
MI1_MXNA3_2 XI1_n1 c VSS VSS nm1p2_svt_lp L=6e-08 W=6.6e-07
MI1_MXNA3_3 XI1_n1 c VSS VSS nm1p2_svt_lp L=6e-08 W=6.6e-07
MI1_MXNA2_2 XI1_n2__2 B XI1_n1 VSS nm1p2_svt_lp L=6e-08 W=6.6e-07
MI1_MXNA1_2 Y A XI1_n2__2 VSS nm1p2_svt_lp L=6e-08 W=6.6e-07
MI1_MXNA1_3 Y A XI1_n2__3 VSS nm1p2_svt_lp L=6e-08 W=6.6e-07
MI1_MXNA2_3 XI1_n2__3 B XI1_n1 VSS nm1p2_svt_lp L=6e-08 W=6.6e-07
MI1_MXNA2 XI1_n2 B XI1_n1 VSS nm1p2_svt_lp L=6e-08 W=6.6e-07
MI1_MXNA1 Y A XI1_n2 VSS nm1p2_svt_lp L=6e-08 W=6.6e-07
MI0_MXPA1 c CN VDD VDD pm1p2_svt_lp L=6e-08 W=2.9e-07
MI0_MXPA1_2 c CN VDD VDD pm1p2_svt_lp L=6e-08 W=2.9e-07
MI1_MXPA3 Y c VDD VDD pm1p2_svt_lp L=6e-08 W=4.1e-07
MI1_MXPA3_2 Y c VDD VDD pm1p2_svt_lp L=6e-08 W=4.1e-07
MI1_MXPA3_3 Y c VDD VDD pm1p2_svt_lp L=6e-08 W=4.1e-07
MI1_MXPA2 Y B VDD VDD pm1p2_svt_lp L=6e-08 W=4.1e-07
MI1_MXPA1 Y A VDD VDD pm1p2_svt_lp L=6e-08 W=4.1e-07
MI1_MXPA1_2 Y A VDD VDD pm1p2_svt_lp L=6e-08 W=4.1e-07
MI1_MXPA2_2 Y B VDD VDD pm1p2_svt_lp L=6e-08 W=4.1e-07
MI1_MXPA2_3 Y B VDD VDD pm1p2_svt_lp L=6e-08 W=4.1e-07
MI1_MXPA1_3 Y A VDD VDD pm1p2_svt_lp L=6e-08 W=4.1e-07
.ENDS

.SUBCKT NAND3XXBX6H9R Y VDD VSS A B CN
MI0_MXNA1 c CN VSS VSS nm1p2_svt_lp L=6e-08 W=3.1e-07
MI0_MXNA1_2 c CN VSS VSS nm1p2_svt_lp L=6e-08 W=3.1e-07
MI1_MXNA3 XI1_n1 c VSS VSS nm1p2_svt_lp L=6e-08 W=5.95e-07
MI1_MXNA3_2 XI1_n1 c VSS VSS nm1p2_svt_lp L=6e-08 W=5.95e-07
MI1_MXNA3_3 XI1_n1 c VSS VSS nm1p2_svt_lp L=6e-08 W=5.95e-07
MI1_MXNA3_4 XI1_n1 c VSS VSS nm1p2_svt_lp L=6e-08 W=5.95e-07
MI1_MXNA3_5 XI1_n1 c VSS VSS nm1p2_svt_lp L=6e-08 W=5.95e-07
MI1_MXNA2_2 XI1_n2__2 B XI1_n1 VSS nm1p2_svt_lp L=6e-08 W=5.95e-07
MI1_MXNA1_2 Y A XI1_n2__2 VSS nm1p2_svt_lp L=6e-08 W=5.95e-07
MI1_MXNA1_3 Y A XI1_n2__3 VSS nm1p2_svt_lp L=6e-08 W=5.95e-07
MI1_MXNA2_3 XI1_n2__3 B XI1_n1 VSS nm1p2_svt_lp L=6e-08 W=5.95e-07
MI1_MXNA2_4 XI1_n2__4 B XI1_n1 VSS nm1p2_svt_lp L=6e-08 W=5.95e-07
MI1_MXNA1_4 Y A XI1_n2__4 VSS nm1p2_svt_lp L=6e-08 W=5.95e-07
MI1_MXNA1_5 Y A XI1_n2__5 VSS nm1p2_svt_lp L=6e-08 W=5.95e-07
MI1_MXNA2_5 XI1_n2__5 B XI1_n1 VSS nm1p2_svt_lp L=6e-08 W=5.95e-07
MI1_MXNA2 XI1_n2 B XI1_n1 VSS nm1p2_svt_lp L=6e-08 W=5.95e-07
MI1_MXNA1 Y A XI1_n2 VSS nm1p2_svt_lp L=6e-08 W=5.95e-07
MI0_MXPA1 c CN VDD VDD pm1p2_svt_lp L=6e-08 W=4.35e-07
MI0_MXPA1_2 c CN VDD VDD pm1p2_svt_lp L=6e-08 W=4.35e-07
MI1_MXPA3 Y c VDD VDD pm1p2_svt_lp L=6e-08 W=3.65e-07
MI1_MXPA3_2 Y c VDD VDD pm1p2_svt_lp L=6e-08 W=3.65e-07
MI1_MXPA3_3 Y c VDD VDD pm1p2_svt_lp L=6e-08 W=3.65e-07
MI1_MXPA3_4 Y c VDD VDD pm1p2_svt_lp L=6e-08 W=3.65e-07
MI1_MXPA3_5 Y c VDD VDD pm1p2_svt_lp L=6e-08 W=3.65e-07
MI1_MXPA2 Y B VDD VDD pm1p2_svt_lp L=6e-08 W=3.65e-07
MI1_MXPA1 Y A VDD VDD pm1p2_svt_lp L=6e-08 W=3.65e-07
MI1_MXPA1_2 Y A VDD VDD pm1p2_svt_lp L=6e-08 W=3.65e-07
MI1_MXPA2_2 Y B VDD VDD pm1p2_svt_lp L=6e-08 W=3.65e-07
MI1_MXPA2_3 Y B VDD VDD pm1p2_svt_lp L=6e-08 W=3.65e-07
MI1_MXPA1_3 Y A VDD VDD pm1p2_svt_lp L=6e-08 W=3.65e-07
MI1_MXPA1_4 Y A VDD VDD pm1p2_svt_lp L=6e-08 W=3.65e-07
MI1_MXPA2_4 Y B VDD VDD pm1p2_svt_lp L=6e-08 W=3.65e-07
MI1_MXPA2_5 Y B VDD VDD pm1p2_svt_lp L=6e-08 W=3.65e-07
MI1_MXPA1_5 Y A VDD VDD pm1p2_svt_lp L=6e-08 W=3.65e-07
.ENDS

.SUBCKT NAND4X0P5H9R Y VDD VSS A B C D
MI0_MXNA4 XI0_n1 D VSS VSS nm1p2_svt_lp L=6e-08 W=3.15e-07
MI0_MXNA3 XI0_n2 C XI0_n1 VSS nm1p2_svt_lp L=6e-08 W=3.15e-07
MI0_MXNA2 XI0_n3 B XI0_n2 VSS nm1p2_svt_lp L=6e-08 W=3.15e-07
MI0_MXNA1 Y A XI0_n3 VSS nm1p2_svt_lp L=6e-08 W=3.15e-07
MI0_MXPA4 Y D VDD VDD pm1p2_svt_lp L=6e-08 W=1.5e-07
MI0_MXPA3 Y C VDD VDD pm1p2_svt_lp L=6e-08 W=1.5e-07
MI0_MXPA2 Y B VDD VDD pm1p2_svt_lp L=6e-08 W=1.5e-07
MI0_MXPA1 Y A VDD VDD pm1p2_svt_lp L=6e-08 W=1.5e-07
.ENDS

.SUBCKT NAND4X0P7H9R Y VDD VSS A B C D
MI0_MXNA4 XI0_n1 D VSS VSS nm1p2_svt_lp L=6e-08 W=3.5e-07
MI0_MXNA3 XI0_n2 C XI0_n1 VSS nm1p2_svt_lp L=6e-08 W=3.5e-07
MI0_MXNA2 XI0_n3 B XI0_n2 VSS nm1p2_svt_lp L=6e-08 W=3.5e-07
MI0_MXNA1 Y A XI0_n3 VSS nm1p2_svt_lp L=6e-08 W=3.5e-07
MI0_MXPA4 Y D VDD VDD pm1p2_svt_lp L=6e-08 W=1.7e-07
MI0_MXPA3 Y C VDD VDD pm1p2_svt_lp L=6e-08 W=1.7e-07
MI0_MXPA2 Y B VDD VDD pm1p2_svt_lp L=6e-08 W=1.7e-07
MI0_MXPA1 Y A VDD VDD pm1p2_svt_lp L=6e-08 W=1.7e-07
.ENDS

.SUBCKT NAND4X1H9R Y VDD VSS A B C D
MI0_MXNA4 XI0_n1 D VSS VSS nm1p2_svt_lp L=6e-08 W=4.95e-07
MI0_MXNA3 XI0_n2 C XI0_n1 VSS nm1p2_svt_lp L=6e-08 W=4.95e-07
MI0_MXNA2 XI0_n3 B XI0_n2 VSS nm1p2_svt_lp L=6e-08 W=4.95e-07
MI0_MXNA1 Y A XI0_n3 VSS nm1p2_svt_lp L=6e-08 W=4.95e-07
MI0_MXPA4 Y D VDD VDD pm1p2_svt_lp L=6e-08 W=2.35e-07
MI0_MXPA3 Y C VDD VDD pm1p2_svt_lp L=6e-08 W=2.35e-07
MI0_MXPA2 Y B VDD VDD pm1p2_svt_lp L=6e-08 W=2.35e-07
MI0_MXPA1 Y A VDD VDD pm1p2_svt_lp L=6e-08 W=2.35e-07
.ENDS

.SUBCKT NAND4X1P4H9R Y VDD VSS A B C D
MI0_MXNA4 XI0_n1 D VSS VSS nm1p2_svt_lp L=6e-08 W=7e-07
MI0_MXNA3 XI0_n2 C XI0_n1 VSS nm1p2_svt_lp L=6e-08 W=7e-07
MI0_MXNA2 XI0_n3 B XI0_n2 VSS nm1p2_svt_lp L=6e-08 W=7e-07
MI0_MXNA1 Y A XI0_n3 VSS nm1p2_svt_lp L=6e-08 W=7e-07
MI0_MXPA4 Y D VDD VDD pm1p2_svt_lp L=6e-08 W=3.4e-07
MI0_MXPA3 Y C VDD VDD pm1p2_svt_lp L=6e-08 W=3.4e-07
MI0_MXPA2 Y B VDD VDD pm1p2_svt_lp L=6e-08 W=3.4e-07
MI0_MXPA1 Y A VDD VDD pm1p2_svt_lp L=6e-08 W=3.4e-07
.ENDS

.SUBCKT NAND4X2H9R Y VDD VSS A B C D
MI0_MXNA3_2 XI0_n2 C XI0_n1__2 VSS nm1p2_svt_lp L=6e-08 W=4.95e-07
MI0_MXNA4_2 XI0_n1__2 D VSS VSS nm1p2_svt_lp L=6e-08 W=4.95e-07
MI0_MXNA4 XI0_n1 D VSS VSS nm1p2_svt_lp L=6e-08 W=4.95e-07
MI0_MXNA3 XI0_n2 C XI0_n1 VSS nm1p2_svt_lp L=6e-08 W=4.95e-07
MI0_MXNA2_2 XI0_n3__2 B XI0_n2 VSS nm1p2_svt_lp L=6e-08 W=4.95e-07
MI0_MXNA1_2 Y A XI0_n3__2 VSS nm1p2_svt_lp L=6e-08 W=4.95e-07
MI0_MXNA1 Y A XI0_n3 VSS nm1p2_svt_lp L=6e-08 W=4.95e-07
MI0_MXNA2 XI0_n3 B XI0_n2 VSS nm1p2_svt_lp L=6e-08 W=4.95e-07
MI0_MXPA3 Y C VDD VDD pm1p2_svt_lp L=6e-08 W=4.7e-07
MI0_MXPA4 Y D VDD VDD pm1p2_svt_lp L=6e-08 W=4.7e-07
MI0_MXPA2 Y B VDD VDD pm1p2_svt_lp L=6e-08 W=4.7e-07
MI0_MXPA1 Y A VDD VDD pm1p2_svt_lp L=6e-08 W=4.7e-07
.ENDS

.SUBCKT NAND4X3H9R Y VDD VSS A B C D
MI0_MXNA4_2 XI0_n1__2 D VSS VSS nm1p2_svt_lp L=6e-08 W=4.95e-07
MI0_MXNA3_2 XI0_n2 C XI0_n1__2 VSS nm1p2_svt_lp L=6e-08 W=4.95e-07
MI0_MXNA3_3 XI0_n2 C XI0_n1__3 VSS nm1p2_svt_lp L=6e-08 W=4.95e-07
MI0_MXNA4_3 XI0_n1__3 D VSS VSS nm1p2_svt_lp L=6e-08 W=4.95e-07
MI0_MXNA4 XI0_n1 D VSS VSS nm1p2_svt_lp L=6e-08 W=4.95e-07
MI0_MXNA3 XI0_n2 C XI0_n1 VSS nm1p2_svt_lp L=6e-08 W=4.95e-07
MI0_MXNA2_2 XI0_n3__2 B XI0_n2 VSS nm1p2_svt_lp L=6e-08 W=4.95e-07
MI0_MXNA1_2 Y A XI0_n3__2 VSS nm1p2_svt_lp L=6e-08 W=4.95e-07
MI0_MXNA1_3 Y A XI0_n3__3 VSS nm1p2_svt_lp L=6e-08 W=4.95e-07
MI0_MXNA2_3 XI0_n3__3 B XI0_n2 VSS nm1p2_svt_lp L=6e-08 W=4.95e-07
MI0_MXNA2 XI0_n3 B XI0_n2 VSS nm1p2_svt_lp L=6e-08 W=4.95e-07
MI0_MXNA1 Y A XI0_n3 VSS nm1p2_svt_lp L=6e-08 W=4.95e-07
MI0_MXPA4 Y D VDD VDD pm1p2_svt_lp L=6e-08 W=3.55e-07
MI0_MXPA3 Y C VDD VDD pm1p2_svt_lp L=6e-08 W=3.55e-07
MI0_MXPA3_2 Y C VDD VDD pm1p2_svt_lp L=6e-08 W=3.55e-07
MI0_MXPA4_2 Y D VDD VDD pm1p2_svt_lp L=6e-08 W=3.55e-07
MI0_MXPA2 Y B VDD VDD pm1p2_svt_lp L=6e-08 W=3.55e-07
MI0_MXPA1 Y A VDD VDD pm1p2_svt_lp L=6e-08 W=3.55e-07
MI0_MXPA1_2 Y A VDD VDD pm1p2_svt_lp L=6e-08 W=3.55e-07
MI0_MXPA2_2 Y B VDD VDD pm1p2_svt_lp L=6e-08 W=3.55e-07
.ENDS

.SUBCKT NAND4X4H9R Y VDD VSS A B C D
MI0_MXNA3_2 XI0_n2 C XI0_n1__2 VSS nm1p2_svt_lp L=6e-08 W=4.95e-07
MI0_MXNA4_2 XI0_n1__2 D VSS VSS nm1p2_svt_lp L=6e-08 W=4.95e-07
MI0_MXNA4_3 XI0_n1__3 D VSS VSS nm1p2_svt_lp L=6e-08 W=4.95e-07
MI0_MXNA3_3 XI0_n2 C XI0_n1__3 VSS nm1p2_svt_lp L=6e-08 W=4.95e-07
MI0_MXNA3_4 XI0_n2 C XI0_n1__4 VSS nm1p2_svt_lp L=6e-08 W=4.95e-07
MI0_MXNA4_4 XI0_n1__4 D VSS VSS nm1p2_svt_lp L=6e-08 W=4.95e-07
MI0_MXNA4 XI0_n1 D VSS VSS nm1p2_svt_lp L=6e-08 W=4.95e-07
MI0_MXNA3 XI0_n2 C XI0_n1 VSS nm1p2_svt_lp L=6e-08 W=4.95e-07
MI0_MXNA2_2 XI0_n3__2 B XI0_n2 VSS nm1p2_svt_lp L=6e-08 W=4.95e-07
MI0_MXNA1_2 Y A XI0_n3__2 VSS nm1p2_svt_lp L=6e-08 W=4.95e-07
MI0_MXNA1_3 Y A XI0_n3__3 VSS nm1p2_svt_lp L=6e-08 W=4.95e-07
MI0_MXNA2_3 XI0_n3__3 B XI0_n2 VSS nm1p2_svt_lp L=6e-08 W=4.95e-07
MI0_MXNA2_4 XI0_n3__4 B XI0_n2 VSS nm1p2_svt_lp L=6e-08 W=4.95e-07
MI0_MXNA1_4 Y A XI0_n3__4 VSS nm1p2_svt_lp L=6e-08 W=4.95e-07
MI0_MXNA1 Y A XI0_n3 VSS nm1p2_svt_lp L=6e-08 W=4.95e-07
MI0_MXNA2 XI0_n3 B XI0_n2 VSS nm1p2_svt_lp L=6e-08 W=4.95e-07
MI0_MXPA3 Y C VDD VDD pm1p2_svt_lp L=6e-08 W=4.7e-07
MI0_MXPA4 Y D VDD VDD pm1p2_svt_lp L=6e-08 W=4.7e-07
MI0_MXPA4_2 Y D VDD VDD pm1p2_svt_lp L=6e-08 W=4.7e-07
MI0_MXPA3_2 Y C VDD VDD pm1p2_svt_lp L=6e-08 W=4.7e-07
MI0_MXPA2 Y B VDD VDD pm1p2_svt_lp L=6e-08 W=4.7e-07
MI0_MXPA1 Y A VDD VDD pm1p2_svt_lp L=6e-08 W=4.7e-07
MI0_MXPA1_2 Y A VDD VDD pm1p2_svt_lp L=6e-08 W=4.7e-07
MI0_MXPA2_2 Y B VDD VDD pm1p2_svt_lp L=6e-08 W=4.7e-07
.ENDS

.SUBCKT NAND4BX0P5H9R Y VDD VSS AN B C D
MI0_MXNA1 a AN VSS VSS nm1p2_svt_lp L=6e-08 W=1.5e-07
MI1_MXNA4 XI1_n1 D VSS VSS nm1p2_svt_lp L=6e-08 W=3.15e-07
MI1_MXNA3 XI1_n2 C XI1_n1 VSS nm1p2_svt_lp L=6e-08 W=3.15e-07
MI1_MXNA2 XI1_n3 B XI1_n2 VSS nm1p2_svt_lp L=6e-08 W=3.15e-07
MI1_MXNA1 Y a XI1_n3 VSS nm1p2_svt_lp L=6e-08 W=3.15e-07
MI0_MXPA1 a AN VDD VDD pm1p2_svt_lp L=6e-08 W=2.1e-07
MI1_MXPA4 Y D VDD VDD pm1p2_svt_lp L=6e-08 W=1.5e-07
MI1_MXPA3 Y C VDD VDD pm1p2_svt_lp L=6e-08 W=1.5e-07
MI1_MXPA2 Y B VDD VDD pm1p2_svt_lp L=6e-08 W=1.5e-07
MI1_MXPA1 Y a VDD VDD pm1p2_svt_lp L=6e-08 W=1.5e-07
.ENDS

.SUBCKT NAND4BX0P7H9R Y VDD VSS AN B C D
MI0_MXNA1 a AN VSS VSS nm1p2_svt_lp L=6e-08 W=1.5e-07
MI1_MXNA4 XI1_n1 D VSS VSS nm1p2_svt_lp L=6e-08 W=3.5e-07
MI1_MXNA3 XI1_n2 C XI1_n1 VSS nm1p2_svt_lp L=6e-08 W=3.5e-07
MI1_MXNA2 XI1_n3 B XI1_n2 VSS nm1p2_svt_lp L=6e-08 W=3.5e-07
MI1_MXNA1 Y a XI1_n3 VSS nm1p2_svt_lp L=6e-08 W=3.5e-07
MI0_MXPA1 a AN VDD VDD pm1p2_svt_lp L=6e-08 W=2.1e-07
MI1_MXPA4 Y D VDD VDD pm1p2_svt_lp L=6e-08 W=1.7e-07
MI1_MXPA3 Y C VDD VDD pm1p2_svt_lp L=6e-08 W=1.7e-07
MI1_MXPA2 Y B VDD VDD pm1p2_svt_lp L=6e-08 W=1.7e-07
MI1_MXPA1 Y a VDD VDD pm1p2_svt_lp L=6e-08 W=1.7e-07
.ENDS

.SUBCKT NAND4BX1H9R Y VDD VSS AN B C D
MI0_MXNA1 a AN VSS VSS nm1p2_svt_lp L=6e-08 W=1.5e-07
MI1_MXNA4 XI1_n1 D VSS VSS nm1p2_svt_lp L=6e-08 W=4.95e-07
MI1_MXNA3 XI1_n2 C XI1_n1 VSS nm1p2_svt_lp L=6e-08 W=4.95e-07
MI1_MXNA2 XI1_n3 B XI1_n2 VSS nm1p2_svt_lp L=6e-08 W=4.95e-07
MI1_MXNA1 Y a XI1_n3 VSS nm1p2_svt_lp L=6e-08 W=4.95e-07
MI0_MXPA1 a AN VDD VDD pm1p2_svt_lp L=6e-08 W=2.1e-07
MI1_MXPA4 Y D VDD VDD pm1p2_svt_lp L=6e-08 W=2.35e-07
MI1_MXPA3 Y C VDD VDD pm1p2_svt_lp L=6e-08 W=2.35e-07
MI1_MXPA2 Y B VDD VDD pm1p2_svt_lp L=6e-08 W=2.35e-07
MI1_MXPA1 Y a VDD VDD pm1p2_svt_lp L=6e-08 W=2.35e-07
.ENDS

.SUBCKT NAND4BX1P4H9R Y VDD VSS AN B C D
MI0_MXNA1 a AN VSS VSS nm1p2_svt_lp L=6e-08 W=1.6e-07
MI1_MXNA4 XI1_n1 D VSS VSS nm1p2_svt_lp L=6e-08 W=7e-07
MI1_MXNA3 XI1_n2 C XI1_n1 VSS nm1p2_svt_lp L=6e-08 W=7e-07
MI1_MXNA2 XI1_n3 B XI1_n2 VSS nm1p2_svt_lp L=6e-08 W=7e-07
MI1_MXNA1 Y a XI1_n3 VSS nm1p2_svt_lp L=6e-08 W=7e-07
MI0_MXPA1 a AN VDD VDD pm1p2_svt_lp L=6e-08 W=2.3e-07
MI1_MXPA4 Y D VDD VDD pm1p2_svt_lp L=6e-08 W=3.4e-07
MI1_MXPA3 Y C VDD VDD pm1p2_svt_lp L=6e-08 W=3.4e-07
MI1_MXPA2 Y B VDD VDD pm1p2_svt_lp L=6e-08 W=3.4e-07
MI1_MXPA1 Y a VDD VDD pm1p2_svt_lp L=6e-08 W=3.4e-07
.ENDS

.SUBCKT NAND4BX2H9R Y VDD VSS AN B C D
MI0_MXNA1 a AN VSS VSS nm1p2_svt_lp L=6e-08 W=2.05e-07
MI1_MXNA2_2 XI1_n3__2 B XI1_n2 VSS nm1p2_svt_lp L=6e-08 W=4.95e-07
MI1_MXNA1_2 Y a XI1_n3__2 VSS nm1p2_svt_lp L=6e-08 W=4.95e-07
MI1_MXNA1 Y a XI1_n3 VSS nm1p2_svt_lp L=6e-08 W=4.95e-07
MI1_MXNA2 XI1_n3 B XI1_n2 VSS nm1p2_svt_lp L=6e-08 W=4.95e-07
MI1_MXNA3_2 XI1_n2 C XI1_n1__2 VSS nm1p2_svt_lp L=6e-08 W=4.95e-07
MI1_MXNA4_2 XI1_n1__2 D VSS VSS nm1p2_svt_lp L=6e-08 W=4.95e-07
MI1_MXNA4 XI1_n1 D VSS VSS nm1p2_svt_lp L=6e-08 W=4.95e-07
MI1_MXNA3 XI1_n2 C XI1_n1 VSS nm1p2_svt_lp L=6e-08 W=4.95e-07
MI0_MXPA1 a AN VDD VDD pm1p2_svt_lp L=6e-08 W=2.9e-07
MI1_MXPA2 Y B VDD VDD pm1p2_svt_lp L=6e-08 W=2.35e-07
MI1_MXPA1 Y a VDD VDD pm1p2_svt_lp L=6e-08 W=2.35e-07
MI1_MXPA1_2 Y a VDD VDD pm1p2_svt_lp L=6e-08 W=2.35e-07
MI1_MXPA2_2 Y B VDD VDD pm1p2_svt_lp L=6e-08 W=2.35e-07
MI1_MXPA3 Y C VDD VDD pm1p2_svt_lp L=6e-08 W=2.35e-07
MI1_MXPA4 Y D VDD VDD pm1p2_svt_lp L=6e-08 W=2.35e-07
MI1_MXPA4_2 Y D VDD VDD pm1p2_svt_lp L=6e-08 W=2.35e-07
MI1_MXPA3_2 Y C VDD VDD pm1p2_svt_lp L=6e-08 W=2.35e-07
.ENDS

.SUBCKT NAND4BX3H9R Y VDD VSS AN B C D
MI0_MXNA1 a AN VSS VSS nm1p2_svt_lp L=6e-08 W=2.95e-07
MI1_MXNA4_2 XI1_n1__2 D VSS VSS nm1p2_svt_lp L=6e-08 W=4.95e-07
MI1_MXNA3_2 XI1_n2 C XI1_n1__2 VSS nm1p2_svt_lp L=6e-08 W=4.95e-07
MI1_MXNA3_3 XI1_n2 C XI1_n1__3 VSS nm1p2_svt_lp L=6e-08 W=4.95e-07
MI1_MXNA4_3 XI1_n1__3 D VSS VSS nm1p2_svt_lp L=6e-08 W=4.95e-07
MI1_MXNA4 XI1_n1 D VSS VSS nm1p2_svt_lp L=6e-08 W=4.95e-07
MI1_MXNA3 XI1_n2 C XI1_n1 VSS nm1p2_svt_lp L=6e-08 W=4.95e-07
MI1_MXNA2_2 XI1_n3__2 B XI1_n2 VSS nm1p2_svt_lp L=6e-08 W=4.95e-07
MI1_MXNA1_2 Y a XI1_n3__2 VSS nm1p2_svt_lp L=6e-08 W=4.95e-07
MI1_MXNA1_3 Y a XI1_n3__3 VSS nm1p2_svt_lp L=6e-08 W=4.95e-07
MI1_MXNA2_3 XI1_n3__3 B XI1_n2 VSS nm1p2_svt_lp L=6e-08 W=4.95e-07
MI1_MXNA2 XI1_n3 B XI1_n2 VSS nm1p2_svt_lp L=6e-08 W=4.95e-07
MI1_MXNA1 Y a XI1_n3 VSS nm1p2_svt_lp L=6e-08 W=4.95e-07
MI0_MXPA1 a AN VDD VDD pm1p2_svt_lp L=6e-08 W=4.1e-07
MI1_MXPA4 Y D VDD VDD pm1p2_svt_lp L=6e-08 W=3.55e-07
MI1_MXPA3 Y C VDD VDD pm1p2_svt_lp L=6e-08 W=3.55e-07
MI1_MXPA3_2 Y C VDD VDD pm1p2_svt_lp L=6e-08 W=3.55e-07
MI1_MXPA4_2 Y D VDD VDD pm1p2_svt_lp L=6e-08 W=3.55e-07
MI1_MXPA2 Y B VDD VDD pm1p2_svt_lp L=6e-08 W=3.55e-07
MI1_MXPA1 Y a VDD VDD pm1p2_svt_lp L=6e-08 W=3.55e-07
MI1_MXPA1_2 Y a VDD VDD pm1p2_svt_lp L=6e-08 W=3.55e-07
MI1_MXPA2_2 Y B VDD VDD pm1p2_svt_lp L=6e-08 W=3.55e-07
.ENDS

.SUBCKT NAND4BX4H9R Y VDD VSS AN B C D
MI0_MXNA1 a AN VSS VSS nm1p2_svt_lp L=6e-08 W=1.95e-07
MI0_MXNA1_2 a AN VSS VSS nm1p2_svt_lp L=6e-08 W=1.95e-07
MI1_MXNA4_2 XI1_n1__2 D VSS VSS nm1p2_svt_lp L=6e-08 W=6.6e-07
MI1_MXNA3_2 XI1_n2 C XI1_n1__2 VSS nm1p2_svt_lp L=6e-08 W=6.6e-07
MI1_MXNA3_3 XI1_n2 C XI1_n1__3 VSS nm1p2_svt_lp L=6e-08 W=6.6e-07
MI1_MXNA4_3 XI1_n1__3 D VSS VSS nm1p2_svt_lp L=6e-08 W=6.6e-07
MI1_MXNA4 XI1_n1 D VSS VSS nm1p2_svt_lp L=6e-08 W=6.6e-07
MI1_MXNA3 XI1_n2 C XI1_n1 VSS nm1p2_svt_lp L=6e-08 W=6.6e-07
MI1_MXNA2_2 XI1_n3__2 B XI1_n2 VSS nm1p2_svt_lp L=6e-08 W=6.6e-07
MI1_MXNA1_2 Y a XI1_n3__2 VSS nm1p2_svt_lp L=6e-08 W=6.6e-07
MI1_MXNA1_3 Y a XI1_n3__3 VSS nm1p2_svt_lp L=6e-08 W=6.6e-07
MI1_MXNA2_3 XI1_n3__3 B XI1_n2 VSS nm1p2_svt_lp L=6e-08 W=6.6e-07
MI1_MXNA2 XI1_n3 B XI1_n2 VSS nm1p2_svt_lp L=6e-08 W=6.6e-07
MI1_MXNA1 Y a XI1_n3 VSS nm1p2_svt_lp L=6e-08 W=6.6e-07
MI0_MXPA1 a AN VDD VDD pm1p2_svt_lp L=6e-08 W=2.7e-07
MI0_MXPA1_2 a AN VDD VDD pm1p2_svt_lp L=6e-08 W=2.7e-07
MI1_MXPA4 Y D VDD VDD pm1p2_svt_lp L=6e-08 W=3.15e-07
MI1_MXPA3 Y C VDD VDD pm1p2_svt_lp L=6e-08 W=3.15e-07
MI1_MXPA3_2 Y C VDD VDD pm1p2_svt_lp L=6e-08 W=3.15e-07
MI1_MXPA4_2 Y D VDD VDD pm1p2_svt_lp L=6e-08 W=3.15e-07
MI1_MXPA4_3 Y D VDD VDD pm1p2_svt_lp L=6e-08 W=3.15e-07
MI1_MXPA3_3 Y C VDD VDD pm1p2_svt_lp L=6e-08 W=3.15e-07
MI1_MXPA2 Y B VDD VDD pm1p2_svt_lp L=6e-08 W=3.15e-07
MI1_MXPA1 Y a VDD VDD pm1p2_svt_lp L=6e-08 W=3.15e-07
MI1_MXPA1_2 Y a VDD VDD pm1p2_svt_lp L=6e-08 W=3.15e-07
MI1_MXPA2_2 Y B VDD VDD pm1p2_svt_lp L=6e-08 W=3.15e-07
MI1_MXPA2_3 Y B VDD VDD pm1p2_svt_lp L=6e-08 W=3.15e-07
MI1_MXPA1_3 Y a VDD VDD pm1p2_svt_lp L=6e-08 W=3.15e-07
.ENDS

.SUBCKT NAND4XXXBX0P5H9R Y VDD VSS A B C DN
MI0_MXNA1 d DN VSS VSS nm1p2_svt_lp L=6e-08 W=1.5e-07
MI1_MXNA4 XI1_n1 d VSS VSS nm1p2_svt_lp L=6e-08 W=3.15e-07
MI1_MXNA3 XI1_n2 C XI1_n1 VSS nm1p2_svt_lp L=6e-08 W=3.15e-07
MI1_MXNA2 XI1_n3 B XI1_n2 VSS nm1p2_svt_lp L=6e-08 W=3.15e-07
MI1_MXNA1 Y A XI1_n3 VSS nm1p2_svt_lp L=6e-08 W=3.15e-07
MI0_MXPA1 d DN VDD VDD pm1p2_svt_lp L=6e-08 W=2.1e-07
MI1_MXPA4 Y d VDD VDD pm1p2_svt_lp L=6e-08 W=1.5e-07
MI1_MXPA3 Y C VDD VDD pm1p2_svt_lp L=6e-08 W=1.5e-07
MI1_MXPA2 Y B VDD VDD pm1p2_svt_lp L=6e-08 W=1.5e-07
MI1_MXPA1 Y A VDD VDD pm1p2_svt_lp L=6e-08 W=1.5e-07
.ENDS

.SUBCKT NAND4XXXBX0P7H9R Y VDD VSS A B C DN
MI0_MXNA1 d DN VSS VSS nm1p2_svt_lp L=6e-08 W=1.5e-07
MI1_MXNA4 XI1_n1 d VSS VSS nm1p2_svt_lp L=6e-08 W=3.5e-07
MI1_MXNA3 XI1_n2 C XI1_n1 VSS nm1p2_svt_lp L=6e-08 W=3.5e-07
MI1_MXNA2 XI1_n3 B XI1_n2 VSS nm1p2_svt_lp L=6e-08 W=3.5e-07
MI1_MXNA1 Y A XI1_n3 VSS nm1p2_svt_lp L=6e-08 W=3.5e-07
MI0_MXPA1 d DN VDD VDD pm1p2_svt_lp L=6e-08 W=2.1e-07
MI1_MXPA4 Y d VDD VDD pm1p2_svt_lp L=6e-08 W=1.7e-07
MI1_MXPA3 Y C VDD VDD pm1p2_svt_lp L=6e-08 W=1.7e-07
MI1_MXPA2 Y B VDD VDD pm1p2_svt_lp L=6e-08 W=1.7e-07
MI1_MXPA1 Y A VDD VDD pm1p2_svt_lp L=6e-08 W=1.7e-07
.ENDS

.SUBCKT NAND4XXXBX1H9R Y VDD VSS A B C DN
MI0_MXNA1 d DN VSS VSS nm1p2_svt_lp L=6e-08 W=1.5e-07
MI1_MXNA4 XI1_n1 d VSS VSS nm1p2_svt_lp L=6e-08 W=4.95e-07
MI1_MXNA3 XI1_n2 C XI1_n1 VSS nm1p2_svt_lp L=6e-08 W=4.95e-07
MI1_MXNA2 XI1_n3 B XI1_n2 VSS nm1p2_svt_lp L=6e-08 W=4.95e-07
MI1_MXNA1 Y A XI1_n3 VSS nm1p2_svt_lp L=6e-08 W=4.95e-07
MI0_MXPA1 d DN VDD VDD pm1p2_svt_lp L=6e-08 W=2.1e-07
MI1_MXPA4 Y d VDD VDD pm1p2_svt_lp L=6e-08 W=2.35e-07
MI1_MXPA3 Y C VDD VDD pm1p2_svt_lp L=6e-08 W=2.35e-07
MI1_MXPA2 Y B VDD VDD pm1p2_svt_lp L=6e-08 W=2.35e-07
MI1_MXPA1 Y A VDD VDD pm1p2_svt_lp L=6e-08 W=2.35e-07
.ENDS

.SUBCKT NAND4XXXBX1P4H9R Y VDD VSS A B C DN
MI0_MXNA1 d DN VSS VSS nm1p2_svt_lp L=6e-08 W=1.6e-07
MI1_MXNA4 XI1_n1 d VSS VSS nm1p2_svt_lp L=6e-08 W=7e-07
MI1_MXNA3 XI1_n2 C XI1_n1 VSS nm1p2_svt_lp L=6e-08 W=7e-07
MI1_MXNA2 XI1_n3 B XI1_n2 VSS nm1p2_svt_lp L=6e-08 W=7e-07
MI1_MXNA1 Y A XI1_n3 VSS nm1p2_svt_lp L=6e-08 W=7e-07
MI0_MXPA1 d DN VDD VDD pm1p2_svt_lp L=6e-08 W=2.3e-07
MI1_MXPA4 Y d VDD VDD pm1p2_svt_lp L=6e-08 W=3.4e-07
MI1_MXPA3 Y C VDD VDD pm1p2_svt_lp L=6e-08 W=3.4e-07
MI1_MXPA2 Y B VDD VDD pm1p2_svt_lp L=6e-08 W=3.4e-07
MI1_MXPA1 Y A VDD VDD pm1p2_svt_lp L=6e-08 W=3.4e-07
.ENDS

.SUBCKT NAND4XXXBX2H9R Y VDD VSS A B C DN
MI0_MXNA1 d DN VSS VSS nm1p2_svt_lp L=6e-08 W=2.05e-07
MI1_MXNA3_2 XI1_n2 C XI1_n1__2 VSS nm1p2_svt_lp L=6e-08 W=4.95e-07
MI1_MXNA4_2 XI1_n1__2 d VSS VSS nm1p2_svt_lp L=6e-08 W=4.95e-07
MI1_MXNA4 XI1_n1 d VSS VSS nm1p2_svt_lp L=6e-08 W=4.95e-07
MI1_MXNA3 XI1_n2 C XI1_n1 VSS nm1p2_svt_lp L=6e-08 W=4.95e-07
MI1_MXNA2_2 XI1_n3__2 B XI1_n2 VSS nm1p2_svt_lp L=6e-08 W=4.95e-07
MI1_MXNA1_2 Y A XI1_n3__2 VSS nm1p2_svt_lp L=6e-08 W=4.95e-07
MI1_MXNA1 Y A XI1_n3 VSS nm1p2_svt_lp L=6e-08 W=4.95e-07
MI1_MXNA2 XI1_n3 B XI1_n2 VSS nm1p2_svt_lp L=6e-08 W=4.95e-07
MI0_MXPA1 d DN VDD VDD pm1p2_svt_lp L=6e-08 W=2.9e-07
MI1_MXPA3 Y C VDD VDD pm1p2_svt_lp L=6e-08 W=4.7e-07
MI1_MXPA4 Y d VDD VDD pm1p2_svt_lp L=6e-08 W=4.7e-07
MI1_MXPA2 Y B VDD VDD pm1p2_svt_lp L=6e-08 W=4.7e-07
MI1_MXPA1 Y A VDD VDD pm1p2_svt_lp L=6e-08 W=4.7e-07
.ENDS

.SUBCKT NAND4XXXBX3H9R Y VDD VSS A B C DN
MI0_MXNA1 d DN VSS VSS nm1p2_svt_lp L=6e-08 W=2.95e-07
MI1_MXNA4_2 XI1_n1__2 d VSS VSS nm1p2_svt_lp L=6e-08 W=4.95e-07
MI1_MXNA3_2 XI1_n2 C XI1_n1__2 VSS nm1p2_svt_lp L=6e-08 W=4.95e-07
MI1_MXNA3_3 XI1_n2 C XI1_n1__3 VSS nm1p2_svt_lp L=6e-08 W=4.95e-07
MI1_MXNA4_3 XI1_n1__3 d VSS VSS nm1p2_svt_lp L=6e-08 W=4.95e-07
MI1_MXNA4 XI1_n1 d VSS VSS nm1p2_svt_lp L=6e-08 W=4.95e-07
MI1_MXNA3 XI1_n2 C XI1_n1 VSS nm1p2_svt_lp L=6e-08 W=4.95e-07
MI1_MXNA2_2 XI1_n3__2 B XI1_n2 VSS nm1p2_svt_lp L=6e-08 W=4.95e-07
MI1_MXNA1_2 Y A XI1_n3__2 VSS nm1p2_svt_lp L=6e-08 W=4.95e-07
MI1_MXNA1_3 Y A XI1_n3__3 VSS nm1p2_svt_lp L=6e-08 W=4.95e-07
MI1_MXNA2_3 XI1_n3__3 B XI1_n2 VSS nm1p2_svt_lp L=6e-08 W=4.95e-07
MI1_MXNA2 XI1_n3 B XI1_n2 VSS nm1p2_svt_lp L=6e-08 W=4.95e-07
MI1_MXNA1 Y A XI1_n3 VSS nm1p2_svt_lp L=6e-08 W=4.95e-07
MI0_MXPA1 d DN VDD VDD pm1p2_svt_lp L=6e-08 W=4.1e-07
MI1_MXPA4 Y d VDD VDD pm1p2_svt_lp L=6e-08 W=3.55e-07
MI1_MXPA3 Y C VDD VDD pm1p2_svt_lp L=6e-08 W=3.55e-07
MI1_MXPA3_2 Y C VDD VDD pm1p2_svt_lp L=6e-08 W=3.55e-07
MI1_MXPA4_2 Y d VDD VDD pm1p2_svt_lp L=6e-08 W=3.55e-07
MI1_MXPA2 Y B VDD VDD pm1p2_svt_lp L=6e-08 W=3.55e-07
MI1_MXPA1 Y A VDD VDD pm1p2_svt_lp L=6e-08 W=3.55e-07
MI1_MXPA1_2 Y A VDD VDD pm1p2_svt_lp L=6e-08 W=3.55e-07
MI1_MXPA2_2 Y B VDD VDD pm1p2_svt_lp L=6e-08 W=3.55e-07
.ENDS

.SUBCKT NAND4XXXBX4H9R Y VDD VSS A B C DN
MI0_MXNA1 d DN VSS VSS nm1p2_svt_lp L=6e-08 W=1.95e-07
MI0_MXNA1_2 d DN VSS VSS nm1p2_svt_lp L=6e-08 W=1.95e-07
MI1_MXNA4_2 XI1_n1__2 d VSS VSS nm1p2_svt_lp L=6e-08 W=6.6e-07
MI1_MXNA3_2 XI1_n2 C XI1_n1__2 VSS nm1p2_svt_lp L=6e-08 W=6.6e-07
MI1_MXNA3_3 XI1_n2 C XI1_n1__3 VSS nm1p2_svt_lp L=6e-08 W=6.6e-07
MI1_MXNA4_3 XI1_n1__3 d VSS VSS nm1p2_svt_lp L=6e-08 W=6.6e-07
MI1_MXNA4 XI1_n1 d VSS VSS nm1p2_svt_lp L=6e-08 W=6.6e-07
MI1_MXNA3 XI1_n2 C XI1_n1 VSS nm1p2_svt_lp L=6e-08 W=6.6e-07
MI1_MXNA2_2 XI1_n3__2 B XI1_n2 VSS nm1p2_svt_lp L=6e-08 W=6.6e-07
MI1_MXNA1_2 Y A XI1_n3__2 VSS nm1p2_svt_lp L=6e-08 W=6.6e-07
MI1_MXNA1_3 Y A XI1_n3__3 VSS nm1p2_svt_lp L=6e-08 W=6.6e-07
MI1_MXNA2_3 XI1_n3__3 B XI1_n2 VSS nm1p2_svt_lp L=6e-08 W=6.6e-07
MI1_MXNA2 XI1_n3 B XI1_n2 VSS nm1p2_svt_lp L=6e-08 W=6.6e-07
MI1_MXNA1 Y A XI1_n3 VSS nm1p2_svt_lp L=6e-08 W=6.6e-07
MI0_MXPA1 d DN VDD VDD pm1p2_svt_lp L=6e-08 W=2.7e-07
MI0_MXPA1_2 d DN VDD VDD pm1p2_svt_lp L=6e-08 W=2.7e-07
MI1_MXPA4 Y d VDD VDD pm1p2_svt_lp L=6e-08 W=3.15e-07
MI1_MXPA3 Y C VDD VDD pm1p2_svt_lp L=6e-08 W=3.15e-07
MI1_MXPA3_2 Y C VDD VDD pm1p2_svt_lp L=6e-08 W=3.15e-07
MI1_MXPA4_2 Y d VDD VDD pm1p2_svt_lp L=6e-08 W=3.15e-07
MI1_MXPA4_3 Y d VDD VDD pm1p2_svt_lp L=6e-08 W=3.15e-07
MI1_MXPA3_3 Y C VDD VDD pm1p2_svt_lp L=6e-08 W=3.15e-07
MI1_MXPA2 Y B VDD VDD pm1p2_svt_lp L=6e-08 W=3.15e-07
MI1_MXPA1 Y A VDD VDD pm1p2_svt_lp L=6e-08 W=3.15e-07
MI1_MXPA1_2 Y A VDD VDD pm1p2_svt_lp L=6e-08 W=3.15e-07
MI1_MXPA2_2 Y B VDD VDD pm1p2_svt_lp L=6e-08 W=3.15e-07
MI1_MXPA2_3 Y B VDD VDD pm1p2_svt_lp L=6e-08 W=3.15e-07
MI1_MXPA1_3 Y A VDD VDD pm1p2_svt_lp L=6e-08 W=3.15e-07
.ENDS

.SUBCKT AND2X0P5H9R Y VDD VSS A B
MI0_MXNA1 ny A XI0_n1 VSS nm1p2_svt_lp L=6e-08 W=1.9e-07
MI0_MXNA2 XI0_n1 B VSS VSS nm1p2_svt_lp L=6e-08 W=1.9e-07
MI1_MXNA1 Y ny VSS VSS nm1p2_svt_lp L=6e-08 W=2.1e-07
MI0_MXPA1 ny A VDD VDD pm1p2_svt_lp L=6e-08 W=1.55e-07
MI0_MXPA2 ny B VDD VDD pm1p2_svt_lp L=6e-08 W=1.55e-07
MI1_MXPA1 Y ny VDD VDD pm1p2_svt_lp L=6e-08 W=2.95e-07
.ENDS

.SUBCKT AND2X0P7H9R Y VDD VSS A B
MI0_MXNA1 ny A XI0_n1 VSS nm1p2_svt_lp L=6e-08 W=2.25e-07
MI0_MXNA2 XI0_n1 B VSS VSS nm1p2_svt_lp L=6e-08 W=2.25e-07
MI1_MXNA1 Y ny VSS VSS nm1p2_svt_lp L=6e-08 W=2.95e-07
MI0_MXPA1 ny A VDD VDD pm1p2_svt_lp L=6e-08 W=1.9e-07
MI0_MXPA2 ny B VDD VDD pm1p2_svt_lp L=6e-08 W=1.9e-07
MI1_MXPA1 Y ny VDD VDD pm1p2_svt_lp L=6e-08 W=4.15e-07
.ENDS

.SUBCKT AND2X1H9R Y VDD VSS A B
MI0_MXNA1 ny A XI0_n1 VSS nm1p2_svt_lp L=6e-08 W=2.8e-07
MI0_MXNA2 XI0_n1 B VSS VSS nm1p2_svt_lp L=6e-08 W=2.8e-07
MI1_MXNA1 Y ny VSS VSS nm1p2_svt_lp L=6e-08 W=4.2e-07
MI0_MXPA1 ny A VDD VDD pm1p2_svt_lp L=6e-08 W=2.35e-07
MI0_MXPA2 ny B VDD VDD pm1p2_svt_lp L=6e-08 W=2.35e-07
MI1_MXPA1 Y ny VDD VDD pm1p2_svt_lp L=6e-08 W=5.85e-07
.ENDS

.SUBCKT AND2X1P4H9R Y VDD VSS A B
MI0_MXNA1 ny A XI0_n1 VSS nm1p2_svt_lp L=6e-08 W=3.75e-07
MI0_MXNA2 XI0_n1 B VSS VSS nm1p2_svt_lp L=6e-08 W=3.75e-07
MI1_MXNA1 Y ny VSS VSS nm1p2_svt_lp L=6e-08 W=2.95e-07
MI1_MXNA1_2 Y ny VSS VSS nm1p2_svt_lp L=6e-08 W=2.95e-07
MI0_MXPA1 ny A VDD VDD pm1p2_svt_lp L=6e-08 W=3.1e-07
MI0_MXPA2 ny B VDD VDD pm1p2_svt_lp L=6e-08 W=3.1e-07
MI1_MXPA1 Y ny VDD VDD pm1p2_svt_lp L=6e-08 W=4.15e-07
MI1_MXPA1_2 Y ny VDD VDD pm1p2_svt_lp L=6e-08 W=4.15e-07
.ENDS

.SUBCKT AND2X2H9R Y VDD VSS A B
MI0_MXNA1 ny A XI0_n1 VSS nm1p2_svt_lp L=6e-08 W=4.85e-07
MI0_MXNA2 XI0_n1 B VSS VSS nm1p2_svt_lp L=6e-08 W=4.85e-07
MI1_MXNA1 Y ny VSS VSS nm1p2_svt_lp L=6e-08 W=4.2e-07
MI1_MXNA1_2 Y ny VSS VSS nm1p2_svt_lp L=6e-08 W=4.2e-07
MI0_MXPA1 ny A VDD VDD pm1p2_svt_lp L=6e-08 W=4e-07
MI0_MXPA2 ny B VDD VDD pm1p2_svt_lp L=6e-08 W=4e-07
MI1_MXPA1 Y ny VDD VDD pm1p2_svt_lp L=6e-08 W=5.85e-07
MI1_MXPA1_2 Y ny VDD VDD pm1p2_svt_lp L=6e-08 W=5.85e-07
.ENDS

.SUBCKT AND2X3H9R Y VDD VSS A B
MI0_MXNA2_2 XI0_n1__2 B VSS VSS nm1p2_svt_lp L=6e-08 W=3.8e-07
MI0_MXNA1_2 ny A XI0_n1__2 VSS nm1p2_svt_lp L=6e-08 W=3.8e-07
MI0_MXNA1 ny A XI0_n1 VSS nm1p2_svt_lp L=6e-08 W=3.8e-07
MI0_MXNA2 XI0_n1 B VSS VSS nm1p2_svt_lp L=6e-08 W=3.8e-07
MI1_MXNA1 Y ny VSS VSS nm1p2_svt_lp L=6e-08 W=4.2e-07
MI1_MXNA1_2 Y ny VSS VSS nm1p2_svt_lp L=6e-08 W=4.2e-07
MI1_MXNA1_3 Y ny VSS VSS nm1p2_svt_lp L=6e-08 W=4.2e-07
MI0_MXPA2 ny B VDD VDD pm1p2_svt_lp L=6e-08 W=3.15e-07
MI0_MXPA1 ny A VDD VDD pm1p2_svt_lp L=6e-08 W=3.15e-07
MI0_MXPA1_2 ny A VDD VDD pm1p2_svt_lp L=6e-08 W=3.15e-07
MI0_MXPA2_2 ny B VDD VDD pm1p2_svt_lp L=6e-08 W=3.15e-07
MI1_MXPA1 Y ny VDD VDD pm1p2_svt_lp L=6e-08 W=5.85e-07
MI1_MXPA1_2 Y ny VDD VDD pm1p2_svt_lp L=6e-08 W=5.85e-07
MI1_MXPA1_3 Y ny VDD VDD pm1p2_svt_lp L=6e-08 W=5.85e-07
.ENDS

.SUBCKT AND2X4H9R Y VDD VSS A B
MI0_MXNA2_2 XI0_n1__2 B VSS VSS nm1p2_svt_lp L=6e-08 W=4.85e-07
MI0_MXNA1_2 ny A XI0_n1__2 VSS nm1p2_svt_lp L=6e-08 W=4.85e-07
MI0_MXNA1 ny A XI0_n1 VSS nm1p2_svt_lp L=6e-08 W=4.85e-07
MI0_MXNA2 XI0_n1 B VSS VSS nm1p2_svt_lp L=6e-08 W=4.85e-07
MI1_MXNA1 Y ny VSS VSS nm1p2_svt_lp L=6e-08 W=4.2e-07
MI1_MXNA1_2 Y ny VSS VSS nm1p2_svt_lp L=6e-08 W=4.2e-07
MI1_MXNA1_3 Y ny VSS VSS nm1p2_svt_lp L=6e-08 W=4.2e-07
MI1_MXNA1_4 Y ny VSS VSS nm1p2_svt_lp L=6e-08 W=4.2e-07
MI0_MXPA2 ny B VDD VDD pm1p2_svt_lp L=6e-08 W=4.05e-07
MI0_MXPA1 ny A VDD VDD pm1p2_svt_lp L=6e-08 W=4.05e-07
MI0_MXPA1_2 ny A VDD VDD pm1p2_svt_lp L=6e-08 W=4.05e-07
MI0_MXPA2_2 ny B VDD VDD pm1p2_svt_lp L=6e-08 W=4.05e-07
MI1_MXPA1 Y ny VDD VDD pm1p2_svt_lp L=6e-08 W=5.85e-07
MI1_MXPA1_2 Y ny VDD VDD pm1p2_svt_lp L=6e-08 W=5.85e-07
MI1_MXPA1_3 Y ny VDD VDD pm1p2_svt_lp L=6e-08 W=5.85e-07
MI1_MXPA1_4 Y ny VDD VDD pm1p2_svt_lp L=6e-08 W=5.85e-07
.ENDS

.SUBCKT AND2X6H9R Y VDD VSS A B
MI0_MXNA1 ny A XI0_n1 VSS nm1p2_svt_lp L=6e-08 W=4.95e-07
MI0_MXNA1_2 ny A XI0_n1 VSS nm1p2_svt_lp L=6e-08 W=4.95e-07
MI0_MXNA1_3 ny A XI0_n1 VSS nm1p2_svt_lp L=6e-08 W=4.95e-07
MI0_MXNA2 XI0_n1 B VSS VSS nm1p2_svt_lp L=6e-08 W=4.95e-07
MI0_MXNA2_2 XI0_n1 B VSS VSS nm1p2_svt_lp L=6e-08 W=4.95e-07
MI0_MXNA2_3 XI0_n1 B VSS VSS nm1p2_svt_lp L=6e-08 W=4.95e-07
MI1_MXNA1 Y ny VSS VSS nm1p2_svt_lp L=6e-08 W=4.2e-07
MI1_MXNA1_2 Y ny VSS VSS nm1p2_svt_lp L=6e-08 W=4.2e-07
MI1_MXNA1_3 Y ny VSS VSS nm1p2_svt_lp L=6e-08 W=4.2e-07
MI1_MXNA1_4 Y ny VSS VSS nm1p2_svt_lp L=6e-08 W=4.2e-07
MI1_MXNA1_5 Y ny VSS VSS nm1p2_svt_lp L=6e-08 W=4.2e-07
MI1_MXNA1_6 Y ny VSS VSS nm1p2_svt_lp L=6e-08 W=4.2e-07
MI0_MXPA1 ny A VDD VDD pm1p2_svt_lp L=6e-08 W=4.1e-07
MI0_MXPA1_2 ny A VDD VDD pm1p2_svt_lp L=6e-08 W=4.1e-07
MI0_MXPA1_3 ny A VDD VDD pm1p2_svt_lp L=6e-08 W=4.1e-07
MI0_MXPA2 ny B VDD VDD pm1p2_svt_lp L=6e-08 W=4.1e-07
MI0_MXPA2_2 ny B VDD VDD pm1p2_svt_lp L=6e-08 W=4.1e-07
MI0_MXPA2_3 ny B VDD VDD pm1p2_svt_lp L=6e-08 W=4.1e-07
MI1_MXPA1 Y ny VDD VDD pm1p2_svt_lp L=6e-08 W=5.85e-07
MI1_MXPA1_2 Y ny VDD VDD pm1p2_svt_lp L=6e-08 W=5.85e-07
MI1_MXPA1_3 Y ny VDD VDD pm1p2_svt_lp L=6e-08 W=5.85e-07
MI1_MXPA1_4 Y ny VDD VDD pm1p2_svt_lp L=6e-08 W=5.85e-07
MI1_MXPA1_5 Y ny VDD VDD pm1p2_svt_lp L=6e-08 W=5.85e-07
MI1_MXPA1_6 Y ny VDD VDD pm1p2_svt_lp L=6e-08 W=5.85e-07
.ENDS

.SUBCKT AND2X8H9R Y VDD VSS A B
MI0_MXNA2_2 XI0_n1__2 B VSS VSS nm1p2_svt_lp L=6e-08 W=4.95e-07
MI0_MXNA1_2 ny A XI0_n1__2 VSS nm1p2_svt_lp L=6e-08 W=4.95e-07
MI0_MXNA1_3 ny A XI0_n1__3 VSS nm1p2_svt_lp L=6e-08 W=4.95e-07
MI0_MXNA2_3 XI0_n1__3 B VSS VSS nm1p2_svt_lp L=6e-08 W=4.95e-07
MI0_MXNA2_4 XI0_n1__4 B VSS VSS nm1p2_svt_lp L=6e-08 W=4.95e-07
MI0_MXNA1_4 ny A XI0_n1__4 VSS nm1p2_svt_lp L=6e-08 W=4.95e-07
MI0_MXNA1 ny A XI0_n1 VSS nm1p2_svt_lp L=6e-08 W=4.95e-07
MI0_MXNA2 XI0_n1 B VSS VSS nm1p2_svt_lp L=6e-08 W=4.95e-07
MI1_MXNA1 Y ny VSS VSS nm1p2_svt_lp L=6e-08 W=4.8e-07
MI1_MXNA1_2 Y ny VSS VSS nm1p2_svt_lp L=6e-08 W=4.8e-07
MI1_MXNA1_3 Y ny VSS VSS nm1p2_svt_lp L=6e-08 W=4.8e-07
MI1_MXNA1_4 Y ny VSS VSS nm1p2_svt_lp L=6e-08 W=4.8e-07
MI1_MXNA1_5 Y ny VSS VSS nm1p2_svt_lp L=6e-08 W=4.8e-07
MI1_MXNA1_6 Y ny VSS VSS nm1p2_svt_lp L=6e-08 W=4.8e-07
MI1_MXNA1_7 Y ny VSS VSS nm1p2_svt_lp L=6e-08 W=4.8e-07
MI0_MXPA1 ny A VDD VDD pm1p2_svt_lp L=6e-08 W=5.5e-07
MI0_MXPA2 ny B VDD VDD pm1p2_svt_lp L=6e-08 W=5.5e-07
MI0_MXPA2_2 ny B VDD VDD pm1p2_svt_lp L=6e-08 W=5.5e-07
MI0_MXPA1_2 ny A VDD VDD pm1p2_svt_lp L=6e-08 W=5.5e-07
MI0_MXPA1_3 ny A VDD VDD pm1p2_svt_lp L=6e-08 W=5.5e-07
MI0_MXPA2_3 ny B VDD VDD pm1p2_svt_lp L=6e-08 W=5.5e-07
MI1_MXPA1 Y ny VDD VDD pm1p2_svt_lp L=6e-08 W=5.85e-07
MI1_MXPA1_2 Y ny VDD VDD pm1p2_svt_lp L=6e-08 W=5.85e-07
MI1_MXPA1_3 Y ny VDD VDD pm1p2_svt_lp L=6e-08 W=5.85e-07
MI1_MXPA1_4 Y ny VDD VDD pm1p2_svt_lp L=6e-08 W=5.85e-07
MI1_MXPA1_5 Y ny VDD VDD pm1p2_svt_lp L=6e-08 W=5.85e-07
MI1_MXPA1_6 Y ny VDD VDD pm1p2_svt_lp L=6e-08 W=5.85e-07
MI1_MXPA1_7 Y ny VDD VDD pm1p2_svt_lp L=6e-08 W=5.85e-07
MI1_MXPA1_8 Y ny VDD VDD pm1p2_svt_lp L=6e-08 W=5.85e-07
.ENDS

.SUBCKT AND2X11H9R Y VDD VSS A B
MI0_MXNA2 XI0_n1 B VSS VSS nm1p2_svt_lp L=6e-08 W=4.6e-07
MI0_MXNA2_2 XI0_n1 B VSS VSS nm1p2_svt_lp L=6e-08 W=4.6e-07
MI0_MXNA2_3 XI0_n1 B VSS VSS nm1p2_svt_lp L=6e-08 W=4.6e-07
MI0_MXNA2_4 XI0_n1 B VSS VSS nm1p2_svt_lp L=6e-08 W=4.6e-07
MI0_MXNA2_5 XI0_n1 B VSS VSS nm1p2_svt_lp L=6e-08 W=4.6e-07
MI0_MXNA2_6 XI0_n1 B VSS VSS nm1p2_svt_lp L=6e-08 W=4.6e-07
MI0_MXNA1 ny A XI0_n1 VSS nm1p2_svt_lp L=6e-08 W=4.6e-07
MI0_MXNA1_2 ny A XI0_n1 VSS nm1p2_svt_lp L=6e-08 W=4.6e-07
MI0_MXNA1_3 ny A XI0_n1 VSS nm1p2_svt_lp L=6e-08 W=4.6e-07
MI0_MXNA1_4 ny A XI0_n1 VSS nm1p2_svt_lp L=6e-08 W=4.6e-07
MI0_MXNA1_5 ny A XI0_n1 VSS nm1p2_svt_lp L=6e-08 W=4.6e-07
MI0_MXNA1_6 ny A XI0_n1 VSS nm1p2_svt_lp L=6e-08 W=4.6e-07
MI1_MXNA1 Y ny VSS VSS nm1p2_svt_lp L=6e-08 W=4.65e-07
MI1_MXNA1_2 Y ny VSS VSS nm1p2_svt_lp L=6e-08 W=4.65e-07
MI1_MXNA1_3 Y ny VSS VSS nm1p2_svt_lp L=6e-08 W=4.65e-07
MI1_MXNA1_4 Y ny VSS VSS nm1p2_svt_lp L=6e-08 W=4.65e-07
MI1_MXNA1_5 Y ny VSS VSS nm1p2_svt_lp L=6e-08 W=4.65e-07
MI1_MXNA1_6 Y ny VSS VSS nm1p2_svt_lp L=6e-08 W=4.65e-07
MI1_MXNA1_7 Y ny VSS VSS nm1p2_svt_lp L=6e-08 W=4.65e-07
MI1_MXNA1_8 Y ny VSS VSS nm1p2_svt_lp L=6e-08 W=4.65e-07
MI1_MXNA1_9 Y ny VSS VSS nm1p2_svt_lp L=6e-08 W=4.65e-07
MI1_MXNA1_10 Y ny VSS VSS nm1p2_svt_lp L=6e-08 W=4.65e-07
MI0_MXPA2 ny B VDD VDD pm1p2_svt_lp L=6e-08 W=5.8e-07
MI0_MXPA2_2 ny B VDD VDD pm1p2_svt_lp L=6e-08 W=5.8e-07
MI0_MXPA2_3 ny B VDD VDD pm1p2_svt_lp L=6e-08 W=5.8e-07
MI0_MXPA2_4 ny B VDD VDD pm1p2_svt_lp L=6e-08 W=5.8e-07
MI0_MXPA1 ny A VDD VDD pm1p2_svt_lp L=6e-08 W=5.8e-07
MI0_MXPA1_2 ny A VDD VDD pm1p2_svt_lp L=6e-08 W=5.8e-07
MI0_MXPA1_3 ny A VDD VDD pm1p2_svt_lp L=6e-08 W=5.8e-07
MI0_MXPA1_4 ny A VDD VDD pm1p2_svt_lp L=6e-08 W=5.8e-07
MI1_MXPA1 Y ny VDD VDD pm1p2_svt_lp L=6e-08 W=5.85e-07
MI1_MXPA1_2 Y ny VDD VDD pm1p2_svt_lp L=6e-08 W=5.85e-07
MI1_MXPA1_3 Y ny VDD VDD pm1p2_svt_lp L=6e-08 W=5.85e-07
MI1_MXPA1_4 Y ny VDD VDD pm1p2_svt_lp L=6e-08 W=5.85e-07
MI1_MXPA1_5 Y ny VDD VDD pm1p2_svt_lp L=6e-08 W=5.85e-07
MI1_MXPA1_6 Y ny VDD VDD pm1p2_svt_lp L=6e-08 W=5.85e-07
MI1_MXPA1_7 Y ny VDD VDD pm1p2_svt_lp L=6e-08 W=5.85e-07
MI1_MXPA1_8 Y ny VDD VDD pm1p2_svt_lp L=6e-08 W=5.85e-07
MI1_MXPA1_9 Y ny VDD VDD pm1p2_svt_lp L=6e-08 W=5.85e-07
MI1_MXPA1_10 Y ny VDD VDD pm1p2_svt_lp L=6e-08 W=5.85e-07
MI1_MXPA1_11 Y ny VDD VDD pm1p2_svt_lp L=6e-08 W=5.85e-07
.ENDS

.SUBCKT AND3X0P5H9R Y VDD VSS A B C
MI0_MXNA1 ny A XI0_n2 VSS nm1p2_svt_lp L=6e-08 W=3.25e-07
MI0_MXNA2 XI0_n2 B XI0_n1 VSS nm1p2_svt_lp L=6e-08 W=3.25e-07
MI0_MXNA3 XI0_n1 C VSS VSS nm1p2_svt_lp L=6e-08 W=3.25e-07
MI1_MXNA1 Y ny VSS VSS nm1p2_svt_lp L=6e-08 W=2.1e-07
MI0_MXPA1 ny A VDD VDD pm1p2_svt_lp L=6e-08 W=1.9e-07
MI0_MXPA2 ny B VDD VDD pm1p2_svt_lp L=6e-08 W=1.9e-07
MI0_MXPA3 ny C VDD VDD pm1p2_svt_lp L=6e-08 W=1.9e-07
MI1_MXPA1 Y ny VDD VDD pm1p2_svt_lp L=6e-08 W=2.95e-07
.ENDS

.SUBCKT AND3X0P7H9R Y VDD VSS A B C
MI0_MXNA1 ny A XI0_n2 VSS nm1p2_svt_lp L=6e-08 W=3.8e-07
MI0_MXNA2 XI0_n2 B XI0_n1 VSS nm1p2_svt_lp L=6e-08 W=3.8e-07
MI0_MXNA3 XI0_n1 C VSS VSS nm1p2_svt_lp L=6e-08 W=3.8e-07
MI1_MXNA1 Y ny VSS VSS nm1p2_svt_lp L=6e-08 W=2.95e-07
MI0_MXPA1 ny A VDD VDD pm1p2_svt_lp L=6e-08 W=2.25e-07
MI0_MXPA2 ny B VDD VDD pm1p2_svt_lp L=6e-08 W=2.25e-07
MI0_MXPA3 ny C VDD VDD pm1p2_svt_lp L=6e-08 W=2.25e-07
MI1_MXPA1 Y ny VDD VDD pm1p2_svt_lp L=6e-08 W=4.15e-07
.ENDS

.SUBCKT AND3X1H9R Y VDD VSS A B C
MI0_MXNA1 ny A XI0_n2 VSS nm1p2_svt_lp L=6e-08 W=4.6e-07
MI0_MXNA2 XI0_n2 B XI0_n1 VSS nm1p2_svt_lp L=6e-08 W=4.6e-07
MI0_MXNA3 XI0_n1 C VSS VSS nm1p2_svt_lp L=6e-08 W=4.6e-07
MI1_MXNA1 Y ny VSS VSS nm1p2_svt_lp L=6e-08 W=4.2e-07
MI0_MXPA1 ny A VDD VDD pm1p2_svt_lp L=6e-08 W=2.7e-07
MI0_MXPA2 ny B VDD VDD pm1p2_svt_lp L=6e-08 W=2.7e-07
MI0_MXPA3 ny C VDD VDD pm1p2_svt_lp L=6e-08 W=2.7e-07
MI1_MXPA1 Y ny VDD VDD pm1p2_svt_lp L=6e-08 W=5.85e-07
.ENDS

.SUBCKT AND3X1P4H9R Y VDD VSS A B C
MI0_MXNA3_2 XI0_n1__2 C VSS VSS nm1p2_svt_lp L=6e-08 W=3.4e-07
MI0_MXNA2_2 XI0_n2__2 B XI0_n1__2 VSS nm1p2_svt_lp L=6e-08 W=3.4e-07
MI0_MXNA1_2 ny A XI0_n2__2 VSS nm1p2_svt_lp L=6e-08 W=3.4e-07
MI0_MXNA1 ny A XI0_n2 VSS nm1p2_svt_lp L=6e-08 W=3.4e-07
MI0_MXNA2 XI0_n2 B XI0_n1 VSS nm1p2_svt_lp L=6e-08 W=3.4e-07
MI0_MXNA3 XI0_n1 C VSS VSS nm1p2_svt_lp L=6e-08 W=3.4e-07
MI1_MXNA1 Y ny VSS VSS nm1p2_svt_lp L=6e-08 W=2.95e-07
MI1_MXNA1_2 Y ny VSS VSS nm1p2_svt_lp L=6e-08 W=2.95e-07
MI0_MXPA3 ny C VDD VDD pm1p2_svt_lp L=6e-08 W=2e-07
MI0_MXPA2 ny B VDD VDD pm1p2_svt_lp L=6e-08 W=2e-07
MI0_MXPA1 ny A VDD VDD pm1p2_svt_lp L=6e-08 W=2e-07
MI0_MXPA1_2 ny A VDD VDD pm1p2_svt_lp L=6e-08 W=2e-07
MI0_MXPA2_2 ny B VDD VDD pm1p2_svt_lp L=6e-08 W=2e-07
MI0_MXPA3_2 ny C VDD VDD pm1p2_svt_lp L=6e-08 W=2e-07
MI1_MXPA1 Y ny VDD VDD pm1p2_svt_lp L=6e-08 W=4.15e-07
MI1_MXPA1_2 Y ny VDD VDD pm1p2_svt_lp L=6e-08 W=4.15e-07
.ENDS

.SUBCKT AND3X2H9R Y VDD VSS A B C
MI0_MXNA3_2 XI0_n1__2 C VSS VSS nm1p2_svt_lp L=6e-08 W=4.25e-07
MI0_MXNA2_2 XI0_n2__2 B XI0_n1__2 VSS nm1p2_svt_lp L=6e-08 W=4.25e-07
MI0_MXNA1_2 ny A XI0_n2__2 VSS nm1p2_svt_lp L=6e-08 W=4.25e-07
MI0_MXNA1 ny A XI0_n2 VSS nm1p2_svt_lp L=6e-08 W=4.25e-07
MI0_MXNA2 XI0_n2 B XI0_n1 VSS nm1p2_svt_lp L=6e-08 W=4.25e-07
MI0_MXNA3 XI0_n1 C VSS VSS nm1p2_svt_lp L=6e-08 W=4.25e-07
MI1_MXNA1 Y ny VSS VSS nm1p2_svt_lp L=6e-08 W=4.2e-07
MI1_MXNA1_2 Y ny VSS VSS nm1p2_svt_lp L=6e-08 W=4.2e-07
MI0_MXPA1 ny A VDD VDD pm1p2_svt_lp L=6e-08 W=5e-07
MI0_MXPA2 ny B VDD VDD pm1p2_svt_lp L=6e-08 W=5e-07
MI0_MXPA3 ny C VDD VDD pm1p2_svt_lp L=6e-08 W=5e-07
MI1_MXPA1 Y ny VDD VDD pm1p2_svt_lp L=6e-08 W=5.85e-07
MI1_MXPA1_2 Y ny VDD VDD pm1p2_svt_lp L=6e-08 W=5.85e-07
.ENDS

.SUBCKT AND3X3H9R Y VDD VSS A B C
MI0_MXNA1_2 ny A XI0_n2__2 VSS nm1p2_svt_lp L=6e-08 W=4.15e-07
MI0_MXNA2_2 XI0_n2__2 B XI0_n1 VSS nm1p2_svt_lp L=6e-08 W=4.15e-07
MI0_MXNA2_3 XI0_n2__3 B XI0_n1 VSS nm1p2_svt_lp L=6e-08 W=4.15e-07
MI0_MXNA1_3 ny A XI0_n2__3 VSS nm1p2_svt_lp L=6e-08 W=4.15e-07
MI0_MXNA1 ny A XI0_n2 VSS nm1p2_svt_lp L=6e-08 W=4.15e-07
MI0_MXNA2 XI0_n2 B XI0_n1 VSS nm1p2_svt_lp L=6e-08 W=4.15e-07
MI0_MXNA3 XI0_n1 C VSS VSS nm1p2_svt_lp L=6e-08 W=4.15e-07
MI0_MXNA3_2 XI0_n1 C VSS VSS nm1p2_svt_lp L=6e-08 W=4.15e-07
MI0_MXNA3_3 XI0_n1 C VSS VSS nm1p2_svt_lp L=6e-08 W=4.15e-07
MI1_MXNA1 Y ny VSS VSS nm1p2_svt_lp L=6e-08 W=4.2e-07
MI1_MXNA1_2 Y ny VSS VSS nm1p2_svt_lp L=6e-08 W=4.2e-07
MI1_MXNA1_3 Y ny VSS VSS nm1p2_svt_lp L=6e-08 W=4.2e-07
MI0_MXPA2 ny B VDD VDD pm1p2_svt_lp L=6e-08 W=3.7e-07
MI0_MXPA1 ny A VDD VDD pm1p2_svt_lp L=6e-08 W=3.7e-07
MI0_MXPA1_2 ny A VDD VDD pm1p2_svt_lp L=6e-08 W=3.7e-07
MI0_MXPA2_2 ny B VDD VDD pm1p2_svt_lp L=6e-08 W=3.7e-07
MI0_MXPA3 ny C VDD VDD pm1p2_svt_lp L=6e-08 W=3.7e-07
MI0_MXPA3_2 ny C VDD VDD pm1p2_svt_lp L=6e-08 W=3.7e-07
MI1_MXPA1 Y ny VDD VDD pm1p2_svt_lp L=6e-08 W=5.85e-07
MI1_MXPA1_2 Y ny VDD VDD pm1p2_svt_lp L=6e-08 W=5.85e-07
MI1_MXPA1_3 Y ny VDD VDD pm1p2_svt_lp L=6e-08 W=5.85e-07
.ENDS

.SUBCKT AND3X4H9R Y VDD VSS A B C
MI0_MXNA1_2 ny A XI0_n2__2 VSS nm1p2_svt_lp L=6e-08 W=4.95e-07
MI0_MXNA2_2 XI0_n2__2 B XI0_n1 VSS nm1p2_svt_lp L=6e-08 W=4.95e-07
MI0_MXNA2_3 XI0_n2__3 B XI0_n1 VSS nm1p2_svt_lp L=6e-08 W=4.95e-07
MI0_MXNA1_3 ny A XI0_n2__3 VSS nm1p2_svt_lp L=6e-08 W=4.95e-07
MI0_MXNA1 ny A XI0_n2 VSS nm1p2_svt_lp L=6e-08 W=4.95e-07
MI0_MXNA2 XI0_n2 B XI0_n1 VSS nm1p2_svt_lp L=6e-08 W=4.95e-07
MI0_MXNA3 XI0_n1 C VSS VSS nm1p2_svt_lp L=6e-08 W=4.95e-07
MI0_MXNA3_2 XI0_n1 C VSS VSS nm1p2_svt_lp L=6e-08 W=4.95e-07
MI0_MXNA3_3 XI0_n1 C VSS VSS nm1p2_svt_lp L=6e-08 W=4.95e-07
MI1_MXNA1 Y ny VSS VSS nm1p2_svt_lp L=6e-08 W=4.2e-07
MI1_MXNA1_2 Y ny VSS VSS nm1p2_svt_lp L=6e-08 W=4.2e-07
MI1_MXNA1_3 Y ny VSS VSS nm1p2_svt_lp L=6e-08 W=4.2e-07
MI1_MXNA1_4 Y ny VSS VSS nm1p2_svt_lp L=6e-08 W=4.2e-07
MI0_MXPA2 ny B VDD VDD pm1p2_svt_lp L=6e-08 W=4.35e-07
MI0_MXPA1 ny A VDD VDD pm1p2_svt_lp L=6e-08 W=4.35e-07
MI0_MXPA1_2 ny A VDD VDD pm1p2_svt_lp L=6e-08 W=4.35e-07
MI0_MXPA2_2 ny B VDD VDD pm1p2_svt_lp L=6e-08 W=4.35e-07
MI0_MXPA3 ny C VDD VDD pm1p2_svt_lp L=6e-08 W=4.35e-07
MI0_MXPA3_2 ny C VDD VDD pm1p2_svt_lp L=6e-08 W=4.35e-07
MI1_MXPA1 Y ny VDD VDD pm1p2_svt_lp L=6e-08 W=5.85e-07
MI1_MXPA1_2 Y ny VDD VDD pm1p2_svt_lp L=6e-08 W=5.85e-07
MI1_MXPA1_3 Y ny VDD VDD pm1p2_svt_lp L=6e-08 W=5.85e-07
MI1_MXPA1_4 Y ny VDD VDD pm1p2_svt_lp L=6e-08 W=5.85e-07
.ENDS

.SUBCKT AND3X6H9R Y VDD VSS A B C
MI0_MXNA1_2 ny A XI0_n2__2 VSS nm1p2_svt_lp L=6e-08 W=4.95e-07
MI0_MXNA2_2 XI0_n2__2 B XI0_n1 VSS nm1p2_svt_lp L=6e-08 W=4.95e-07
MI0_MXNA2_3 XI0_n2__3 B XI0_n1 VSS nm1p2_svt_lp L=6e-08 W=4.95e-07
MI0_MXNA1_3 ny A XI0_n2__3 VSS nm1p2_svt_lp L=6e-08 W=4.95e-07
MI0_MXNA1_4 ny A XI0_n2__4 VSS nm1p2_svt_lp L=6e-08 W=4.95e-07
MI0_MXNA2_4 XI0_n2__4 B XI0_n1 VSS nm1p2_svt_lp L=6e-08 W=4.95e-07
MI0_MXNA2_5 XI0_n2__5 B XI0_n1 VSS nm1p2_svt_lp L=6e-08 W=4.95e-07
MI0_MXNA1_5 ny A XI0_n2__5 VSS nm1p2_svt_lp L=6e-08 W=4.95e-07
MI0_MXNA1 ny A XI0_n2 VSS nm1p2_svt_lp L=6e-08 W=4.95e-07
MI0_MXNA2 XI0_n2 B XI0_n1 VSS nm1p2_svt_lp L=6e-08 W=4.95e-07
MI0_MXNA3 XI0_n1 C VSS VSS nm1p2_svt_lp L=6e-08 W=4.95e-07
MI0_MXNA3_2 XI0_n1 C VSS VSS nm1p2_svt_lp L=6e-08 W=4.95e-07
MI0_MXNA3_3 XI0_n1 C VSS VSS nm1p2_svt_lp L=6e-08 W=4.95e-07
MI0_MXNA3_4 XI0_n1 C VSS VSS nm1p2_svt_lp L=6e-08 W=4.95e-07
MI0_MXNA3_5 XI0_n1 C VSS VSS nm1p2_svt_lp L=6e-08 W=4.95e-07
MI1_MXNA1 Y ny VSS VSS nm1p2_svt_lp L=6e-08 W=4.2e-07
MI1_MXNA1_2 Y ny VSS VSS nm1p2_svt_lp L=6e-08 W=4.2e-07
MI1_MXNA1_3 Y ny VSS VSS nm1p2_svt_lp L=6e-08 W=4.2e-07
MI1_MXNA1_4 Y ny VSS VSS nm1p2_svt_lp L=6e-08 W=4.2e-07
MI1_MXNA1_5 Y ny VSS VSS nm1p2_svt_lp L=6e-08 W=4.2e-07
MI1_MXNA1_6 Y ny VSS VSS nm1p2_svt_lp L=6e-08 W=4.2e-07
MI0_MXPA1 ny A VDD VDD pm1p2_svt_lp L=6e-08 W=4.85e-07
MI0_MXPA2 ny B VDD VDD pm1p2_svt_lp L=6e-08 W=4.85e-07
MI0_MXPA2_2 ny B VDD VDD pm1p2_svt_lp L=6e-08 W=4.85e-07
MI0_MXPA1_2 ny A VDD VDD pm1p2_svt_lp L=6e-08 W=4.85e-07
MI0_MXPA1_3 ny A VDD VDD pm1p2_svt_lp L=6e-08 W=4.85e-07
MI0_MXPA2_3 ny B VDD VDD pm1p2_svt_lp L=6e-08 W=4.85e-07
MI0_MXPA3 ny C VDD VDD pm1p2_svt_lp L=6e-08 W=4.85e-07
MI0_MXPA3_2 ny C VDD VDD pm1p2_svt_lp L=6e-08 W=4.85e-07
MI0_MXPA3_3 ny C VDD VDD pm1p2_svt_lp L=6e-08 W=4.85e-07
MI1_MXPA1 Y ny VDD VDD pm1p2_svt_lp L=6e-08 W=5.85e-07
MI1_MXPA1_2 Y ny VDD VDD pm1p2_svt_lp L=6e-08 W=5.85e-07
MI1_MXPA1_3 Y ny VDD VDD pm1p2_svt_lp L=6e-08 W=5.85e-07
MI1_MXPA1_4 Y ny VDD VDD pm1p2_svt_lp L=6e-08 W=5.85e-07
MI1_MXPA1_5 Y ny VDD VDD pm1p2_svt_lp L=6e-08 W=5.85e-07
MI1_MXPA1_6 Y ny VDD VDD pm1p2_svt_lp L=6e-08 W=5.85e-07
.ENDS

.SUBCKT AND3X8H9R Y VDD VSS A B C
MI0_MXNA1_2 ny A XI0_n2__2 VSS nm1p2_svt_lp L=6e-08 W=6.65e-07
MI0_MXNA2_2 XI0_n2__2 B XI0_n1 VSS nm1p2_svt_lp L=6e-08 W=6.65e-07
MI0_MXNA2_3 XI0_n2__3 B XI0_n1 VSS nm1p2_svt_lp L=6e-08 W=6.65e-07
MI0_MXNA1_3 ny A XI0_n2__3 VSS nm1p2_svt_lp L=6e-08 W=6.65e-07
MI0_MXNA1_4 ny A XI0_n2__4 VSS nm1p2_svt_lp L=6e-08 W=6.65e-07
MI0_MXNA2_4 XI0_n2__4 B XI0_n1 VSS nm1p2_svt_lp L=6e-08 W=6.65e-07
MI0_MXNA2_5 XI0_n2__5 B XI0_n1 VSS nm1p2_svt_lp L=6e-08 W=6.65e-07
MI0_MXNA1_5 ny A XI0_n2__5 VSS nm1p2_svt_lp L=6e-08 W=6.65e-07
MI0_MXNA1 ny A XI0_n2 VSS nm1p2_svt_lp L=6e-08 W=6.65e-07
MI0_MXNA2 XI0_n2 B XI0_n1 VSS nm1p2_svt_lp L=6e-08 W=6.65e-07
MI0_MXNA3 XI0_n1 C VSS VSS nm1p2_svt_lp L=6e-08 W=6.65e-07
MI0_MXNA3_2 XI0_n1 C VSS VSS nm1p2_svt_lp L=6e-08 W=6.65e-07
MI0_MXNA3_3 XI0_n1 C VSS VSS nm1p2_svt_lp L=6e-08 W=6.65e-07
MI0_MXNA3_4 XI0_n1 C VSS VSS nm1p2_svt_lp L=6e-08 W=6.65e-07
MI0_MXNA3_5 XI0_n1 C VSS VSS nm1p2_svt_lp L=6e-08 W=6.65e-07
MI1_MXNA1 Y ny VSS VSS nm1p2_svt_lp L=6e-08 W=4.8e-07
MI1_MXNA1_2 Y ny VSS VSS nm1p2_svt_lp L=6e-08 W=4.8e-07
MI1_MXNA1_3 Y ny VSS VSS nm1p2_svt_lp L=6e-08 W=4.8e-07
MI1_MXNA1_4 Y ny VSS VSS nm1p2_svt_lp L=6e-08 W=4.8e-07
MI1_MXNA1_5 Y ny VSS VSS nm1p2_svt_lp L=6e-08 W=4.8e-07
MI1_MXNA1_6 Y ny VSS VSS nm1p2_svt_lp L=6e-08 W=4.8e-07
MI1_MXNA1_7 Y ny VSS VSS nm1p2_svt_lp L=6e-08 W=4.8e-07
MI0_MXPA1 ny A VDD VDD pm1p2_svt_lp L=6e-08 W=3.95e-07
MI0_MXPA2 ny B VDD VDD pm1p2_svt_lp L=6e-08 W=3.95e-07
MI0_MXPA2_2 ny B VDD VDD pm1p2_svt_lp L=6e-08 W=3.95e-07
MI0_MXPA1_2 ny A VDD VDD pm1p2_svt_lp L=6e-08 W=3.95e-07
MI0_MXPA1_3 ny A VDD VDD pm1p2_svt_lp L=6e-08 W=3.95e-07
MI0_MXPA2_3 ny B VDD VDD pm1p2_svt_lp L=6e-08 W=3.95e-07
MI0_MXPA2_4 ny B VDD VDD pm1p2_svt_lp L=6e-08 W=3.95e-07
MI0_MXPA1_4 ny A VDD VDD pm1p2_svt_lp L=6e-08 W=3.95e-07
MI0_MXPA1_5 ny A VDD VDD pm1p2_svt_lp L=6e-08 W=3.95e-07
MI0_MXPA2_5 ny B VDD VDD pm1p2_svt_lp L=6e-08 W=3.95e-07
MI0_MXPA3 ny C VDD VDD pm1p2_svt_lp L=6e-08 W=3.95e-07
MI0_MXPA3_2 ny C VDD VDD pm1p2_svt_lp L=6e-08 W=3.95e-07
MI0_MXPA3_3 ny C VDD VDD pm1p2_svt_lp L=6e-08 W=3.95e-07
MI0_MXPA3_4 ny C VDD VDD pm1p2_svt_lp L=6e-08 W=3.95e-07
MI0_MXPA3_5 ny C VDD VDD pm1p2_svt_lp L=6e-08 W=3.95e-07
MI1_MXPA1 Y ny VDD VDD pm1p2_svt_lp L=6e-08 W=5.85e-07
MI1_MXPA1_2 Y ny VDD VDD pm1p2_svt_lp L=6e-08 W=5.85e-07
MI1_MXPA1_3 Y ny VDD VDD pm1p2_svt_lp L=6e-08 W=5.85e-07
MI1_MXPA1_4 Y ny VDD VDD pm1p2_svt_lp L=6e-08 W=5.85e-07
MI1_MXPA1_5 Y ny VDD VDD pm1p2_svt_lp L=6e-08 W=5.85e-07
MI1_MXPA1_6 Y ny VDD VDD pm1p2_svt_lp L=6e-08 W=5.85e-07
MI1_MXPA1_7 Y ny VDD VDD pm1p2_svt_lp L=6e-08 W=5.85e-07
MI1_MXPA1_8 Y ny VDD VDD pm1p2_svt_lp L=6e-08 W=5.85e-07
.ENDS

.SUBCKT AND3X11H9R Y VDD VSS A B C
MI0_MXNA1_2 ny A XI0_n2__2 VSS nm1p2_svt_lp L=6e-08 W=6.5e-07
MI0_MXNA2_2 XI0_n2__2 B XI0_n1 VSS nm1p2_svt_lp L=6e-08 W=6.5e-07
MI0_MXNA2_3 XI0_n2__3 B XI0_n1 VSS nm1p2_svt_lp L=6e-08 W=6.5e-07
MI0_MXNA1_3 ny A XI0_n2__3 VSS nm1p2_svt_lp L=6e-08 W=6.5e-07
MI0_MXNA1_4 ny A XI0_n2__4 VSS nm1p2_svt_lp L=6e-08 W=6.5e-07
MI0_MXNA2_4 XI0_n2__4 B XI0_n1 VSS nm1p2_svt_lp L=6e-08 W=6.5e-07
MI0_MXNA2_5 XI0_n2__5 B XI0_n1 VSS nm1p2_svt_lp L=6e-08 W=6.5e-07
MI0_MXNA1_5 ny A XI0_n2__5 VSS nm1p2_svt_lp L=6e-08 W=6.5e-07
MI0_MXNA1_6 ny A XI0_n2__6 VSS nm1p2_svt_lp L=6e-08 W=6.5e-07
MI0_MXNA2_6 XI0_n2__6 B XI0_n1 VSS nm1p2_svt_lp L=6e-08 W=6.5e-07
MI0_MXNA2_7 XI0_n2__7 B XI0_n1 VSS nm1p2_svt_lp L=6e-08 W=6.5e-07
MI0_MXNA1_7 ny A XI0_n2__7 VSS nm1p2_svt_lp L=6e-08 W=6.5e-07
MI0_MXNA1 ny A XI0_n2 VSS nm1p2_svt_lp L=6e-08 W=6.5e-07
MI0_MXNA2 XI0_n2 B XI0_n1 VSS nm1p2_svt_lp L=6e-08 W=6.5e-07
MI0_MXNA3 XI0_n1 C VSS VSS nm1p2_svt_lp L=6e-08 W=6.5e-07
MI0_MXNA3_2 XI0_n1 C VSS VSS nm1p2_svt_lp L=6e-08 W=6.5e-07
MI0_MXNA3_3 XI0_n1 C VSS VSS nm1p2_svt_lp L=6e-08 W=6.5e-07
MI0_MXNA3_4 XI0_n1 C VSS VSS nm1p2_svt_lp L=6e-08 W=6.5e-07
MI0_MXNA3_5 XI0_n1 C VSS VSS nm1p2_svt_lp L=6e-08 W=6.5e-07
MI0_MXNA3_6 XI0_n1 C VSS VSS nm1p2_svt_lp L=6e-08 W=6.5e-07
MI0_MXNA3_7 XI0_n1 C VSS VSS nm1p2_svt_lp L=6e-08 W=6.5e-07
MI1_MXNA1 Y ny VSS VSS nm1p2_svt_lp L=6e-08 W=4.65e-07
MI1_MXNA1_2 Y ny VSS VSS nm1p2_svt_lp L=6e-08 W=4.65e-07
MI1_MXNA1_3 Y ny VSS VSS nm1p2_svt_lp L=6e-08 W=4.65e-07
MI1_MXNA1_4 Y ny VSS VSS nm1p2_svt_lp L=6e-08 W=4.65e-07
MI1_MXNA1_5 Y ny VSS VSS nm1p2_svt_lp L=6e-08 W=4.65e-07
MI1_MXNA1_6 Y ny VSS VSS nm1p2_svt_lp L=6e-08 W=4.65e-07
MI1_MXNA1_7 Y ny VSS VSS nm1p2_svt_lp L=6e-08 W=4.65e-07
MI1_MXNA1_8 Y ny VSS VSS nm1p2_svt_lp L=6e-08 W=4.65e-07
MI1_MXNA1_9 Y ny VSS VSS nm1p2_svt_lp L=6e-08 W=4.65e-07
MI1_MXNA1_10 Y ny VSS VSS nm1p2_svt_lp L=6e-08 W=4.65e-07
MI0_MXPA1 ny A VDD VDD pm1p2_svt_lp L=6e-08 W=3.75e-07
MI0_MXPA2 ny B VDD VDD pm1p2_svt_lp L=6e-08 W=3.75e-07
MI0_MXPA2_2 ny B VDD VDD pm1p2_svt_lp L=6e-08 W=3.75e-07
MI0_MXPA1_2 ny A VDD VDD pm1p2_svt_lp L=6e-08 W=3.75e-07
MI0_MXPA1_3 ny A VDD VDD pm1p2_svt_lp L=6e-08 W=3.75e-07
MI0_MXPA2_3 ny B VDD VDD pm1p2_svt_lp L=6e-08 W=3.75e-07
MI0_MXPA2_4 ny B VDD VDD pm1p2_svt_lp L=6e-08 W=3.75e-07
MI0_MXPA1_4 ny A VDD VDD pm1p2_svt_lp L=6e-08 W=3.75e-07
MI0_MXPA1_5 ny A VDD VDD pm1p2_svt_lp L=6e-08 W=3.75e-07
MI0_MXPA2_5 ny B VDD VDD pm1p2_svt_lp L=6e-08 W=3.75e-07
MI0_MXPA2_6 ny B VDD VDD pm1p2_svt_lp L=6e-08 W=3.75e-07
MI0_MXPA1_6 ny A VDD VDD pm1p2_svt_lp L=6e-08 W=3.75e-07
MI0_MXPA1_7 ny A VDD VDD pm1p2_svt_lp L=6e-08 W=3.75e-07
MI0_MXPA2_7 ny B VDD VDD pm1p2_svt_lp L=6e-08 W=3.75e-07
MI0_MXPA3 ny C VDD VDD pm1p2_svt_lp L=6e-08 W=3.75e-07
MI0_MXPA3_2 ny C VDD VDD pm1p2_svt_lp L=6e-08 W=3.75e-07
MI0_MXPA3_3 ny C VDD VDD pm1p2_svt_lp L=6e-08 W=3.75e-07
MI0_MXPA3_4 ny C VDD VDD pm1p2_svt_lp L=6e-08 W=3.75e-07
MI0_MXPA3_5 ny C VDD VDD pm1p2_svt_lp L=6e-08 W=3.75e-07
MI0_MXPA3_6 ny C VDD VDD pm1p2_svt_lp L=6e-08 W=3.75e-07
MI0_MXPA3_7 ny C VDD VDD pm1p2_svt_lp L=6e-08 W=3.75e-07
MI1_MXPA1 Y ny VDD VDD pm1p2_svt_lp L=6e-08 W=5.85e-07
MI1_MXPA1_2 Y ny VDD VDD pm1p2_svt_lp L=6e-08 W=5.85e-07
MI1_MXPA1_3 Y ny VDD VDD pm1p2_svt_lp L=6e-08 W=5.85e-07
MI1_MXPA1_4 Y ny VDD VDD pm1p2_svt_lp L=6e-08 W=5.85e-07
MI1_MXPA1_5 Y ny VDD VDD pm1p2_svt_lp L=6e-08 W=5.85e-07
MI1_MXPA1_6 Y ny VDD VDD pm1p2_svt_lp L=6e-08 W=5.85e-07
MI1_MXPA1_7 Y ny VDD VDD pm1p2_svt_lp L=6e-08 W=5.85e-07
MI1_MXPA1_8 Y ny VDD VDD pm1p2_svt_lp L=6e-08 W=5.85e-07
MI1_MXPA1_9 Y ny VDD VDD pm1p2_svt_lp L=6e-08 W=5.85e-07
MI1_MXPA1_10 Y ny VDD VDD pm1p2_svt_lp L=6e-08 W=5.85e-07
MI1_MXPA1_11 Y ny VDD VDD pm1p2_svt_lp L=6e-08 W=5.85e-07
.ENDS

.SUBCKT AND4X0P5H9R Y VDD VSS A B C D
MI0_MXNA1 ny A XI0_n3 VSS nm1p2_svt_lp L=6e-08 W=4.65e-07
MI0_MXNA2 XI0_n3 B XI0_n2 VSS nm1p2_svt_lp L=6e-08 W=4.65e-07
MI0_MXNA3 XI0_n2 C XI0_n1 VSS nm1p2_svt_lp L=6e-08 W=4.65e-07
MI0_MXNA4 XI0_n1 D VSS VSS nm1p2_svt_lp L=6e-08 W=4.65e-07
MI1_MXNA1 Y ny VSS VSS nm1p2_svt_lp L=6e-08 W=2.1e-07
MI0_MXPA1 ny A VDD VDD pm1p2_svt_lp L=6e-08 W=2.15e-07
MI0_MXPA2 ny B VDD VDD pm1p2_svt_lp L=6e-08 W=2.15e-07
MI0_MXPA3 ny C VDD VDD pm1p2_svt_lp L=6e-08 W=2.15e-07
MI0_MXPA4 ny D VDD VDD pm1p2_svt_lp L=6e-08 W=2.15e-07
MI1_MXPA1 Y ny VDD VDD pm1p2_svt_lp L=6e-08 W=2.95e-07
.ENDS

.SUBCKT AND4X0P7H9R Y VDD VSS A B C D
MI0_MXNA4_2 XI0_n1__2 D VSS VSS nm1p2_svt_lp L=6e-08 W=4.05e-07
MI0_MXNA3_2 XI0_n2__2 C XI0_n1__2 VSS nm1p2_svt_lp L=6e-08 W=4.05e-07
MI0_MXNA2_2 XI0_n3__2 B XI0_n2__2 VSS nm1p2_svt_lp L=6e-08 W=4.05e-07
MI0_MXNA1_2 ny A XI0_n3__2 VSS nm1p2_svt_lp L=6e-08 W=4.05e-07
MI0_MXNA1 ny A XI0_n3 VSS nm1p2_svt_lp L=6e-08 W=4.05e-07
MI0_MXNA2 XI0_n3 B XI0_n2 VSS nm1p2_svt_lp L=6e-08 W=4.05e-07
MI0_MXNA3 XI0_n2 C XI0_n1 VSS nm1p2_svt_lp L=6e-08 W=4.05e-07
MI0_MXNA4 XI0_n1 D VSS VSS nm1p2_svt_lp L=6e-08 W=4.05e-07
MI1_MXNA1 Y ny VSS VSS nm1p2_svt_lp L=6e-08 W=2.95e-07
MI0_MXPA4 ny D VDD VDD pm1p2_svt_lp L=6e-08 W=1.85e-07
MI0_MXPA3 ny C VDD VDD pm1p2_svt_lp L=6e-08 W=1.85e-07
MI0_MXPA2 ny B VDD VDD pm1p2_svt_lp L=6e-08 W=1.85e-07
MI0_MXPA1 ny A VDD VDD pm1p2_svt_lp L=6e-08 W=1.85e-07
MI0_MXPA1_2 ny A VDD VDD pm1p2_svt_lp L=6e-08 W=1.85e-07
MI0_MXPA2_2 ny B VDD VDD pm1p2_svt_lp L=6e-08 W=1.85e-07
MI0_MXPA3_2 ny C VDD VDD pm1p2_svt_lp L=6e-08 W=1.85e-07
MI0_MXPA4_2 ny D VDD VDD pm1p2_svt_lp L=6e-08 W=1.85e-07
MI1_MXPA1 Y ny VDD VDD pm1p2_svt_lp L=6e-08 W=4.15e-07
.ENDS

.SUBCKT AND4X1H9R Y VDD VSS A B C D
MI0_MXNA4_2 XI0_n1__2 D VSS VSS nm1p2_svt_lp L=6e-08 W=4.6e-07
MI0_MXNA3_2 XI0_n2__2 C XI0_n1__2 VSS nm1p2_svt_lp L=6e-08 W=4.6e-07
MI0_MXNA2_2 XI0_n3__2 B XI0_n2__2 VSS nm1p2_svt_lp L=6e-08 W=4.6e-07
MI0_MXNA1_2 ny A XI0_n3__2 VSS nm1p2_svt_lp L=6e-08 W=4.6e-07
MI0_MXNA1 ny A XI0_n3 VSS nm1p2_svt_lp L=6e-08 W=4.6e-07
MI0_MXNA2 XI0_n3 B XI0_n2 VSS nm1p2_svt_lp L=6e-08 W=4.6e-07
MI0_MXNA3 XI0_n2 C XI0_n1 VSS nm1p2_svt_lp L=6e-08 W=4.6e-07
MI0_MXNA4 XI0_n1 D VSS VSS nm1p2_svt_lp L=6e-08 W=4.6e-07
MI1_MXNA1 Y ny VSS VSS nm1p2_svt_lp L=6e-08 W=4.2e-07
MI0_MXPA4 ny D VDD VDD pm1p2_svt_lp L=6e-08 W=2.1e-07
MI0_MXPA3 ny C VDD VDD pm1p2_svt_lp L=6e-08 W=2.1e-07
MI0_MXPA2 ny B VDD VDD pm1p2_svt_lp L=6e-08 W=2.1e-07
MI0_MXPA1 ny A VDD VDD pm1p2_svt_lp L=6e-08 W=2.1e-07
MI0_MXPA1_2 ny A VDD VDD pm1p2_svt_lp L=6e-08 W=2.1e-07
MI0_MXPA2_2 ny B VDD VDD pm1p2_svt_lp L=6e-08 W=2.1e-07
MI0_MXPA3_2 ny C VDD VDD pm1p2_svt_lp L=6e-08 W=2.1e-07
MI0_MXPA4_2 ny D VDD VDD pm1p2_svt_lp L=6e-08 W=2.1e-07
MI1_MXPA1 Y ny VDD VDD pm1p2_svt_lp L=6e-08 W=5.85e-07
.ENDS

.SUBCKT AND4X1P4H9R Y VDD VSS A B C D
MI0_MXNA3_2 XI0_n2 C XI0_n1__2 VSS nm1p2_svt_lp L=6e-08 W=6.15e-07
MI0_MXNA4_2 XI0_n1__2 D VSS VSS nm1p2_svt_lp L=6e-08 W=6.15e-07
MI0_MXNA4 XI0_n1 D VSS VSS nm1p2_svt_lp L=6e-08 W=6.15e-07
MI0_MXNA3 XI0_n2 C XI0_n1 VSS nm1p2_svt_lp L=6e-08 W=6.15e-07
MI0_MXNA2_2 XI0_n3__2 B XI0_n2 VSS nm1p2_svt_lp L=6e-08 W=6.15e-07
MI0_MXNA1_2 ny A XI0_n3__2 VSS nm1p2_svt_lp L=6e-08 W=6.15e-07
MI0_MXNA1 ny A XI0_n3 VSS nm1p2_svt_lp L=6e-08 W=6.15e-07
MI0_MXNA2 XI0_n3 B XI0_n2 VSS nm1p2_svt_lp L=6e-08 W=6.15e-07
MI1_MXNA1 Y ny VSS VSS nm1p2_svt_lp L=6e-08 W=5.9e-07
MI0_MXPA3 ny C VDD VDD pm1p2_svt_lp L=6e-08 W=2.85e-07
MI0_MXPA4 ny D VDD VDD pm1p2_svt_lp L=6e-08 W=2.85e-07
MI0_MXPA4_2 ny D VDD VDD pm1p2_svt_lp L=6e-08 W=2.85e-07
MI0_MXPA3_2 ny C VDD VDD pm1p2_svt_lp L=6e-08 W=2.85e-07
MI0_MXPA2 ny B VDD VDD pm1p2_svt_lp L=6e-08 W=2.85e-07
MI0_MXPA1 ny A VDD VDD pm1p2_svt_lp L=6e-08 W=2.85e-07
MI0_MXPA1_2 ny A VDD VDD pm1p2_svt_lp L=6e-08 W=2.85e-07
MI0_MXPA2_2 ny B VDD VDD pm1p2_svt_lp L=6e-08 W=2.85e-07
MI1_MXPA1 Y ny VDD VDD pm1p2_svt_lp L=6e-08 W=4.15e-07
MI1_MXPA1_2 Y ny VDD VDD pm1p2_svt_lp L=6e-08 W=4.15e-07
.ENDS

.SUBCKT AND4X2H9R Y VDD VSS A B C D
MI0_MXNA3_2 XI0_n2 C XI0_n1__2 VSS nm1p2_svt_lp L=6e-08 W=7.3e-07
MI0_MXNA4_2 XI0_n1__2 D VSS VSS nm1p2_svt_lp L=6e-08 W=7.3e-07
MI0_MXNA4 XI0_n1 D VSS VSS nm1p2_svt_lp L=6e-08 W=7.3e-07
MI0_MXNA3 XI0_n2 C XI0_n1 VSS nm1p2_svt_lp L=6e-08 W=7.3e-07
MI0_MXNA2_2 XI0_n3__2 B XI0_n2 VSS nm1p2_svt_lp L=6e-08 W=7.3e-07
MI0_MXNA1_2 ny A XI0_n3__2 VSS nm1p2_svt_lp L=6e-08 W=7.3e-07
MI0_MXNA1 ny A XI0_n3 VSS nm1p2_svt_lp L=6e-08 W=7.3e-07
MI0_MXNA2 XI0_n3 B XI0_n2 VSS nm1p2_svt_lp L=6e-08 W=7.3e-07
MI1_MXNA1 Y ny VSS VSS nm1p2_svt_lp L=6e-08 W=4.2e-07
MI1_MXNA1_2 Y ny VSS VSS nm1p2_svt_lp L=6e-08 W=4.2e-07
MI0_MXPA3 ny C VDD VDD pm1p2_svt_lp L=6e-08 W=3.3e-07
MI0_MXPA4 ny D VDD VDD pm1p2_svt_lp L=6e-08 W=3.3e-07
MI0_MXPA4_2 ny D VDD VDD pm1p2_svt_lp L=6e-08 W=3.3e-07
MI0_MXPA3_2 ny C VDD VDD pm1p2_svt_lp L=6e-08 W=3.3e-07
MI0_MXPA2 ny B VDD VDD pm1p2_svt_lp L=6e-08 W=3.3e-07
MI0_MXPA1 ny A VDD VDD pm1p2_svt_lp L=6e-08 W=3.3e-07
MI0_MXPA1_2 ny A VDD VDD pm1p2_svt_lp L=6e-08 W=3.3e-07
MI0_MXPA2_2 ny B VDD VDD pm1p2_svt_lp L=6e-08 W=3.3e-07
MI1_MXPA1 Y ny VDD VDD pm1p2_svt_lp L=6e-08 W=5.85e-07
MI1_MXPA1_2 Y ny VDD VDD pm1p2_svt_lp L=6e-08 W=5.85e-07
.ENDS

.SUBCKT AND4X3H9R Y VDD VSS A B C D
MI0_MXNA3_2 XI0_n2 C XI0_n1__2 VSS nm1p2_svt_lp L=6e-08 W=4.85e-07
MI0_MXNA4_2 XI0_n1__2 D VSS VSS nm1p2_svt_lp L=6e-08 W=4.85e-07
MI0_MXNA4_3 XI0_n1__3 D VSS VSS nm1p2_svt_lp L=6e-08 W=4.85e-07
MI0_MXNA3_3 XI0_n2 C XI0_n1__3 VSS nm1p2_svt_lp L=6e-08 W=4.85e-07
MI0_MXNA3_4 XI0_n2 C XI0_n1__4 VSS nm1p2_svt_lp L=6e-08 W=4.85e-07
MI0_MXNA4_4 XI0_n1__4 D VSS VSS nm1p2_svt_lp L=6e-08 W=4.85e-07
MI0_MXNA4 XI0_n1 D VSS VSS nm1p2_svt_lp L=6e-08 W=4.85e-07
MI0_MXNA3 XI0_n2 C XI0_n1 VSS nm1p2_svt_lp L=6e-08 W=4.85e-07
MI0_MXNA2_2 XI0_n3__2 B XI0_n2 VSS nm1p2_svt_lp L=6e-08 W=4.85e-07
MI0_MXNA1_2 ny A XI0_n3__2 VSS nm1p2_svt_lp L=6e-08 W=4.85e-07
MI0_MXNA1_3 ny A XI0_n3__3 VSS nm1p2_svt_lp L=6e-08 W=4.85e-07
MI0_MXNA2_3 XI0_n3__3 B XI0_n2 VSS nm1p2_svt_lp L=6e-08 W=4.85e-07
MI0_MXNA2_4 XI0_n3__4 B XI0_n2 VSS nm1p2_svt_lp L=6e-08 W=4.85e-07
MI0_MXNA1_4 ny A XI0_n3__4 VSS nm1p2_svt_lp L=6e-08 W=4.85e-07
MI0_MXNA1 ny A XI0_n3 VSS nm1p2_svt_lp L=6e-08 W=4.85e-07
MI0_MXNA2 XI0_n3 B XI0_n2 VSS nm1p2_svt_lp L=6e-08 W=4.85e-07
MI1_MXNA1 Y ny VSS VSS nm1p2_svt_lp L=6e-08 W=4.2e-07
MI1_MXNA1_2 Y ny VSS VSS nm1p2_svt_lp L=6e-08 W=4.2e-07
MI1_MXNA1_3 Y ny VSS VSS nm1p2_svt_lp L=6e-08 W=4.2e-07
MI0_MXPA3 ny C VDD VDD pm1p2_svt_lp L=6e-08 W=4.5e-07
MI0_MXPA4 ny D VDD VDD pm1p2_svt_lp L=6e-08 W=4.5e-07
MI0_MXPA4_2 ny D VDD VDD pm1p2_svt_lp L=6e-08 W=4.5e-07
MI0_MXPA3_2 ny C VDD VDD pm1p2_svt_lp L=6e-08 W=4.5e-07
MI0_MXPA2 ny B VDD VDD pm1p2_svt_lp L=6e-08 W=4.5e-07
MI0_MXPA1 ny A VDD VDD pm1p2_svt_lp L=6e-08 W=4.5e-07
MI0_MXPA1_2 ny A VDD VDD pm1p2_svt_lp L=6e-08 W=4.5e-07
MI0_MXPA2_2 ny B VDD VDD pm1p2_svt_lp L=6e-08 W=4.5e-07
MI1_MXPA1 Y ny VDD VDD pm1p2_svt_lp L=6e-08 W=5.85e-07
MI1_MXPA1_2 Y ny VDD VDD pm1p2_svt_lp L=6e-08 W=5.85e-07
MI1_MXPA1_3 Y ny VDD VDD pm1p2_svt_lp L=6e-08 W=5.85e-07
.ENDS

.SUBCKT AND4X4H9R Y VDD VSS A B C D
MI0_MXNA4 XI0_n1 D VSS VSS nm1p2_svt_lp L=6e-08 W=7e-07
MI0_MXNA4_2 XI0_n1 D VSS VSS nm1p2_svt_lp L=6e-08 W=7e-07
MI0_MXNA4_3 XI0_n1 D VSS VSS nm1p2_svt_lp L=6e-08 W=7e-07
MI0_MXNA4_4 XI0_n1 D VSS VSS nm1p2_svt_lp L=6e-08 W=7e-07
MI0_MXNA3 XI0_n2 C XI0_n1 VSS nm1p2_svt_lp L=6e-08 W=7e-07
MI0_MXNA3_2 XI0_n2 C XI0_n1 VSS nm1p2_svt_lp L=6e-08 W=7e-07
MI0_MXNA3_3 XI0_n2 C XI0_n1 VSS nm1p2_svt_lp L=6e-08 W=7e-07
MI0_MXNA3_4 XI0_n2 C XI0_n1 VSS nm1p2_svt_lp L=6e-08 W=7e-07
MI0_MXNA2 XI0_n3 B XI0_n2 VSS nm1p2_svt_lp L=6e-08 W=7e-07
MI0_MXNA2_2 XI0_n3 B XI0_n2 VSS nm1p2_svt_lp L=6e-08 W=7e-07
MI0_MXNA2_3 XI0_n3 B XI0_n2 VSS nm1p2_svt_lp L=6e-08 W=7e-07
MI0_MXNA2_4 XI0_n3 B XI0_n2 VSS nm1p2_svt_lp L=6e-08 W=7e-07
MI0_MXNA1 ny A XI0_n3 VSS nm1p2_svt_lp L=6e-08 W=7e-07
MI0_MXNA1_2 ny A XI0_n3 VSS nm1p2_svt_lp L=6e-08 W=7e-07
MI0_MXNA1_3 ny A XI0_n3 VSS nm1p2_svt_lp L=6e-08 W=7e-07
MI0_MXNA1_4 ny A XI0_n3 VSS nm1p2_svt_lp L=6e-08 W=7e-07
MI1_MXNA1 Y ny VSS VSS nm1p2_svt_lp L=6e-08 W=4.2e-07
MI1_MXNA1_2 Y ny VSS VSS nm1p2_svt_lp L=6e-08 W=4.2e-07
MI1_MXNA1_3 Y ny VSS VSS nm1p2_svt_lp L=6e-08 W=4.2e-07
MI1_MXNA1_4 Y ny VSS VSS nm1p2_svt_lp L=6e-08 W=4.2e-07
MI0_MXPA4 ny D VDD VDD pm1p2_svt_lp L=6e-08 W=3.15e-07
MI0_MXPA4_2 ny D VDD VDD pm1p2_svt_lp L=6e-08 W=3.15e-07
MI0_MXPA4_3 ny D VDD VDD pm1p2_svt_lp L=6e-08 W=3.15e-07
MI0_MXPA4_4 ny D VDD VDD pm1p2_svt_lp L=6e-08 W=3.15e-07
MI0_MXPA3 ny C VDD VDD pm1p2_svt_lp L=6e-08 W=3.15e-07
MI0_MXPA3_2 ny C VDD VDD pm1p2_svt_lp L=6e-08 W=3.15e-07
MI0_MXPA3_3 ny C VDD VDD pm1p2_svt_lp L=6e-08 W=3.15e-07
MI0_MXPA3_4 ny C VDD VDD pm1p2_svt_lp L=6e-08 W=3.15e-07
MI0_MXPA2 ny B VDD VDD pm1p2_svt_lp L=6e-08 W=3.15e-07
MI0_MXPA2_2 ny B VDD VDD pm1p2_svt_lp L=6e-08 W=3.15e-07
MI0_MXPA2_3 ny B VDD VDD pm1p2_svt_lp L=6e-08 W=3.15e-07
MI0_MXPA2_4 ny B VDD VDD pm1p2_svt_lp L=6e-08 W=3.15e-07
MI0_MXPA1 ny A VDD VDD pm1p2_svt_lp L=6e-08 W=3.15e-07
MI0_MXPA1_2 ny A VDD VDD pm1p2_svt_lp L=6e-08 W=3.15e-07
MI0_MXPA1_3 ny A VDD VDD pm1p2_svt_lp L=6e-08 W=3.15e-07
MI0_MXPA1_4 ny A VDD VDD pm1p2_svt_lp L=6e-08 W=3.15e-07
MI1_MXPA1 Y ny VDD VDD pm1p2_svt_lp L=6e-08 W=5.85e-07
MI1_MXPA1_2 Y ny VDD VDD pm1p2_svt_lp L=6e-08 W=5.85e-07
MI1_MXPA1_3 Y ny VDD VDD pm1p2_svt_lp L=6e-08 W=5.85e-07
MI1_MXPA1_4 Y ny VDD VDD pm1p2_svt_lp L=6e-08 W=5.85e-07
.ENDS

.SUBCKT AND4X6H9R Y VDD VSS A B C D
MI0_MXNA3_2 XI0_n2 C XI0_n1__2 VSS nm1p2_svt_lp L=6e-08 W=6.6e-07
MI0_MXNA4_2 XI0_n1__2 D VSS VSS nm1p2_svt_lp L=6e-08 W=6.6e-07
MI0_MXNA4_3 XI0_n1__3 D VSS VSS nm1p2_svt_lp L=6e-08 W=6.6e-07
MI0_MXNA3_3 XI0_n2 C XI0_n1__3 VSS nm1p2_svt_lp L=6e-08 W=6.6e-07
MI0_MXNA3_4 XI0_n2 C XI0_n1__4 VSS nm1p2_svt_lp L=6e-08 W=6.6e-07
MI0_MXNA4_4 XI0_n1__4 D VSS VSS nm1p2_svt_lp L=6e-08 W=6.6e-07
MI0_MXNA4_5 XI0_n1__5 D VSS VSS nm1p2_svt_lp L=6e-08 W=6.6e-07
MI0_MXNA3_5 XI0_n2 C XI0_n1__5 VSS nm1p2_svt_lp L=6e-08 W=6.6e-07
MI0_MXNA3_6 XI0_n2 C XI0_n1__6 VSS nm1p2_svt_lp L=6e-08 W=6.6e-07
MI0_MXNA4_6 XI0_n1__6 D VSS VSS nm1p2_svt_lp L=6e-08 W=6.6e-07
MI0_MXNA4 XI0_n1 D VSS VSS nm1p2_svt_lp L=6e-08 W=6.6e-07
MI0_MXNA3 XI0_n2 C XI0_n1 VSS nm1p2_svt_lp L=6e-08 W=6.6e-07
MI0_MXNA2_2 XI0_n3__2 B XI0_n2 VSS nm1p2_svt_lp L=6e-08 W=6.6e-07
MI0_MXNA1_2 ny A XI0_n3__2 VSS nm1p2_svt_lp L=6e-08 W=6.6e-07
MI0_MXNA1_3 ny A XI0_n3__3 VSS nm1p2_svt_lp L=6e-08 W=6.6e-07
MI0_MXNA2_3 XI0_n3__3 B XI0_n2 VSS nm1p2_svt_lp L=6e-08 W=6.6e-07
MI0_MXNA2_4 XI0_n3__4 B XI0_n2 VSS nm1p2_svt_lp L=6e-08 W=6.6e-07
MI0_MXNA1_4 ny A XI0_n3__4 VSS nm1p2_svt_lp L=6e-08 W=6.6e-07
MI0_MXNA1_5 ny A XI0_n3__5 VSS nm1p2_svt_lp L=6e-08 W=6.6e-07
MI0_MXNA2_5 XI0_n3__5 B XI0_n2 VSS nm1p2_svt_lp L=6e-08 W=6.6e-07
MI0_MXNA2_6 XI0_n3__6 B XI0_n2 VSS nm1p2_svt_lp L=6e-08 W=6.6e-07
MI0_MXNA1_6 ny A XI0_n3__6 VSS nm1p2_svt_lp L=6e-08 W=6.6e-07
MI0_MXNA1 ny A XI0_n3 VSS nm1p2_svt_lp L=6e-08 W=6.6e-07
MI0_MXNA2 XI0_n3 B XI0_n2 VSS nm1p2_svt_lp L=6e-08 W=6.6e-07
MI1_MXNA1 Y ny VSS VSS nm1p2_svt_lp L=6e-08 W=4.2e-07
MI1_MXNA1_2 Y ny VSS VSS nm1p2_svt_lp L=6e-08 W=4.2e-07
MI1_MXNA1_3 Y ny VSS VSS nm1p2_svt_lp L=6e-08 W=4.2e-07
MI1_MXNA1_4 Y ny VSS VSS nm1p2_svt_lp L=6e-08 W=4.2e-07
MI1_MXNA1_5 Y ny VSS VSS nm1p2_svt_lp L=6e-08 W=4.2e-07
MI1_MXNA1_6 Y ny VSS VSS nm1p2_svt_lp L=6e-08 W=4.2e-07
MI0_MXPA3 ny C VDD VDD pm1p2_svt_lp L=6e-08 W=3e-07
MI0_MXPA4 ny D VDD VDD pm1p2_svt_lp L=6e-08 W=3e-07
MI0_MXPA4_2 ny D VDD VDD pm1p2_svt_lp L=6e-08 W=3e-07
MI0_MXPA3_2 ny C VDD VDD pm1p2_svt_lp L=6e-08 W=3e-07
MI0_MXPA3_3 ny C VDD VDD pm1p2_svt_lp L=6e-08 W=3e-07
MI0_MXPA4_3 ny D VDD VDD pm1p2_svt_lp L=6e-08 W=3e-07
MI0_MXPA4_4 ny D VDD VDD pm1p2_svt_lp L=6e-08 W=3e-07
MI0_MXPA3_4 ny C VDD VDD pm1p2_svt_lp L=6e-08 W=3e-07
MI0_MXPA3_5 ny C VDD VDD pm1p2_svt_lp L=6e-08 W=3e-07
MI0_MXPA4_5 ny D VDD VDD pm1p2_svt_lp L=6e-08 W=3e-07
MI0_MXPA4_6 ny D VDD VDD pm1p2_svt_lp L=6e-08 W=3e-07
MI0_MXPA3_6 ny C VDD VDD pm1p2_svt_lp L=6e-08 W=3e-07
MI0_MXPA2 ny B VDD VDD pm1p2_svt_lp L=6e-08 W=3e-07
MI0_MXPA1 ny A VDD VDD pm1p2_svt_lp L=6e-08 W=3e-07
MI0_MXPA1_2 ny A VDD VDD pm1p2_svt_lp L=6e-08 W=3e-07
MI0_MXPA2_2 ny B VDD VDD pm1p2_svt_lp L=6e-08 W=3e-07
MI0_MXPA2_3 ny B VDD VDD pm1p2_svt_lp L=6e-08 W=3e-07
MI0_MXPA1_3 ny A VDD VDD pm1p2_svt_lp L=6e-08 W=3e-07
MI0_MXPA1_4 ny A VDD VDD pm1p2_svt_lp L=6e-08 W=3e-07
MI0_MXPA2_4 ny B VDD VDD pm1p2_svt_lp L=6e-08 W=3e-07
MI0_MXPA2_5 ny B VDD VDD pm1p2_svt_lp L=6e-08 W=3e-07
MI0_MXPA1_5 ny A VDD VDD pm1p2_svt_lp L=6e-08 W=3e-07
MI0_MXPA1_6 ny A VDD VDD pm1p2_svt_lp L=6e-08 W=3e-07
MI0_MXPA2_6 ny B VDD VDD pm1p2_svt_lp L=6e-08 W=3e-07
MI1_MXPA1 Y ny VDD VDD pm1p2_svt_lp L=6e-08 W=5.85e-07
MI1_MXPA1_2 Y ny VDD VDD pm1p2_svt_lp L=6e-08 W=5.85e-07
MI1_MXPA1_3 Y ny VDD VDD pm1p2_svt_lp L=6e-08 W=5.85e-07
MI1_MXPA1_4 Y ny VDD VDD pm1p2_svt_lp L=6e-08 W=5.85e-07
MI1_MXPA1_5 Y ny VDD VDD pm1p2_svt_lp L=6e-08 W=5.85e-07
MI1_MXPA1_6 Y ny VDD VDD pm1p2_svt_lp L=6e-08 W=5.85e-07
.ENDS

.SUBCKT AND4X8H9R Y VDD VSS A B C D
MI0_MXNA3_2 XI0_n2 C XI0_n1__2 VSS nm1p2_svt_lp L=6e-08 W=6.85e-07
MI0_MXNA4_2 XI0_n1__2 D VSS VSS nm1p2_svt_lp L=6e-08 W=6.85e-07
MI0_MXNA4_3 XI0_n1__3 D VSS VSS nm1p2_svt_lp L=6e-08 W=6.85e-07
MI0_MXNA3_3 XI0_n2 C XI0_n1__3 VSS nm1p2_svt_lp L=6e-08 W=6.85e-07
MI0_MXNA3_4 XI0_n2 C XI0_n1__4 VSS nm1p2_svt_lp L=6e-08 W=6.85e-07
MI0_MXNA4_4 XI0_n1__4 D VSS VSS nm1p2_svt_lp L=6e-08 W=6.85e-07
MI0_MXNA4_5 XI0_n1__5 D VSS VSS nm1p2_svt_lp L=6e-08 W=6.85e-07
MI0_MXNA3_5 XI0_n2 C XI0_n1__5 VSS nm1p2_svt_lp L=6e-08 W=6.85e-07
MI0_MXNA3_6 XI0_n2 C XI0_n1__6 VSS nm1p2_svt_lp L=6e-08 W=6.85e-07
MI0_MXNA4_6 XI0_n1__6 D VSS VSS nm1p2_svt_lp L=6e-08 W=6.85e-07
MI0_MXNA4_7 XI0_n1__7 D VSS VSS nm1p2_svt_lp L=6e-08 W=6.85e-07
MI0_MXNA3_7 XI0_n2 C XI0_n1__7 VSS nm1p2_svt_lp L=6e-08 W=6.85e-07
MI0_MXNA3_8 XI0_n2 C XI0_n1__8 VSS nm1p2_svt_lp L=6e-08 W=6.85e-07
MI0_MXNA4_8 XI0_n1__8 D VSS VSS nm1p2_svt_lp L=6e-08 W=6.85e-07
MI0_MXNA4 XI0_n1 D VSS VSS nm1p2_svt_lp L=6e-08 W=6.85e-07
MI0_MXNA3 XI0_n2 C XI0_n1 VSS nm1p2_svt_lp L=6e-08 W=6.85e-07
MI0_MXNA2_2 XI0_n3__2 B XI0_n2 VSS nm1p2_svt_lp L=6e-08 W=6.85e-07
MI0_MXNA1_2 ny A XI0_n3__2 VSS nm1p2_svt_lp L=6e-08 W=6.85e-07
MI0_MXNA1_3 ny A XI0_n3__3 VSS nm1p2_svt_lp L=6e-08 W=6.85e-07
MI0_MXNA2_3 XI0_n3__3 B XI0_n2 VSS nm1p2_svt_lp L=6e-08 W=6.85e-07
MI0_MXNA2_4 XI0_n3__4 B XI0_n2 VSS nm1p2_svt_lp L=6e-08 W=6.85e-07
MI0_MXNA1_4 ny A XI0_n3__4 VSS nm1p2_svt_lp L=6e-08 W=6.85e-07
MI0_MXNA1_5 ny A XI0_n3__5 VSS nm1p2_svt_lp L=6e-08 W=6.85e-07
MI0_MXNA2_5 XI0_n3__5 B XI0_n2 VSS nm1p2_svt_lp L=6e-08 W=6.85e-07
MI0_MXNA2_6 XI0_n3__6 B XI0_n2 VSS nm1p2_svt_lp L=6e-08 W=6.85e-07
MI0_MXNA1_6 ny A XI0_n3__6 VSS nm1p2_svt_lp L=6e-08 W=6.85e-07
MI0_MXNA1_7 ny A XI0_n3__7 VSS nm1p2_svt_lp L=6e-08 W=6.85e-07
MI0_MXNA2_7 XI0_n3__7 B XI0_n2 VSS nm1p2_svt_lp L=6e-08 W=6.85e-07
MI0_MXNA2_8 XI0_n3__8 B XI0_n2 VSS nm1p2_svt_lp L=6e-08 W=6.85e-07
MI0_MXNA1_8 ny A XI0_n3__8 VSS nm1p2_svt_lp L=6e-08 W=6.85e-07
MI0_MXNA1 ny A XI0_n3 VSS nm1p2_svt_lp L=6e-08 W=6.85e-07
MI0_MXNA2 XI0_n3 B XI0_n2 VSS nm1p2_svt_lp L=6e-08 W=6.85e-07
MI1_MXNA1 Y ny VSS VSS nm1p2_svt_lp L=6e-08 W=4.8e-07
MI1_MXNA1_2 Y ny VSS VSS nm1p2_svt_lp L=6e-08 W=4.8e-07
MI1_MXNA1_3 Y ny VSS VSS nm1p2_svt_lp L=6e-08 W=4.8e-07
MI1_MXNA1_4 Y ny VSS VSS nm1p2_svt_lp L=6e-08 W=4.8e-07
MI1_MXNA1_5 Y ny VSS VSS nm1p2_svt_lp L=6e-08 W=4.8e-07
MI1_MXNA1_6 Y ny VSS VSS nm1p2_svt_lp L=6e-08 W=4.8e-07
MI1_MXNA1_7 Y ny VSS VSS nm1p2_svt_lp L=6e-08 W=4.8e-07
MI0_MXPA3 ny C VDD VDD pm1p2_svt_lp L=6e-08 W=3.1e-07
MI0_MXPA4 ny D VDD VDD pm1p2_svt_lp L=6e-08 W=3.1e-07
MI0_MXPA4_2 ny D VDD VDD pm1p2_svt_lp L=6e-08 W=3.1e-07
MI0_MXPA3_2 ny C VDD VDD pm1p2_svt_lp L=6e-08 W=3.1e-07
MI0_MXPA3_3 ny C VDD VDD pm1p2_svt_lp L=6e-08 W=3.1e-07
MI0_MXPA4_3 ny D VDD VDD pm1p2_svt_lp L=6e-08 W=3.1e-07
MI0_MXPA4_4 ny D VDD VDD pm1p2_svt_lp L=6e-08 W=3.1e-07
MI0_MXPA3_4 ny C VDD VDD pm1p2_svt_lp L=6e-08 W=3.1e-07
MI0_MXPA3_5 ny C VDD VDD pm1p2_svt_lp L=6e-08 W=3.1e-07
MI0_MXPA4_5 ny D VDD VDD pm1p2_svt_lp L=6e-08 W=3.1e-07
MI0_MXPA4_6 ny D VDD VDD pm1p2_svt_lp L=6e-08 W=3.1e-07
MI0_MXPA3_6 ny C VDD VDD pm1p2_svt_lp L=6e-08 W=3.1e-07
MI0_MXPA3_7 ny C VDD VDD pm1p2_svt_lp L=6e-08 W=3.1e-07
MI0_MXPA4_7 ny D VDD VDD pm1p2_svt_lp L=6e-08 W=3.1e-07
MI0_MXPA4_8 ny D VDD VDD pm1p2_svt_lp L=6e-08 W=3.1e-07
MI0_MXPA3_8 ny C VDD VDD pm1p2_svt_lp L=6e-08 W=3.1e-07
MI0_MXPA2 ny B VDD VDD pm1p2_svt_lp L=6e-08 W=3.1e-07
MI0_MXPA1 ny A VDD VDD pm1p2_svt_lp L=6e-08 W=3.1e-07
MI0_MXPA1_2 ny A VDD VDD pm1p2_svt_lp L=6e-08 W=3.1e-07
MI0_MXPA2_2 ny B VDD VDD pm1p2_svt_lp L=6e-08 W=3.1e-07
MI0_MXPA2_3 ny B VDD VDD pm1p2_svt_lp L=6e-08 W=3.1e-07
MI0_MXPA1_3 ny A VDD VDD pm1p2_svt_lp L=6e-08 W=3.1e-07
MI0_MXPA1_4 ny A VDD VDD pm1p2_svt_lp L=6e-08 W=3.1e-07
MI0_MXPA2_4 ny B VDD VDD pm1p2_svt_lp L=6e-08 W=3.1e-07
MI0_MXPA2_5 ny B VDD VDD pm1p2_svt_lp L=6e-08 W=3.1e-07
MI0_MXPA1_5 ny A VDD VDD pm1p2_svt_lp L=6e-08 W=3.1e-07
MI0_MXPA1_6 ny A VDD VDD pm1p2_svt_lp L=6e-08 W=3.1e-07
MI0_MXPA2_6 ny B VDD VDD pm1p2_svt_lp L=6e-08 W=3.1e-07
MI0_MXPA2_7 ny B VDD VDD pm1p2_svt_lp L=6e-08 W=3.1e-07
MI0_MXPA1_7 ny A VDD VDD pm1p2_svt_lp L=6e-08 W=3.1e-07
MI0_MXPA1_8 ny A VDD VDD pm1p2_svt_lp L=6e-08 W=3.1e-07
MI0_MXPA2_8 ny B VDD VDD pm1p2_svt_lp L=6e-08 W=3.1e-07
MI1_MXPA1 Y ny VDD VDD pm1p2_svt_lp L=6e-08 W=5.85e-07
MI1_MXPA1_2 Y ny VDD VDD pm1p2_svt_lp L=6e-08 W=5.85e-07
MI1_MXPA1_3 Y ny VDD VDD pm1p2_svt_lp L=6e-08 W=5.85e-07
MI1_MXPA1_4 Y ny VDD VDD pm1p2_svt_lp L=6e-08 W=5.85e-07
MI1_MXPA1_5 Y ny VDD VDD pm1p2_svt_lp L=6e-08 W=5.85e-07
MI1_MXPA1_6 Y ny VDD VDD pm1p2_svt_lp L=6e-08 W=5.85e-07
MI1_MXPA1_7 Y ny VDD VDD pm1p2_svt_lp L=6e-08 W=5.85e-07
MI1_MXPA1_8 Y ny VDD VDD pm1p2_svt_lp L=6e-08 W=5.85e-07
.ENDS

.SUBCKT NOR2X0P5H9R Y VDD VSS A B
MI0_MXNA2 Y B VSS VSS nm1p2_svt_lp L=6e-08 W=1.5e-07
MI0_MXNA1 Y A VSS VSS nm1p2_svt_lp L=6e-08 W=1.5e-07
MI0_MXPA2 XI0_p1 B VDD VDD pm1p2_svt_lp L=6e-08 W=3.75e-07
MI0_MXPA1 Y A XI0_p1 VDD pm1p2_svt_lp L=6e-08 W=3.75e-07
.ENDS

.SUBCKT NOR2X0P7H9R Y VDD VSS A B
MI0_MXNA2 Y B VSS VSS nm1p2_svt_lp L=6e-08 W=1.65e-07
MI0_MXNA1 Y A VSS VSS nm1p2_svt_lp L=6e-08 W=1.65e-07
MI0_MXPA2 XI0_p1 B VDD VDD pm1p2_svt_lp L=6e-08 W=4.15e-07
MI0_MXPA1 Y A XI0_p1 VDD pm1p2_svt_lp L=6e-08 W=4.15e-07
.ENDS

.SUBCKT NOR2X1H9R Y VDD VSS A B
MI0_MXNA2 Y B VSS VSS nm1p2_svt_lp L=6e-08 W=2.35e-07
MI0_MXNA1 Y A VSS VSS nm1p2_svt_lp L=6e-08 W=2.35e-07
MI0_MXPA2 XI0_p1 B VDD VDD pm1p2_svt_lp L=6e-08 W=5.85e-07
MI0_MXPA1 Y A XI0_p1 VDD pm1p2_svt_lp L=6e-08 W=5.85e-07
.ENDS

.SUBCKT NOR2X1P4H9R Y VDD VSS A B
MI0_MXNA1 Y A VSS VSS nm1p2_svt_lp L=6e-08 W=3.3e-07
MI0_MXNA2 Y B VSS VSS nm1p2_svt_lp L=6e-08 W=3.3e-07
MI0_MXPA2_2 XI0_p1__2 B VDD VDD pm1p2_svt_lp L=6e-08 W=4.15e-07
MI0_MXPA1_2 Y A XI0_p1__2 VDD pm1p2_svt_lp L=6e-08 W=4.15e-07
MI0_MXPA1 Y A XI0_p1 VDD pm1p2_svt_lp L=6e-08 W=4.15e-07
MI0_MXPA2 XI0_p1 B VDD VDD pm1p2_svt_lp L=6e-08 W=4.15e-07
.ENDS

.SUBCKT NOR2X2H9R Y VDD VSS A B
MI0_MXNA2 Y B VSS VSS nm1p2_svt_lp L=6e-08 W=2.35e-07
MI0_MXNA1 Y A VSS VSS nm1p2_svt_lp L=6e-08 W=2.35e-07
MI0_MXNA1_2 Y A VSS VSS nm1p2_svt_lp L=6e-08 W=2.35e-07
MI0_MXNA2_2 Y B VSS VSS nm1p2_svt_lp L=6e-08 W=2.35e-07
MI0_MXPA2_2 XI0_p1__2 B VDD VDD pm1p2_svt_lp L=6e-08 W=5.85e-07
MI0_MXPA1_2 Y A XI0_p1__2 VDD pm1p2_svt_lp L=6e-08 W=5.85e-07
MI0_MXPA1 Y A XI0_p1 VDD pm1p2_svt_lp L=6e-08 W=5.85e-07
MI0_MXPA2 XI0_p1 B VDD VDD pm1p2_svt_lp L=6e-08 W=5.85e-07
.ENDS

.SUBCKT NOR2X3H9R Y VDD VSS A B
MI0_MXNA2 Y B VSS VSS nm1p2_svt_lp L=6e-08 W=3.55e-07
MI0_MXNA1 Y A VSS VSS nm1p2_svt_lp L=6e-08 W=3.55e-07
MI0_MXNA1_2 Y A VSS VSS nm1p2_svt_lp L=6e-08 W=3.55e-07
MI0_MXNA2_2 Y B VSS VSS nm1p2_svt_lp L=6e-08 W=3.55e-07
MI0_MXPA1_2 Y A XI0_p1__2 VDD pm1p2_svt_lp L=6e-08 W=5.85e-07
MI0_MXPA2_2 XI0_p1__2 B VDD VDD pm1p2_svt_lp L=6e-08 W=5.85e-07
MI0_MXPA2_3 XI0_p1__3 B VDD VDD pm1p2_svt_lp L=6e-08 W=5.85e-07
MI0_MXPA1_3 Y A XI0_p1__3 VDD pm1p2_svt_lp L=6e-08 W=5.85e-07
MI0_MXPA1 Y A XI0_p1 VDD pm1p2_svt_lp L=6e-08 W=5.85e-07
MI0_MXPA2 XI0_p1 B VDD VDD pm1p2_svt_lp L=6e-08 W=5.85e-07
.ENDS

.SUBCKT NOR2X4H9R Y VDD VSS A B
MI0_MXNA1 Y A VSS VSS nm1p2_svt_lp L=6e-08 W=3.15e-07
MI0_MXNA2 Y B VSS VSS nm1p2_svt_lp L=6e-08 W=3.15e-07
MI0_MXNA2_2 Y B VSS VSS nm1p2_svt_lp L=6e-08 W=3.15e-07
MI0_MXNA1_2 Y A VSS VSS nm1p2_svt_lp L=6e-08 W=3.15e-07
MI0_MXNA1_3 Y A VSS VSS nm1p2_svt_lp L=6e-08 W=3.15e-07
MI0_MXNA2_3 Y B VSS VSS nm1p2_svt_lp L=6e-08 W=3.15e-07
MI0_MXPA2_2 XI0_p1__2 B VDD VDD pm1p2_svt_lp L=6e-08 W=5.85e-07
MI0_MXPA1_2 Y A XI0_p1__2 VDD pm1p2_svt_lp L=6e-08 W=5.85e-07
MI0_MXPA1_3 Y A XI0_p1__3 VDD pm1p2_svt_lp L=6e-08 W=5.85e-07
MI0_MXPA2_3 XI0_p1__3 B VDD VDD pm1p2_svt_lp L=6e-08 W=5.85e-07
MI0_MXPA2_4 XI0_p1__4 B VDD VDD pm1p2_svt_lp L=6e-08 W=5.85e-07
MI0_MXPA1_4 Y A XI0_p1__4 VDD pm1p2_svt_lp L=6e-08 W=5.85e-07
MI0_MXPA1 Y A XI0_p1 VDD pm1p2_svt_lp L=6e-08 W=5.85e-07
MI0_MXPA2 XI0_p1 B VDD VDD pm1p2_svt_lp L=6e-08 W=5.85e-07
.ENDS

.SUBCKT NOR2X6H9R Y VDD VSS A B
MI0_MXNA2 Y B VSS VSS nm1p2_svt_lp L=6e-08 W=2.35e-07
MI0_MXNA1 Y A VSS VSS nm1p2_svt_lp L=6e-08 W=2.35e-07
MI0_MXNA1_2 Y A VSS VSS nm1p2_svt_lp L=6e-08 W=2.35e-07
MI0_MXNA2_2 Y B VSS VSS nm1p2_svt_lp L=6e-08 W=2.35e-07
MI0_MXNA2_3 Y B VSS VSS nm1p2_svt_lp L=6e-08 W=2.35e-07
MI0_MXNA1_3 Y A VSS VSS nm1p2_svt_lp L=6e-08 W=2.35e-07
MI0_MXNA1_4 Y A VSS VSS nm1p2_svt_lp L=6e-08 W=2.35e-07
MI0_MXNA2_4 Y B VSS VSS nm1p2_svt_lp L=6e-08 W=2.35e-07
MI0_MXNA2_5 Y B VSS VSS nm1p2_svt_lp L=6e-08 W=2.35e-07
MI0_MXNA1_5 Y A VSS VSS nm1p2_svt_lp L=6e-08 W=2.35e-07
MI0_MXNA1_6 Y A VSS VSS nm1p2_svt_lp L=6e-08 W=2.35e-07
MI0_MXNA2_6 Y B VSS VSS nm1p2_svt_lp L=6e-08 W=2.35e-07
MI0_MXPA2_2 XI0_p1__2 B VDD VDD pm1p2_svt_lp L=6e-08 W=5.85e-07
MI0_MXPA1_2 Y A XI0_p1__2 VDD pm1p2_svt_lp L=6e-08 W=5.85e-07
MI0_MXPA1_3 Y A XI0_p1__3 VDD pm1p2_svt_lp L=6e-08 W=5.85e-07
MI0_MXPA2_3 XI0_p1__3 B VDD VDD pm1p2_svt_lp L=6e-08 W=5.85e-07
MI0_MXPA2_4 XI0_p1__4 B VDD VDD pm1p2_svt_lp L=6e-08 W=5.85e-07
MI0_MXPA1_4 Y A XI0_p1__4 VDD pm1p2_svt_lp L=6e-08 W=5.85e-07
MI0_MXPA1_5 Y A XI0_p1__5 VDD pm1p2_svt_lp L=6e-08 W=5.85e-07
MI0_MXPA2_5 XI0_p1__5 B VDD VDD pm1p2_svt_lp L=6e-08 W=5.85e-07
MI0_MXPA2_6 XI0_p1__6 B VDD VDD pm1p2_svt_lp L=6e-08 W=5.85e-07
MI0_MXPA1_6 Y A XI0_p1__6 VDD pm1p2_svt_lp L=6e-08 W=5.85e-07
MI0_MXPA1 Y A XI0_p1 VDD pm1p2_svt_lp L=6e-08 W=5.85e-07
MI0_MXPA2 XI0_p1 B VDD VDD pm1p2_svt_lp L=6e-08 W=5.85e-07
.ENDS

.SUBCKT NOR2X8H9R Y VDD VSS A B
MI0_MXNA1 Y A VSS VSS nm1p2_svt_lp L=6e-08 W=2.7e-07
MI0_MXNA1_2 Y A VSS VSS nm1p2_svt_lp L=6e-08 W=2.7e-07
MI0_MXNA2 Y B VSS VSS nm1p2_svt_lp L=6e-08 W=2.7e-07
MI0_MXNA2_2 Y B VSS VSS nm1p2_svt_lp L=6e-08 W=2.7e-07
MI0_MXNA1_3 Y A VSS VSS nm1p2_svt_lp L=6e-08 W=2.7e-07
MI0_MXNA2_3 Y B VSS VSS nm1p2_svt_lp L=6e-08 W=2.7e-07
MI0_MXNA2_4 Y B VSS VSS nm1p2_svt_lp L=6e-08 W=2.7e-07
MI0_MXNA1_4 Y A VSS VSS nm1p2_svt_lp L=6e-08 W=2.7e-07
MI0_MXNA1_5 Y A VSS VSS nm1p2_svt_lp L=6e-08 W=2.7e-07
MI0_MXNA2_5 Y B VSS VSS nm1p2_svt_lp L=6e-08 W=2.7e-07
MI0_MXNA2_6 Y B VSS VSS nm1p2_svt_lp L=6e-08 W=2.7e-07
MI0_MXNA1_6 Y A VSS VSS nm1p2_svt_lp L=6e-08 W=2.7e-07
MI0_MXNA1_7 Y A VSS VSS nm1p2_svt_lp L=6e-08 W=2.7e-07
MI0_MXNA2_7 Y B VSS VSS nm1p2_svt_lp L=6e-08 W=2.7e-07
MI0_MXPA2_2 XI0_p1__2 B VDD VDD pm1p2_svt_lp L=6e-08 W=5.85e-07
MI0_MXPA1_2 Y A XI0_p1__2 VDD pm1p2_svt_lp L=6e-08 W=5.85e-07
MI0_MXPA1_3 Y A XI0_p1__3 VDD pm1p2_svt_lp L=6e-08 W=5.85e-07
MI0_MXPA2_3 XI0_p1__3 B VDD VDD pm1p2_svt_lp L=6e-08 W=5.85e-07
MI0_MXPA2_4 XI0_p1__4 B VDD VDD pm1p2_svt_lp L=6e-08 W=5.85e-07
MI0_MXPA1_4 Y A XI0_p1__4 VDD pm1p2_svt_lp L=6e-08 W=5.85e-07
MI0_MXPA1_5 Y A XI0_p1__5 VDD pm1p2_svt_lp L=6e-08 W=5.85e-07
MI0_MXPA2_5 XI0_p1__5 B VDD VDD pm1p2_svt_lp L=6e-08 W=5.85e-07
MI0_MXPA2_6 XI0_p1__6 B VDD VDD pm1p2_svt_lp L=6e-08 W=5.85e-07
MI0_MXPA1_6 Y A XI0_p1__6 VDD pm1p2_svt_lp L=6e-08 W=5.85e-07
MI0_MXPA1_7 Y A XI0_p1__7 VDD pm1p2_svt_lp L=6e-08 W=5.85e-07
MI0_MXPA2_7 XI0_p1__7 B VDD VDD pm1p2_svt_lp L=6e-08 W=5.85e-07
MI0_MXPA2_8 XI0_p1__8 B VDD VDD pm1p2_svt_lp L=6e-08 W=5.85e-07
MI0_MXPA1_8 Y A XI0_p1__8 VDD pm1p2_svt_lp L=6e-08 W=5.85e-07
MI0_MXPA1 Y A XI0_p1 VDD pm1p2_svt_lp L=6e-08 W=5.85e-07
MI0_MXPA2 XI0_p1 B VDD VDD pm1p2_svt_lp L=6e-08 W=5.85e-07
.ENDS

.SUBCKT NOR2BX0P5H9R Y VDD VSS AN B
MI0_MXNA1 a AN VSS VSS nm1p2_svt_lp L=6e-08 W=1.5e-07
MI1_MXNA2 Y B VSS VSS nm1p2_svt_lp L=6e-08 W=1.5e-07
MI1_MXNA1 Y a VSS VSS nm1p2_svt_lp L=6e-08 W=1.5e-07
MI0_MXPA1 a AN VDD VDD pm1p2_svt_lp L=6e-08 W=2.1e-07
MI1_MXPA2 XI1_p1 B VDD VDD pm1p2_svt_lp L=6e-08 W=3.75e-07
MI1_MXPA1 Y a XI1_p1 VDD pm1p2_svt_lp L=6e-08 W=3.75e-07
.ENDS

.SUBCKT NOR2BX0P7H9R Y VDD VSS AN B
MI0_MXNA1 a AN VSS VSS nm1p2_svt_lp L=6e-08 W=1.5e-07
MI1_MXNA2 Y B VSS VSS nm1p2_svt_lp L=6e-08 W=1.65e-07
MI1_MXNA1 Y a VSS VSS nm1p2_svt_lp L=6e-08 W=1.65e-07
MI0_MXPA1 a AN VDD VDD pm1p2_svt_lp L=6e-08 W=2.1e-07
MI1_MXPA2 XI1_p1 B VDD VDD pm1p2_svt_lp L=6e-08 W=4.15e-07
MI1_MXPA1 Y a XI1_p1 VDD pm1p2_svt_lp L=6e-08 W=4.15e-07
.ENDS

.SUBCKT NOR2BX1H9R Y VDD VSS AN B
MI0_MXNA1 a AN VSS VSS nm1p2_svt_lp L=6e-08 W=1.5e-07
MI1_MXNA2 Y B VSS VSS nm1p2_svt_lp L=6e-08 W=2.35e-07
MI1_MXNA1 Y a VSS VSS nm1p2_svt_lp L=6e-08 W=2.35e-07
MI0_MXPA1 a AN VDD VDD pm1p2_svt_lp L=6e-08 W=2.1e-07
MI1_MXPA2 XI1_p1 B VDD VDD pm1p2_svt_lp L=6e-08 W=5.85e-07
MI1_MXPA1 Y a XI1_p1 VDD pm1p2_svt_lp L=6e-08 W=5.85e-07
.ENDS

.SUBCKT NOR2BX1P4H9R Y VDD VSS AN B
MI0_MXNA1 a AN VSS VSS nm1p2_svt_lp L=6e-08 W=1.75e-07
MI1_MXNA2 Y B VSS VSS nm1p2_svt_lp L=6e-08 W=1.65e-07
MI1_MXNA1 Y a VSS VSS nm1p2_svt_lp L=6e-08 W=1.65e-07
MI1_MXNA1_2 Y a VSS VSS nm1p2_svt_lp L=6e-08 W=1.65e-07
MI1_MXNA2_2 Y B VSS VSS nm1p2_svt_lp L=6e-08 W=1.65e-07
MI0_MXPA1 a AN VDD VDD pm1p2_svt_lp L=6e-08 W=2.45e-07
MI1_MXPA2_2 XI1_p1__2 B VDD VDD pm1p2_svt_lp L=6e-08 W=4.15e-07
MI1_MXPA1_2 Y a XI1_p1__2 VDD pm1p2_svt_lp L=6e-08 W=4.15e-07
MI1_MXPA1 Y a XI1_p1 VDD pm1p2_svt_lp L=6e-08 W=4.15e-07
MI1_MXPA2 XI1_p1 B VDD VDD pm1p2_svt_lp L=6e-08 W=4.15e-07
.ENDS

.SUBCKT NOR2BX2H9R Y VDD VSS AN B
MI0_MXNA1 a AN VSS VSS nm1p2_svt_lp L=6e-08 W=2.25e-07
MI1_MXNA2 Y B VSS VSS nm1p2_svt_lp L=6e-08 W=2.35e-07
MI1_MXNA1 Y a VSS VSS nm1p2_svt_lp L=6e-08 W=2.35e-07
MI1_MXNA1_2 Y a VSS VSS nm1p2_svt_lp L=6e-08 W=2.35e-07
MI1_MXNA2_2 Y B VSS VSS nm1p2_svt_lp L=6e-08 W=2.35e-07
MI0_MXPA1 a AN VDD VDD pm1p2_svt_lp L=6e-08 W=3.15e-07
MI1_MXPA2_2 XI1_p1__2 B VDD VDD pm1p2_svt_lp L=6e-08 W=5.85e-07
MI1_MXPA1_2 Y a XI1_p1__2 VDD pm1p2_svt_lp L=6e-08 W=5.85e-07
MI1_MXPA1 Y a XI1_p1 VDD pm1p2_svt_lp L=6e-08 W=5.85e-07
MI1_MXPA2 XI1_p1 B VDD VDD pm1p2_svt_lp L=6e-08 W=5.85e-07
.ENDS

.SUBCKT NOR2BX3H9R Y VDD VSS AN B
MI0_MXNA1 a AN VSS VSS nm1p2_svt_lp L=6e-08 W=3.2e-07
MI1_MXNA2 Y B VSS VSS nm1p2_svt_lp L=6e-08 W=3.55e-07
MI1_MXNA1 Y a VSS VSS nm1p2_svt_lp L=6e-08 W=3.55e-07
MI1_MXNA1_2 Y a VSS VSS nm1p2_svt_lp L=6e-08 W=3.55e-07
MI1_MXNA2_2 Y B VSS VSS nm1p2_svt_lp L=6e-08 W=3.55e-07
MI0_MXPA1 a AN VDD VDD pm1p2_svt_lp L=6e-08 W=4.5e-07
MI1_MXPA2_2 XI1_p1__2 B VDD VDD pm1p2_svt_lp L=6e-08 W=5.85e-07
MI1_MXPA1_2 Y a XI1_p1__2 VDD pm1p2_svt_lp L=6e-08 W=5.85e-07
MI1_MXPA1_3 Y a XI1_p1__3 VDD pm1p2_svt_lp L=6e-08 W=5.85e-07
MI1_MXPA2_3 XI1_p1__3 B VDD VDD pm1p2_svt_lp L=6e-08 W=5.85e-07
MI1_MXPA2 XI1_p1 B VDD VDD pm1p2_svt_lp L=6e-08 W=5.85e-07
MI1_MXPA1 Y a XI1_p1 VDD pm1p2_svt_lp L=6e-08 W=5.85e-07
.ENDS

.SUBCKT NOR2BX4H9R Y VDD VSS AN B
MI0_MXNA1 a AN VSS VSS nm1p2_svt_lp L=6e-08 W=2.1e-07
MI0_MXNA1_2 a AN VSS VSS nm1p2_svt_lp L=6e-08 W=2.1e-07
MI1_MXNA2 Y B VSS VSS nm1p2_svt_lp L=6e-08 W=4.7e-07
MI1_MXNA1 Y a VSS VSS nm1p2_svt_lp L=6e-08 W=4.7e-07
MI1_MXNA1_2 Y a VSS VSS nm1p2_svt_lp L=6e-08 W=4.7e-07
MI1_MXNA2_2 Y B VSS VSS nm1p2_svt_lp L=6e-08 W=4.7e-07
MI0_MXPA1 a AN VDD VDD pm1p2_svt_lp L=6e-08 W=5.85e-07
MI1_MXPA2_2 XI1_p1__2 B VDD VDD pm1p2_svt_lp L=6e-08 W=5.85e-07
MI1_MXPA1_2 Y a XI1_p1__2 VDD pm1p2_svt_lp L=6e-08 W=5.85e-07
MI1_MXPA1_3 Y a XI1_p1__3 VDD pm1p2_svt_lp L=6e-08 W=5.85e-07
MI1_MXPA2_3 XI1_p1__3 B VDD VDD pm1p2_svt_lp L=6e-08 W=5.85e-07
MI1_MXPA2_4 XI1_p1__4 B VDD VDD pm1p2_svt_lp L=6e-08 W=5.85e-07
MI1_MXPA1_4 Y a XI1_p1__4 VDD pm1p2_svt_lp L=6e-08 W=5.85e-07
MI1_MXPA1 Y a XI1_p1 VDD pm1p2_svt_lp L=6e-08 W=5.85e-07
MI1_MXPA2 XI1_p1 B VDD VDD pm1p2_svt_lp L=6e-08 W=5.85e-07
.ENDS

.SUBCKT NOR2BX6H9R Y VDD VSS AN B
MI0_MXNA1 a AN VSS VSS nm1p2_svt_lp L=6e-08 W=3.2e-07
MI0_MXNA1_2 a AN VSS VSS nm1p2_svt_lp L=6e-08 W=3.2e-07
MI1_MXNA2 Y B VSS VSS nm1p2_svt_lp L=6e-08 W=3.55e-07
MI1_MXNA1 Y a VSS VSS nm1p2_svt_lp L=6e-08 W=3.55e-07
MI1_MXNA1_2 Y a VSS VSS nm1p2_svt_lp L=6e-08 W=3.55e-07
MI1_MXNA2_2 Y B VSS VSS nm1p2_svt_lp L=6e-08 W=3.55e-07
MI1_MXNA2_3 Y B VSS VSS nm1p2_svt_lp L=6e-08 W=3.55e-07
MI1_MXNA1_3 Y a VSS VSS nm1p2_svt_lp L=6e-08 W=3.55e-07
MI1_MXNA1_4 Y a VSS VSS nm1p2_svt_lp L=6e-08 W=3.55e-07
MI1_MXNA2_4 Y B VSS VSS nm1p2_svt_lp L=6e-08 W=3.55e-07
MI0_MXPA1 a AN VDD VDD pm1p2_svt_lp L=6e-08 W=4.45e-07
MI0_MXPA1_2 a AN VDD VDD pm1p2_svt_lp L=6e-08 W=4.45e-07
MI1_MXPA2_2 XI1_p1__2 B VDD VDD pm1p2_svt_lp L=6e-08 W=5.85e-07
MI1_MXPA1_2 Y a XI1_p1__2 VDD pm1p2_svt_lp L=6e-08 W=5.85e-07
MI1_MXPA1_3 Y a XI1_p1__3 VDD pm1p2_svt_lp L=6e-08 W=5.85e-07
MI1_MXPA2_3 XI1_p1__3 B VDD VDD pm1p2_svt_lp L=6e-08 W=5.85e-07
MI1_MXPA2_4 XI1_p1__4 B VDD VDD pm1p2_svt_lp L=6e-08 W=5.85e-07
MI1_MXPA1_4 Y a XI1_p1__4 VDD pm1p2_svt_lp L=6e-08 W=5.85e-07
MI1_MXPA1_5 Y a XI1_p1__5 VDD pm1p2_svt_lp L=6e-08 W=5.85e-07
MI1_MXPA2_5 XI1_p1__5 B VDD VDD pm1p2_svt_lp L=6e-08 W=5.85e-07
MI1_MXPA2_6 XI1_p1__6 B VDD VDD pm1p2_svt_lp L=6e-08 W=5.85e-07
MI1_MXPA1_6 Y a XI1_p1__6 VDD pm1p2_svt_lp L=6e-08 W=5.85e-07
MI1_MXPA1 Y a XI1_p1 VDD pm1p2_svt_lp L=6e-08 W=5.85e-07
MI1_MXPA2 XI1_p1 B VDD VDD pm1p2_svt_lp L=6e-08 W=5.85e-07
.ENDS

.SUBCKT NOR2BX8H9R Y VDD VSS AN B
MI0_MXNA1 a AN VSS VSS nm1p2_svt_lp L=6e-08 W=4.2e-07
MI0_MXNA1_2 a AN VSS VSS nm1p2_svt_lp L=6e-08 W=4.2e-07
MI1_MXNA2 Y B VSS VSS nm1p2_svt_lp L=6e-08 W=4.7e-07
MI1_MXNA1 Y a VSS VSS nm1p2_svt_lp L=6e-08 W=4.7e-07
MI1_MXNA1_2 Y a VSS VSS nm1p2_svt_lp L=6e-08 W=4.7e-07
MI1_MXNA2_2 Y B VSS VSS nm1p2_svt_lp L=6e-08 W=4.7e-07
MI1_MXNA1_3 Y a VSS VSS nm1p2_svt_lp L=6e-08 W=4.7e-07
MI1_MXNA1_4 Y a VSS VSS nm1p2_svt_lp L=6e-08 W=4.7e-07
MI1_MXNA2_3 Y B VSS VSS nm1p2_svt_lp L=6e-08 W=4.7e-07
MI1_MXNA2_4 Y B VSS VSS nm1p2_svt_lp L=6e-08 W=4.7e-07
MI0_MXPA1 a AN VDD VDD pm1p2_svt_lp L=6e-08 W=5.85e-07
MI0_MXPA1_2 a AN VDD VDD pm1p2_svt_lp L=6e-08 W=5.85e-07
MI1_MXPA2_2 XI1_p1__2 B VDD VDD pm1p2_svt_lp L=6e-08 W=5.85e-07
MI1_MXPA1_2 Y a XI1_p1__2 VDD pm1p2_svt_lp L=6e-08 W=5.85e-07
MI1_MXPA1_3 Y a XI1_p1__3 VDD pm1p2_svt_lp L=6e-08 W=5.85e-07
MI1_MXPA2_3 XI1_p1__3 B VDD VDD pm1p2_svt_lp L=6e-08 W=5.85e-07
MI1_MXPA2_4 XI1_p1__4 B VDD VDD pm1p2_svt_lp L=6e-08 W=5.85e-07
MI1_MXPA1_4 Y a XI1_p1__4 VDD pm1p2_svt_lp L=6e-08 W=5.85e-07
MI1_MXPA1_5 Y a XI1_p1__5 VDD pm1p2_svt_lp L=6e-08 W=5.85e-07
MI1_MXPA2_5 XI1_p1__5 B VDD VDD pm1p2_svt_lp L=6e-08 W=5.85e-07
MI1_MXPA2_6 XI1_p1__6 B VDD VDD pm1p2_svt_lp L=6e-08 W=5.85e-07
MI1_MXPA1_6 Y a XI1_p1__6 VDD pm1p2_svt_lp L=6e-08 W=5.85e-07
MI1_MXPA1_7 Y a XI1_p1__7 VDD pm1p2_svt_lp L=6e-08 W=5.85e-07
MI1_MXPA2_7 XI1_p1__7 B VDD VDD pm1p2_svt_lp L=6e-08 W=5.85e-07
MI1_MXPA2_8 XI1_p1__8 B VDD VDD pm1p2_svt_lp L=6e-08 W=5.85e-07
MI1_MXPA1_8 Y a XI1_p1__8 VDD pm1p2_svt_lp L=6e-08 W=5.85e-07
MI1_MXPA1 Y a XI1_p1 VDD pm1p2_svt_lp L=6e-08 W=5.85e-07
MI1_MXPA2 XI1_p1 B VDD VDD pm1p2_svt_lp L=6e-08 W=5.85e-07
.ENDS

.SUBCKT NOR2XBX0P5H9R Y VDD VSS A BN
MI0_MXNA1 b BN VSS VSS nm1p2_svt_lp L=6e-08 W=1.5e-07
MI1_MXNA2 Y b VSS VSS nm1p2_svt_lp L=6e-08 W=1.5e-07
MI1_MXNA1 Y A VSS VSS nm1p2_svt_lp L=6e-08 W=1.5e-07
MI0_MXPA1 b BN VDD VDD pm1p2_svt_lp L=6e-08 W=2.1e-07
MI1_MXPA2 XI1_p1 b VDD VDD pm1p2_svt_lp L=6e-08 W=3.75e-07
MI1_MXPA1 Y A XI1_p1 VDD pm1p2_svt_lp L=6e-08 W=3.75e-07
.ENDS

.SUBCKT NOR2XBX0P7H9R Y VDD VSS A BN
MI0_MXNA1 b BN VSS VSS nm1p2_svt_lp L=6e-08 W=1.5e-07
MI1_MXNA2 Y b VSS VSS nm1p2_svt_lp L=6e-08 W=1.65e-07
MI1_MXNA1 Y A VSS VSS nm1p2_svt_lp L=6e-08 W=1.65e-07
MI0_MXPA1 b BN VDD VDD pm1p2_svt_lp L=6e-08 W=2.1e-07
MI1_MXPA2 XI1_p1 b VDD VDD pm1p2_svt_lp L=6e-08 W=4.15e-07
MI1_MXPA1 Y A XI1_p1 VDD pm1p2_svt_lp L=6e-08 W=4.15e-07
.ENDS

.SUBCKT NOR2XBX1H9R Y VDD VSS A BN
MI0_MXNA1 b BN VSS VSS nm1p2_svt_lp L=6e-08 W=1.5e-07
MI1_MXNA2 Y b VSS VSS nm1p2_svt_lp L=6e-08 W=2.35e-07
MI1_MXNA1 Y A VSS VSS nm1p2_svt_lp L=6e-08 W=2.35e-07
MI0_MXPA1 b BN VDD VDD pm1p2_svt_lp L=6e-08 W=2.1e-07
MI1_MXPA2 XI1_p1 b VDD VDD pm1p2_svt_lp L=6e-08 W=5.85e-07
MI1_MXPA1 Y A XI1_p1 VDD pm1p2_svt_lp L=6e-08 W=5.85e-07
.ENDS

.SUBCKT NOR2XBX1P4H9R Y VDD VSS A BN
MI0_MXNA1 b BN VSS VSS nm1p2_svt_lp L=6e-08 W=1.75e-07
MI1_MXNA2 Y b VSS VSS nm1p2_svt_lp L=6e-08 W=1.65e-07
MI1_MXNA1 Y A VSS VSS nm1p2_svt_lp L=6e-08 W=1.65e-07
MI1_MXNA1_2 Y A VSS VSS nm1p2_svt_lp L=6e-08 W=1.65e-07
MI1_MXNA2_2 Y b VSS VSS nm1p2_svt_lp L=6e-08 W=1.65e-07
MI0_MXPA1 b BN VDD VDD pm1p2_svt_lp L=6e-08 W=2.45e-07
MI1_MXPA2_2 XI1_p1__2 b VDD VDD pm1p2_svt_lp L=6e-08 W=4.15e-07
MI1_MXPA1_2 Y A XI1_p1__2 VDD pm1p2_svt_lp L=6e-08 W=4.15e-07
MI1_MXPA1 Y A XI1_p1 VDD pm1p2_svt_lp L=6e-08 W=4.15e-07
MI1_MXPA2 XI1_p1 b VDD VDD pm1p2_svt_lp L=6e-08 W=4.15e-07
.ENDS

.SUBCKT NOR2XBX2H9R Y VDD VSS A BN
MI0_MXNA1 b BN VSS VSS nm1p2_svt_lp L=6e-08 W=2.25e-07
MI1_MXNA2 Y b VSS VSS nm1p2_svt_lp L=6e-08 W=2.35e-07
MI1_MXNA1 Y A VSS VSS nm1p2_svt_lp L=6e-08 W=2.35e-07
MI1_MXNA1_2 Y A VSS VSS nm1p2_svt_lp L=6e-08 W=2.35e-07
MI1_MXNA2_2 Y b VSS VSS nm1p2_svt_lp L=6e-08 W=2.35e-07
MI0_MXPA1 b BN VDD VDD pm1p2_svt_lp L=6e-08 W=3.15e-07
MI1_MXPA2_2 XI1_p1__2 b VDD VDD pm1p2_svt_lp L=6e-08 W=5.85e-07
MI1_MXPA1_2 Y A XI1_p1__2 VDD pm1p2_svt_lp L=6e-08 W=5.85e-07
MI1_MXPA1 Y A XI1_p1 VDD pm1p2_svt_lp L=6e-08 W=5.85e-07
MI1_MXPA2 XI1_p1 b VDD VDD pm1p2_svt_lp L=6e-08 W=5.85e-07
.ENDS

.SUBCKT NOR2XBX3H9R Y VDD VSS A BN
MI0_MXNA1 b BN VSS VSS nm1p2_svt_lp L=6e-08 W=3.2e-07
MI1_MXNA2 Y b VSS VSS nm1p2_svt_lp L=6e-08 W=3.55e-07
MI1_MXNA1 Y A VSS VSS nm1p2_svt_lp L=6e-08 W=3.55e-07
MI1_MXNA1_2 Y A VSS VSS nm1p2_svt_lp L=6e-08 W=3.55e-07
MI1_MXNA2_2 Y b VSS VSS nm1p2_svt_lp L=6e-08 W=3.55e-07
MI0_MXPA1 b BN VDD VDD pm1p2_svt_lp L=6e-08 W=4.5e-07
MI1_MXPA2_2 XI1_p1__2 b VDD VDD pm1p2_svt_lp L=6e-08 W=5.85e-07
MI1_MXPA1_2 Y A XI1_p1__2 VDD pm1p2_svt_lp L=6e-08 W=5.85e-07
MI1_MXPA1_3 Y A XI1_p1__3 VDD pm1p2_svt_lp L=6e-08 W=5.85e-07
MI1_MXPA2_3 XI1_p1__3 b VDD VDD pm1p2_svt_lp L=6e-08 W=5.85e-07
MI1_MXPA2 XI1_p1 b VDD VDD pm1p2_svt_lp L=6e-08 W=5.85e-07
MI1_MXPA1 Y A XI1_p1 VDD pm1p2_svt_lp L=6e-08 W=5.85e-07
.ENDS

.SUBCKT NOR2XBX4H9R Y VDD VSS A BN
MI0_MXNA1 b BN VSS VSS nm1p2_svt_lp L=6e-08 W=4.2e-07
MI1_MXNA2 Y b VSS VSS nm1p2_svt_lp L=6e-08 W=4.7e-07
MI1_MXNA2_2 Y b VSS VSS nm1p2_svt_lp L=6e-08 W=4.7e-07
MI1_MXNA1 Y A VSS VSS nm1p2_svt_lp L=6e-08 W=4.7e-07
MI1_MXNA1_2 Y A VSS VSS nm1p2_svt_lp L=6e-08 W=4.7e-07
MI0_MXPA1 b BN VDD VDD pm1p2_svt_lp L=6e-08 W=5.85e-07
MI1_MXPA2_2 XI1_p1__2 b VDD VDD pm1p2_svt_lp L=6e-08 W=5.85e-07
MI1_MXPA1_2 Y A XI1_p1__2 VDD pm1p2_svt_lp L=6e-08 W=5.85e-07
MI1_MXPA1_3 Y A XI1_p1__3 VDD pm1p2_svt_lp L=6e-08 W=5.85e-07
MI1_MXPA2_3 XI1_p1__3 b VDD VDD pm1p2_svt_lp L=6e-08 W=5.85e-07
MI1_MXPA2_4 XI1_p1__4 b VDD VDD pm1p2_svt_lp L=6e-08 W=5.85e-07
MI1_MXPA1_4 Y A XI1_p1__4 VDD pm1p2_svt_lp L=6e-08 W=5.85e-07
MI1_MXPA1 Y A XI1_p1 VDD pm1p2_svt_lp L=6e-08 W=5.85e-07
MI1_MXPA2 XI1_p1 b VDD VDD pm1p2_svt_lp L=6e-08 W=5.85e-07
.ENDS

.SUBCKT NOR2XBX6H9R Y VDD VSS A BN
MI0_MXNA1 b BN VSS VSS nm1p2_svt_lp L=6e-08 W=3.2e-07
MI0_MXNA1_2 b BN VSS VSS nm1p2_svt_lp L=6e-08 W=3.2e-07
MI1_MXNA1 Y A VSS VSS nm1p2_svt_lp L=6e-08 W=4.7e-07
MI1_MXNA1_2 Y A VSS VSS nm1p2_svt_lp L=6e-08 W=4.7e-07
MI1_MXNA2 Y b VSS VSS nm1p2_svt_lp L=6e-08 W=4.7e-07
MI1_MXNA1_3 Y A VSS VSS nm1p2_svt_lp L=6e-08 W=4.7e-07
MI1_MXNA2_2 Y b VSS VSS nm1p2_svt_lp L=6e-08 W=4.7e-07
MI1_MXNA2_3 Y b VSS VSS nm1p2_svt_lp L=6e-08 W=4.7e-07
MI0_MXPA1 b BN VDD VDD pm1p2_svt_lp L=6e-08 W=4.45e-07
MI0_MXPA1_2 b BN VDD VDD pm1p2_svt_lp L=6e-08 W=4.45e-07
MI1_MXPA2_2 XI1_p1__2 b VDD VDD pm1p2_svt_lp L=6e-08 W=5.85e-07
MI1_MXPA1_2 Y A XI1_p1__2 VDD pm1p2_svt_lp L=6e-08 W=5.85e-07
MI1_MXPA1_3 Y A XI1_p1__3 VDD pm1p2_svt_lp L=6e-08 W=5.85e-07
MI1_MXPA2_3 XI1_p1__3 b VDD VDD pm1p2_svt_lp L=6e-08 W=5.85e-07
MI1_MXPA2_4 XI1_p1__4 b VDD VDD pm1p2_svt_lp L=6e-08 W=5.85e-07
MI1_MXPA1_4 Y A XI1_p1__4 VDD pm1p2_svt_lp L=6e-08 W=5.85e-07
MI1_MXPA1_5 Y A XI1_p1__5 VDD pm1p2_svt_lp L=6e-08 W=5.85e-07
MI1_MXPA2_5 XI1_p1__5 b VDD VDD pm1p2_svt_lp L=6e-08 W=5.85e-07
MI1_MXPA2_6 XI1_p1__6 b VDD VDD pm1p2_svt_lp L=6e-08 W=5.85e-07
MI1_MXPA1_6 Y A XI1_p1__6 VDD pm1p2_svt_lp L=6e-08 W=5.85e-07
MI1_MXPA1 Y A XI1_p1 VDD pm1p2_svt_lp L=6e-08 W=5.85e-07
MI1_MXPA2 XI1_p1 b VDD VDD pm1p2_svt_lp L=6e-08 W=5.85e-07
.ENDS

.SUBCKT NOR2XBX8H9R Y VDD VSS A BN
MI0_MXNA1 b BN VSS VSS nm1p2_svt_lp L=6e-08 W=4.2e-07
MI0_MXNA1_2 b BN VSS VSS nm1p2_svt_lp L=6e-08 W=4.2e-07
MI1_MXNA2 Y b VSS VSS nm1p2_svt_lp L=6e-08 W=4.7e-07
MI1_MXNA1 Y A VSS VSS nm1p2_svt_lp L=6e-08 W=4.7e-07
MI1_MXNA1_2 Y A VSS VSS nm1p2_svt_lp L=6e-08 W=4.7e-07
MI1_MXNA2_2 Y b VSS VSS nm1p2_svt_lp L=6e-08 W=4.7e-07
MI1_MXNA1_3 Y A VSS VSS nm1p2_svt_lp L=6e-08 W=4.7e-07
MI1_MXNA1_4 Y A VSS VSS nm1p2_svt_lp L=6e-08 W=4.7e-07
MI1_MXNA2_3 Y b VSS VSS nm1p2_svt_lp L=6e-08 W=4.7e-07
MI1_MXNA2_4 Y b VSS VSS nm1p2_svt_lp L=6e-08 W=4.7e-07
MI0_MXPA1 b BN VDD VDD pm1p2_svt_lp L=6e-08 W=5.85e-07
MI0_MXPA1_2 b BN VDD VDD pm1p2_svt_lp L=6e-08 W=5.85e-07
MI1_MXPA2_2 XI1_p1__2 b VDD VDD pm1p2_svt_lp L=6e-08 W=5.85e-07
MI1_MXPA1_2 Y A XI1_p1__2 VDD pm1p2_svt_lp L=6e-08 W=5.85e-07
MI1_MXPA1_3 Y A XI1_p1__3 VDD pm1p2_svt_lp L=6e-08 W=5.85e-07
MI1_MXPA2_3 XI1_p1__3 b VDD VDD pm1p2_svt_lp L=6e-08 W=5.85e-07
MI1_MXPA2_4 XI1_p1__4 b VDD VDD pm1p2_svt_lp L=6e-08 W=5.85e-07
MI1_MXPA1_4 Y A XI1_p1__4 VDD pm1p2_svt_lp L=6e-08 W=5.85e-07
MI1_MXPA1_5 Y A XI1_p1__5 VDD pm1p2_svt_lp L=6e-08 W=5.85e-07
MI1_MXPA2_5 XI1_p1__5 b VDD VDD pm1p2_svt_lp L=6e-08 W=5.85e-07
MI1_MXPA2_6 XI1_p1__6 b VDD VDD pm1p2_svt_lp L=6e-08 W=5.85e-07
MI1_MXPA1_6 Y A XI1_p1__6 VDD pm1p2_svt_lp L=6e-08 W=5.85e-07
MI1_MXPA1_7 Y A XI1_p1__7 VDD pm1p2_svt_lp L=6e-08 W=5.85e-07
MI1_MXPA2_7 XI1_p1__7 b VDD VDD pm1p2_svt_lp L=6e-08 W=5.85e-07
MI1_MXPA2_8 XI1_p1__8 b VDD VDD pm1p2_svt_lp L=6e-08 W=5.85e-07
MI1_MXPA1_8 Y A XI1_p1__8 VDD pm1p2_svt_lp L=6e-08 W=5.85e-07
MI1_MXPA1 Y A XI1_p1 VDD pm1p2_svt_lp L=6e-08 W=5.85e-07
MI1_MXPA2 XI1_p1 b VDD VDD pm1p2_svt_lp L=6e-08 W=5.85e-07
.ENDS

.SUBCKT NOR3X0P5H9R Y VDD VSS A B C
MI0_MXNA3 Y C VSS VSS nm1p2_svt_lp L=6e-08 W=1.5e-07
MI0_MXNA2 Y B VSS VSS nm1p2_svt_lp L=6e-08 W=1.5e-07
MI0_MXNA1 Y A VSS VSS nm1p2_svt_lp L=6e-08 W=1.5e-07
MI0_MXPA3 XI0_p1 C VDD VDD pm1p2_svt_lp L=6e-08 W=2.95e-07
MI0_MXPA2 XI0_p2 B XI0_p1 VDD pm1p2_svt_lp L=6e-08 W=2.95e-07
MI0_MXPA1 Y A XI0_p2 VDD pm1p2_svt_lp L=6e-08 W=2.95e-07
.ENDS

.SUBCKT NOR3X0P7H9R Y VDD VSS A B C
MI0_MXNA3 Y C VSS VSS nm1p2_svt_lp L=6e-08 W=1.5e-07
MI0_MXNA2 Y B VSS VSS nm1p2_svt_lp L=6e-08 W=1.5e-07
MI0_MXNA1 Y A VSS VSS nm1p2_svt_lp L=6e-08 W=1.5e-07
MI0_MXPA3 XI0_p1 C VDD VDD pm1p2_svt_lp L=6e-08 W=5.25e-07
MI0_MXPA2 XI0_p2 B XI0_p1 VDD pm1p2_svt_lp L=6e-08 W=5.25e-07
MI0_MXPA1 Y A XI0_p2 VDD pm1p2_svt_lp L=6e-08 W=5.25e-07
.ENDS

.SUBCKT NOR3X1H9R Y VDD VSS A B C
MI0_MXNA3 Y C VSS VSS nm1p2_svt_lp L=6e-08 W=1.65e-07
MI0_MXNA2 Y B VSS VSS nm1p2_svt_lp L=6e-08 W=1.65e-07
MI0_MXNA1 Y A VSS VSS nm1p2_svt_lp L=6e-08 W=1.65e-07
MI0_MXPA3 XI0_p1 C VDD VDD pm1p2_svt_lp L=6e-08 W=5.85e-07
MI0_MXPA2 XI0_p2 B XI0_p1 VDD pm1p2_svt_lp L=6e-08 W=5.85e-07
MI0_MXPA1 Y A XI0_p2 VDD pm1p2_svt_lp L=6e-08 W=5.85e-07
.ENDS

.SUBCKT NOR3X1P4H9R Y VDD VSS A B C
MI0_MXNA1 Y A VSS VSS nm1p2_svt_lp L=6e-08 W=2.4e-07
MI0_MXNA2 Y B VSS VSS nm1p2_svt_lp L=6e-08 W=2.4e-07
MI0_MXNA3 Y C VSS VSS nm1p2_svt_lp L=6e-08 W=2.4e-07
MI0_MXPA3_2 XI0_p1__2 C VDD VDD pm1p2_svt_lp L=6e-08 W=4.15e-07
MI0_MXPA2_2 XI0_p2__2 B XI0_p1__2 VDD pm1p2_svt_lp L=6e-08 W=4.15e-07
MI0_MXPA1_2 Y A XI0_p2__2 VDD pm1p2_svt_lp L=6e-08 W=4.15e-07
MI0_MXPA1 Y A XI0_p2 VDD pm1p2_svt_lp L=6e-08 W=4.15e-07
MI0_MXPA2 XI0_p2 B XI0_p1 VDD pm1p2_svt_lp L=6e-08 W=4.15e-07
MI0_MXPA3 XI0_p1 C VDD VDD pm1p2_svt_lp L=6e-08 W=4.15e-07
.ENDS

.SUBCKT NOR3X2H9R Y VDD VSS A B C
MI0_MXNA3 Y C VSS VSS nm1p2_svt_lp L=6e-08 W=1.65e-07
MI0_MXNA3_2 Y C VSS VSS nm1p2_svt_lp L=6e-08 W=1.65e-07
MI0_MXNA2 Y B VSS VSS nm1p2_svt_lp L=6e-08 W=1.65e-07
MI0_MXNA1 Y A VSS VSS nm1p2_svt_lp L=6e-08 W=1.65e-07
MI0_MXNA1_2 Y A VSS VSS nm1p2_svt_lp L=6e-08 W=1.65e-07
MI0_MXNA2_2 Y B VSS VSS nm1p2_svt_lp L=6e-08 W=1.65e-07
MI0_MXPA3 XI0_p1 C VDD VDD pm1p2_svt_lp L=6e-08 W=5.85e-07
MI0_MXPA3_2 XI0_p1 C VDD VDD pm1p2_svt_lp L=6e-08 W=5.85e-07
MI0_MXPA2_2 XI0_p2__2 B XI0_p1 VDD pm1p2_svt_lp L=6e-08 W=5.85e-07
MI0_MXPA1_2 Y A XI0_p2__2 VDD pm1p2_svt_lp L=6e-08 W=5.85e-07
MI0_MXPA1 Y A XI0_p2 VDD pm1p2_svt_lp L=6e-08 W=5.85e-07
MI0_MXPA2 XI0_p2 B XI0_p1 VDD pm1p2_svt_lp L=6e-08 W=5.85e-07
.ENDS

.SUBCKT NOR3X3H9R Y VDD VSS A B C
MI0_MXNA3 Y C VSS VSS nm1p2_svt_lp L=6e-08 W=1.65e-07
MI0_MXNA3_2 Y C VSS VSS nm1p2_svt_lp L=6e-08 W=1.65e-07
MI0_MXNA3_3 Y C VSS VSS nm1p2_svt_lp L=6e-08 W=1.65e-07
MI0_MXNA2 Y B VSS VSS nm1p2_svt_lp L=6e-08 W=1.65e-07
MI0_MXNA1 Y A VSS VSS nm1p2_svt_lp L=6e-08 W=1.65e-07
MI0_MXNA1_2 Y A VSS VSS nm1p2_svt_lp L=6e-08 W=1.65e-07
MI0_MXNA2_2 Y B VSS VSS nm1p2_svt_lp L=6e-08 W=1.65e-07
MI0_MXNA2_3 Y B VSS VSS nm1p2_svt_lp L=6e-08 W=1.65e-07
MI0_MXNA1_3 Y A VSS VSS nm1p2_svt_lp L=6e-08 W=1.65e-07
MI0_MXPA3 XI0_p1 C VDD VDD pm1p2_svt_lp L=6e-08 W=5.85e-07
MI0_MXPA3_2 XI0_p1 C VDD VDD pm1p2_svt_lp L=6e-08 W=5.85e-07
MI0_MXPA3_3 XI0_p1 C VDD VDD pm1p2_svt_lp L=6e-08 W=5.85e-07
MI0_MXPA2_2 XI0_p2__2 B XI0_p1 VDD pm1p2_svt_lp L=6e-08 W=5.85e-07
MI0_MXPA1_2 Y A XI0_p2__2 VDD pm1p2_svt_lp L=6e-08 W=5.85e-07
MI0_MXPA1_3 Y A XI0_p2__3 VDD pm1p2_svt_lp L=6e-08 W=5.85e-07
MI0_MXPA2_3 XI0_p2__3 B XI0_p1 VDD pm1p2_svt_lp L=6e-08 W=5.85e-07
MI0_MXPA2 XI0_p2 B XI0_p1 VDD pm1p2_svt_lp L=6e-08 W=5.85e-07
MI0_MXPA1 Y A XI0_p2 VDD pm1p2_svt_lp L=6e-08 W=5.85e-07
.ENDS

.SUBCKT NOR3X4H9R Y VDD VSS A B C
MI0_MXNA3 Y C VSS VSS nm1p2_svt_lp L=6e-08 W=2.2e-07
MI0_MXNA3_2 Y C VSS VSS nm1p2_svt_lp L=6e-08 W=2.2e-07
MI0_MXNA3_3 Y C VSS VSS nm1p2_svt_lp L=6e-08 W=2.2e-07
MI0_MXNA2 Y B VSS VSS nm1p2_svt_lp L=6e-08 W=2.2e-07
MI0_MXNA1 Y A VSS VSS nm1p2_svt_lp L=6e-08 W=2.2e-07
MI0_MXNA1_2 Y A VSS VSS nm1p2_svt_lp L=6e-08 W=2.2e-07
MI0_MXNA2_2 Y B VSS VSS nm1p2_svt_lp L=6e-08 W=2.2e-07
MI0_MXNA2_3 Y B VSS VSS nm1p2_svt_lp L=6e-08 W=2.2e-07
MI0_MXNA1_3 Y A VSS VSS nm1p2_svt_lp L=6e-08 W=2.2e-07
MI0_MXPA3 XI0_p1 C VDD VDD pm1p2_svt_lp L=6e-08 W=5.85e-07
MI0_MXPA3_2 XI0_p1 C VDD VDD pm1p2_svt_lp L=6e-08 W=5.85e-07
MI0_MXPA3_3 XI0_p1 C VDD VDD pm1p2_svt_lp L=6e-08 W=5.85e-07
MI0_MXPA3_4 XI0_p1 C VDD VDD pm1p2_svt_lp L=6e-08 W=5.85e-07
MI0_MXPA2_2 XI0_p2__2 B XI0_p1 VDD pm1p2_svt_lp L=6e-08 W=5.85e-07
MI0_MXPA1_2 Y A XI0_p2__2 VDD pm1p2_svt_lp L=6e-08 W=5.85e-07
MI0_MXPA1_3 Y A XI0_p2__3 VDD pm1p2_svt_lp L=6e-08 W=5.85e-07
MI0_MXPA2_3 XI0_p2__3 B XI0_p1 VDD pm1p2_svt_lp L=6e-08 W=5.85e-07
MI0_MXPA2_4 XI0_p2__4 B XI0_p1 VDD pm1p2_svt_lp L=6e-08 W=5.85e-07
MI0_MXPA1_4 Y A XI0_p2__4 VDD pm1p2_svt_lp L=6e-08 W=5.85e-07
MI0_MXPA1 Y A XI0_p2 VDD pm1p2_svt_lp L=6e-08 W=5.85e-07
MI0_MXPA2 XI0_p2 B XI0_p1 VDD pm1p2_svt_lp L=6e-08 W=5.85e-07
.ENDS

.SUBCKT OR2X0P5H9R Y VDD VSS A B
MI0_MXNA1 ny A VSS VSS nm1p2_svt_lp L=6e-08 W=1.5e-07
MI0_MXNA2 ny B VSS VSS nm1p2_svt_lp L=6e-08 W=1.5e-07
MI1_MXNA1 Y ny VSS VSS nm1p2_svt_lp L=6e-08 W=2.1e-07
MI0_MXPA1 ny A XI0_p1 VDD pm1p2_svt_lp L=6e-08 W=3.9e-07
MI0_MXPA2 XI0_p1 B VDD VDD pm1p2_svt_lp L=6e-08 W=3.9e-07
MI1_MXPA1 Y ny VDD VDD pm1p2_svt_lp L=6e-08 W=2.95e-07
.ENDS

.SUBCKT OR2X0P7H9R Y VDD VSS A B
MI0_MXNA1 ny A VSS VSS nm1p2_svt_lp L=6e-08 W=1.5e-07
MI0_MXNA2 ny B VSS VSS nm1p2_svt_lp L=6e-08 W=1.5e-07
MI1_MXNA1 Y ny VSS VSS nm1p2_svt_lp L=6e-08 W=2.95e-07
MI0_MXPA1 ny A XI0_p1 VDD pm1p2_svt_lp L=6e-08 W=3.9e-07
MI0_MXPA2 XI0_p1 B VDD VDD pm1p2_svt_lp L=6e-08 W=3.9e-07
MI1_MXPA1 Y ny VDD VDD pm1p2_svt_lp L=6e-08 W=4.15e-07
.ENDS

.SUBCKT OR2X1H9R Y VDD VSS A B
MI0_MXNA1 ny A VSS VSS nm1p2_svt_lp L=6e-08 W=1.7e-07
MI0_MXNA2 ny B VSS VSS nm1p2_svt_lp L=6e-08 W=1.7e-07
MI1_MXNA1 Y ny VSS VSS nm1p2_svt_lp L=6e-08 W=4.2e-07
MI0_MXPA1 ny A XI0_p1 VDD pm1p2_svt_lp L=6e-08 W=4.45e-07
MI0_MXPA2 XI0_p1 B VDD VDD pm1p2_svt_lp L=6e-08 W=4.45e-07
MI1_MXPA1 Y ny VDD VDD pm1p2_svt_lp L=6e-08 W=5.85e-07
.ENDS

.SUBCKT OR2X1P4H9R Y VDD VSS A B
MI0_MXNA1 ny A VSS VSS nm1p2_svt_lp L=6e-08 W=2.25e-07
MI0_MXNA2 ny B VSS VSS nm1p2_svt_lp L=6e-08 W=2.25e-07
MI1_MXNA1 Y ny VSS VSS nm1p2_svt_lp L=6e-08 W=2.95e-07
MI1_MXNA1_2 Y ny VSS VSS nm1p2_svt_lp L=6e-08 W=2.95e-07
MI0_MXPA1 ny A XI0_p1 VDD pm1p2_svt_lp L=6e-08 W=5.85e-07
MI0_MXPA2 XI0_p1 B VDD VDD pm1p2_svt_lp L=6e-08 W=5.85e-07
MI1_MXPA1 Y ny VDD VDD pm1p2_svt_lp L=6e-08 W=4.15e-07
MI1_MXPA1_2 Y ny VDD VDD pm1p2_svt_lp L=6e-08 W=4.15e-07
.ENDS

.SUBCKT OR2X2H9R Y VDD VSS A B
MI0_MXNA1 ny A VSS VSS nm1p2_svt_lp L=6e-08 W=3.3e-07
MI0_MXNA2 ny B VSS VSS nm1p2_svt_lp L=6e-08 W=3.3e-07
MI1_MXNA1 Y ny VSS VSS nm1p2_svt_lp L=6e-08 W=4.2e-07
MI1_MXNA1_2 Y ny VSS VSS nm1p2_svt_lp L=6e-08 W=4.2e-07
MI0_MXPA2_2 XI0_p1__2 B VDD VDD pm1p2_svt_lp L=6e-08 W=4.35e-07
MI0_MXPA1_2 ny A XI0_p1__2 VDD pm1p2_svt_lp L=6e-08 W=4.35e-07
MI0_MXPA1 ny A XI0_p1 VDD pm1p2_svt_lp L=6e-08 W=4.35e-07
MI0_MXPA2 XI0_p1 B VDD VDD pm1p2_svt_lp L=6e-08 W=4.35e-07
MI1_MXPA1 Y ny VDD VDD pm1p2_svt_lp L=6e-08 W=5.85e-07
MI1_MXPA1_2 Y ny VDD VDD pm1p2_svt_lp L=6e-08 W=5.85e-07
.ENDS

.SUBCKT OR2X3H9R Y VDD VSS A B
MI0_MXNA1 ny A VSS VSS nm1p2_svt_lp L=6e-08 W=4.5e-07
MI0_MXNA2 ny B VSS VSS nm1p2_svt_lp L=6e-08 W=4.5e-07
MI1_MXNA1 Y ny VSS VSS nm1p2_svt_lp L=6e-08 W=4.2e-07
MI1_MXNA1_2 Y ny VSS VSS nm1p2_svt_lp L=6e-08 W=4.2e-07
MI1_MXNA1_3 Y ny VSS VSS nm1p2_svt_lp L=6e-08 W=4.2e-07
MI0_MXPA2_2 XI0_p1__2 B VDD VDD pm1p2_svt_lp L=6e-08 W=5.85e-07
MI0_MXPA1_2 ny A XI0_p1__2 VDD pm1p2_svt_lp L=6e-08 W=5.85e-07
MI0_MXPA1 ny A XI0_p1 VDD pm1p2_svt_lp L=6e-08 W=5.85e-07
MI0_MXPA2 XI0_p1 B VDD VDD pm1p2_svt_lp L=6e-08 W=5.85e-07
MI1_MXPA1 Y ny VDD VDD pm1p2_svt_lp L=6e-08 W=5.85e-07
MI1_MXPA1_2 Y ny VDD VDD pm1p2_svt_lp L=6e-08 W=5.85e-07
MI1_MXPA1_3 Y ny VDD VDD pm1p2_svt_lp L=6e-08 W=5.85e-07
.ENDS

.SUBCKT OR2X4H9R Y VDD VSS A B
MI0_MXNA2 ny B VSS VSS nm1p2_svt_lp L=6e-08 W=3.45e-07
MI0_MXNA1 ny A VSS VSS nm1p2_svt_lp L=6e-08 W=3.45e-07
MI0_MXNA1_2 ny A VSS VSS nm1p2_svt_lp L=6e-08 W=3e-07
MI0_MXNA2_2 ny B VSS VSS nm1p2_svt_lp L=6e-08 W=3e-07
MI1_MXNA1 Y ny VSS VSS nm1p2_svt_lp L=6e-08 W=4.2e-07
MI1_MXNA1_2 Y ny VSS VSS nm1p2_svt_lp L=6e-08 W=4.2e-07
MI1_MXNA1_3 Y ny VSS VSS nm1p2_svt_lp L=6e-08 W=4.2e-07
MI1_MXNA1_4 Y ny VSS VSS nm1p2_svt_lp L=6e-08 W=4.2e-07
MI0_MXPA1_2 ny A XI0_p1__2 VDD pm1p2_svt_lp L=6e-08 W=5.55e-07
MI0_MXPA2_2 XI0_p1__2 B VDD VDD pm1p2_svt_lp L=6e-08 W=5.55e-07
MI0_MXPA2_3 XI0_p1__3 B VDD VDD pm1p2_svt_lp L=6e-08 W=5.55e-07
MI0_MXPA1_3 ny A XI0_p1__3 VDD pm1p2_svt_lp L=6e-08 W=5.55e-07
MI0_MXPA1 ny A XI0_p1 VDD pm1p2_svt_lp L=6e-08 W=5.55e-07
MI0_MXPA2 XI0_p1 B VDD VDD pm1p2_svt_lp L=6e-08 W=5.55e-07
MI1_MXPA1 Y ny VDD VDD pm1p2_svt_lp L=6e-08 W=5.85e-07
MI1_MXPA1_2 Y ny VDD VDD pm1p2_svt_lp L=6e-08 W=5.85e-07
MI1_MXPA1_3 Y ny VDD VDD pm1p2_svt_lp L=6e-08 W=5.85e-07
MI1_MXPA1_4 Y ny VDD VDD pm1p2_svt_lp L=6e-08 W=5.85e-07
.ENDS

.SUBCKT OR2X6H9R Y VDD VSS A B
MI0_MXNA1 ny A VSS VSS nm1p2_svt_lp L=6e-08 W=3e-07
MI0_MXNA2 ny B VSS VSS nm1p2_svt_lp L=6e-08 W=3e-07
MI0_MXNA2_2 ny B VSS VSS nm1p2_svt_lp L=6e-08 W=3e-07
MI0_MXNA1_2 ny A VSS VSS nm1p2_svt_lp L=6e-08 W=3e-07
MI0_MXNA1_3 ny A VSS VSS nm1p2_svt_lp L=6e-08 W=3e-07
MI0_MXNA2_3 ny B VSS VSS nm1p2_svt_lp L=6e-08 W=3e-07
MI1_MXNA1 Y ny VSS VSS nm1p2_svt_lp L=6e-08 W=4.2e-07
MI1_MXNA1_2 Y ny VSS VSS nm1p2_svt_lp L=6e-08 W=4.2e-07
MI1_MXNA1_3 Y ny VSS VSS nm1p2_svt_lp L=6e-08 W=4.2e-07
MI1_MXNA1_4 Y ny VSS VSS nm1p2_svt_lp L=6e-08 W=4.2e-07
MI1_MXNA1_5 Y ny VSS VSS nm1p2_svt_lp L=6e-08 W=4.2e-07
MI1_MXNA1_6 Y ny VSS VSS nm1p2_svt_lp L=6e-08 W=4.2e-07
MI0_MXPA2_2 XI0_p1__2 B VDD VDD pm1p2_svt_lp L=6e-08 W=5.85e-07
MI0_MXPA1_2 ny A XI0_p1__2 VDD pm1p2_svt_lp L=6e-08 W=5.85e-07
MI0_MXPA1_3 ny A XI0_p1__3 VDD pm1p2_svt_lp L=6e-08 W=5.85e-07
MI0_MXPA2_3 XI0_p1__3 B VDD VDD pm1p2_svt_lp L=6e-08 W=5.85e-07
MI0_MXPA2_4 XI0_p1__4 B VDD VDD pm1p2_svt_lp L=6e-08 W=5.85e-07
MI0_MXPA1_4 ny A XI0_p1__4 VDD pm1p2_svt_lp L=6e-08 W=5.85e-07
MI0_MXPA1 ny A XI0_p1 VDD pm1p2_svt_lp L=6e-08 W=5.85e-07
MI0_MXPA2 XI0_p1 B VDD VDD pm1p2_svt_lp L=6e-08 W=5.85e-07
MI1_MXPA1 Y ny VDD VDD pm1p2_svt_lp L=6e-08 W=5.85e-07
MI1_MXPA1_2 Y ny VDD VDD pm1p2_svt_lp L=6e-08 W=5.85e-07
MI1_MXPA1_3 Y ny VDD VDD pm1p2_svt_lp L=6e-08 W=5.85e-07
MI1_MXPA1_4 Y ny VDD VDD pm1p2_svt_lp L=6e-08 W=5.85e-07
MI1_MXPA1_5 Y ny VDD VDD pm1p2_svt_lp L=6e-08 W=5.85e-07
MI1_MXPA1_6 Y ny VDD VDD pm1p2_svt_lp L=6e-08 W=5.85e-07
.ENDS

.SUBCKT OR2X8H9R Y VDD VSS A B
MI0_MXNA1 ny A VSS VSS nm1p2_svt_lp L=6e-08 W=4.3e-07
MI0_MXNA2 ny B VSS VSS nm1p2_svt_lp L=6e-08 W=4.3e-07
MI0_MXNA2_2 ny B VSS VSS nm1p2_svt_lp L=6e-08 W=4.3e-07
MI0_MXNA1_2 ny A VSS VSS nm1p2_svt_lp L=6e-08 W=4.3e-07
MI0_MXNA1_3 ny A VSS VSS nm1p2_svt_lp L=6e-08 W=4.3e-07
MI0_MXNA2_3 ny B VSS VSS nm1p2_svt_lp L=6e-08 W=4.3e-07
MI1_MXNA1 Y ny VSS VSS nm1p2_svt_lp L=6e-08 W=4.8e-07
MI1_MXNA1_2 Y ny VSS VSS nm1p2_svt_lp L=6e-08 W=4.8e-07
MI1_MXNA1_3 Y ny VSS VSS nm1p2_svt_lp L=6e-08 W=4.8e-07
MI1_MXNA1_4 Y ny VSS VSS nm1p2_svt_lp L=6e-08 W=4.8e-07
MI1_MXNA1_5 Y ny VSS VSS nm1p2_svt_lp L=6e-08 W=4.8e-07
MI1_MXNA1_6 Y ny VSS VSS nm1p2_svt_lp L=6e-08 W=4.8e-07
MI1_MXNA1_7 Y ny VSS VSS nm1p2_svt_lp L=6e-08 W=4.8e-07
MI0_MXPA2_2 XI0_p1__2 B VDD VDD pm1p2_svt_lp L=6e-08 W=5.6e-07
MI0_MXPA1_2 ny A XI0_p1__2 VDD pm1p2_svt_lp L=6e-08 W=5.6e-07
MI0_MXPA1_3 ny A XI0_p1__3 VDD pm1p2_svt_lp L=6e-08 W=5.6e-07
MI0_MXPA2_3 XI0_p1__3 B VDD VDD pm1p2_svt_lp L=6e-08 W=5.6e-07
MI0_MXPA2_4 XI0_p1__4 B VDD VDD pm1p2_svt_lp L=6e-08 W=5.6e-07
MI0_MXPA1_4 ny A XI0_p1__4 VDD pm1p2_svt_lp L=6e-08 W=5.6e-07
MI0_MXPA1_5 ny A XI0_p1__5 VDD pm1p2_svt_lp L=6e-08 W=5.6e-07
MI0_MXPA2_5 XI0_p1__5 B VDD VDD pm1p2_svt_lp L=6e-08 W=5.6e-07
MI0_MXPA2_6 XI0_p1__6 B VDD VDD pm1p2_svt_lp L=6e-08 W=5.6e-07
MI0_MXPA1_6 ny A XI0_p1__6 VDD pm1p2_svt_lp L=6e-08 W=5.6e-07
MI0_MXPA1 ny A XI0_p1 VDD pm1p2_svt_lp L=6e-08 W=5.6e-07
MI0_MXPA2 XI0_p1 B VDD VDD pm1p2_svt_lp L=6e-08 W=5.6e-07
MI1_MXPA1 Y ny VDD VDD pm1p2_svt_lp L=6e-08 W=5.85e-07
MI1_MXPA1_2 Y ny VDD VDD pm1p2_svt_lp L=6e-08 W=5.85e-07
MI1_MXPA1_3 Y ny VDD VDD pm1p2_svt_lp L=6e-08 W=5.85e-07
MI1_MXPA1_4 Y ny VDD VDD pm1p2_svt_lp L=6e-08 W=5.85e-07
MI1_MXPA1_5 Y ny VDD VDD pm1p2_svt_lp L=6e-08 W=5.85e-07
MI1_MXPA1_6 Y ny VDD VDD pm1p2_svt_lp L=6e-08 W=5.85e-07
MI1_MXPA1_7 Y ny VDD VDD pm1p2_svt_lp L=6e-08 W=5.85e-07
MI1_MXPA1_8 Y ny VDD VDD pm1p2_svt_lp L=6e-08 W=5.85e-07
.ENDS

.SUBCKT OR2X11H9R Y VDD VSS A B
MI0_MXNA2 ny B VSS VSS nm1p2_svt_lp L=6e-08 W=2.85e-07
MI0_MXNA2_2 ny B VSS VSS nm1p2_svt_lp L=6e-08 W=2.95e-07
MI0_MXNA2_3 ny B VSS VSS nm1p2_svt_lp L=6e-08 W=2.95e-07
MI0_MXNA2_4 ny B VSS VSS nm1p2_svt_lp L=6e-08 W=2.95e-07
MI0_MXNA2_5 ny B VSS VSS nm1p2_svt_lp L=6e-08 W=2.95e-07
MI0_MXNA2_6 ny B VSS VSS nm1p2_svt_lp L=6e-08 W=2.95e-07
MI0_MXNA1 ny A VSS VSS nm1p2_svt_lp L=6e-08 W=2.95e-07
MI0_MXNA1_2 ny A VSS VSS nm1p2_svt_lp L=6e-08 W=2.95e-07
MI0_MXNA1_3 ny A VSS VSS nm1p2_svt_lp L=6e-08 W=2.95e-07
MI0_MXNA1_4 ny A VSS VSS nm1p2_svt_lp L=6e-08 W=2.95e-07
MI0_MXNA1_5 ny A VSS VSS nm1p2_svt_lp L=6e-08 W=2.95e-07
MI0_MXNA1_6 ny A VSS VSS nm1p2_svt_lp L=6e-08 W=2.85e-07
MI1_MXNA1 Y ny VSS VSS nm1p2_svt_lp L=6e-08 W=4.2e-07
MI1_MXNA1_2 Y ny VSS VSS nm1p2_svt_lp L=6e-08 W=4.2e-07
MI1_MXNA1_3 Y ny VSS VSS nm1p2_svt_lp L=6e-08 W=4.2e-07
MI1_MXNA1_4 Y ny VSS VSS nm1p2_svt_lp L=6e-08 W=4.2e-07
MI1_MXNA1_5 Y ny VSS VSS nm1p2_svt_lp L=6e-08 W=4.2e-07
MI1_MXNA1_6 Y ny VSS VSS nm1p2_svt_lp L=6e-08 W=4.2e-07
MI1_MXNA1_7 Y ny VSS VSS nm1p2_svt_lp L=6e-08 W=4.2e-07
MI1_MXNA1_8 Y ny VSS VSS nm1p2_svt_lp L=6e-08 W=4.2e-07
MI1_MXNA1_9 Y ny VSS VSS nm1p2_svt_lp L=6e-08 W=4.2e-07
MI1_MXNA1_10 Y ny VSS VSS nm1p2_svt_lp L=6e-08 W=4.2e-07
MI1_MXNA1_11 Y ny VSS VSS nm1p2_svt_lp L=6e-08 W=4.2e-07
MI0_MXPA2 XI0_p1 B VDD VDD pm1p2_svt_lp L=6e-08 W=2.5e-07
MI0_MXPA2_2 XI0_p1 B VDD VDD pm1p2_svt_lp L=6e-08 W=5e-07
MI0_MXPA2_3 XI0_p1 B VDD VDD pm1p2_svt_lp L=6e-08 W=7.7e-07
MI0_MXPA2_4 XI0_p1 B VDD VDD pm1p2_svt_lp L=6e-08 W=7.7e-07
MI0_MXPA2_5 XI0_p1 B VDD VDD pm1p2_svt_lp L=6e-08 W=7.7e-07
MI0_MXPA2_6 XI0_p1 B VDD VDD pm1p2_svt_lp L=6e-08 W=7.7e-07
MI0_MXPA2_7 XI0_p1 B VDD VDD pm1p2_svt_lp L=6e-08 W=7.7e-07
MI0_MXPA1 ny A XI0_p1 VDD pm1p2_svt_lp L=6e-08 W=7.7e-07
MI0_MXPA1_2 ny A XI0_p1 VDD pm1p2_svt_lp L=6e-08 W=7.7e-07
MI0_MXPA1_3 ny A XI0_p1 VDD pm1p2_svt_lp L=6e-08 W=7.7e-07
MI0_MXPA1_4 ny A XI0_p1 VDD pm1p2_svt_lp L=6e-08 W=7.7e-07
MI0_MXPA1_5 ny A XI0_p1 VDD pm1p2_svt_lp L=6e-08 W=7.7e-07
MI0_MXPA1_6 ny A XI0_p1 VDD pm1p2_svt_lp L=6e-08 W=7.5e-07
MI1_MXPA1 Y ny VDD VDD pm1p2_svt_lp L=6e-08 W=5.85e-07
MI1_MXPA1_2 Y ny VDD VDD pm1p2_svt_lp L=6e-08 W=5.85e-07
MI1_MXPA1_3 Y ny VDD VDD pm1p2_svt_lp L=6e-08 W=5.85e-07
MI1_MXPA1_4 Y ny VDD VDD pm1p2_svt_lp L=6e-08 W=5.85e-07
MI1_MXPA1_5 Y ny VDD VDD pm1p2_svt_lp L=6e-08 W=5.85e-07
MI1_MXPA1_6 Y ny VDD VDD pm1p2_svt_lp L=6e-08 W=5.85e-07
MI1_MXPA1_7 Y ny VDD VDD pm1p2_svt_lp L=6e-08 W=5.85e-07
MI1_MXPA1_8 Y ny VDD VDD pm1p2_svt_lp L=6e-08 W=5.85e-07
MI1_MXPA1_9 Y ny VDD VDD pm1p2_svt_lp L=6e-08 W=5.85e-07
MI1_MXPA1_10 Y ny VDD VDD pm1p2_svt_lp L=6e-08 W=5.85e-07
MI1_MXPA1_11 Y ny VDD VDD pm1p2_svt_lp L=6e-08 W=5.85e-07
.ENDS

.SUBCKT OR3X0P5H9R Y VDD VSS A B C
MI0_MXNA1 ny A VSS VSS nm1p2_svt_lp L=6e-08 W=1.5e-07
MI0_MXNA2 ny B VSS VSS nm1p2_svt_lp L=6e-08 W=1.5e-07
MI0_MXNA3 ny C VSS VSS nm1p2_svt_lp L=6e-08 W=1.5e-07
MI1_MXNA1 Y ny VSS VSS nm1p2_svt_lp L=6e-08 W=2.1e-07
MI0_MXPA1 ny A XI0_p2 VDD pm1p2_svt_lp L=6e-08 W=5.55e-07
MI0_MXPA2 XI0_p2 B XI0_p1 VDD pm1p2_svt_lp L=6e-08 W=5.55e-07
MI0_MXPA3 XI0_p1 C VDD VDD pm1p2_svt_lp L=6e-08 W=5.55e-07
MI1_MXPA1 Y ny VDD VDD pm1p2_svt_lp L=6e-08 W=2.95e-07
.ENDS

.SUBCKT OR3X0P7H9R Y VDD VSS A B C
MI0_MXNA1 ny A VSS VSS nm1p2_svt_lp L=6e-08 W=2.1e-07
MI0_MXNA2 ny B VSS VSS nm1p2_svt_lp L=6e-08 W=2.1e-07
MI0_MXNA3 ny C VSS VSS nm1p2_svt_lp L=6e-08 W=2.1e-07
MI1_MXNA1 Y ny VSS VSS nm1p2_svt_lp L=6e-08 W=2.95e-07
MI0_MXPA3_2 XI0_p1__2 C VDD VDD pm1p2_svt_lp L=6e-08 W=3.85e-07
MI0_MXPA2_2 XI0_p2__2 B XI0_p1__2 VDD pm1p2_svt_lp L=6e-08 W=3.85e-07
MI0_MXPA1_2 ny A XI0_p2__2 VDD pm1p2_svt_lp L=6e-08 W=3.85e-07
MI0_MXPA1 ny A XI0_p2 VDD pm1p2_svt_lp L=6e-08 W=3.85e-07
MI0_MXPA2 XI0_p2 B XI0_p1 VDD pm1p2_svt_lp L=6e-08 W=3.85e-07
MI0_MXPA3 XI0_p1 C VDD VDD pm1p2_svt_lp L=6e-08 W=3.85e-07
MI1_MXPA1 Y ny VDD VDD pm1p2_svt_lp L=6e-08 W=4.15e-07
.ENDS

.SUBCKT OR3X1H9R Y VDD VSS A B C
MI0_MXNA1 ny A VSS VSS nm1p2_svt_lp L=6e-08 W=2.5e-07
MI0_MXNA2 ny B VSS VSS nm1p2_svt_lp L=6e-08 W=2.5e-07
MI0_MXNA3 ny C VSS VSS nm1p2_svt_lp L=6e-08 W=2.5e-07
MI1_MXNA1 Y ny VSS VSS nm1p2_svt_lp L=6e-08 W=4.2e-07
MI0_MXPA3_2 XI0_p1__2 C VDD VDD pm1p2_svt_lp L=6e-08 W=4.55e-07
MI0_MXPA2_2 XI0_p2__2 B XI0_p1__2 VDD pm1p2_svt_lp L=6e-08 W=4.55e-07
MI0_MXPA1_2 ny A XI0_p2__2 VDD pm1p2_svt_lp L=6e-08 W=4.55e-07
MI0_MXPA1 ny A XI0_p2 VDD pm1p2_svt_lp L=6e-08 W=4.55e-07
MI0_MXPA2 XI0_p2 B XI0_p1 VDD pm1p2_svt_lp L=6e-08 W=4.55e-07
MI0_MXPA3 XI0_p1 C VDD VDD pm1p2_svt_lp L=6e-08 W=4.55e-07
MI1_MXPA1 Y ny VDD VDD pm1p2_svt_lp L=6e-08 W=5.85e-07
.ENDS

.SUBCKT OR3X1P4H9R Y VDD VSS A B C
MI0_MXNA1 ny A VSS VSS nm1p2_svt_lp L=6e-08 W=3.1e-07
MI0_MXNA2 ny B VSS VSS nm1p2_svt_lp L=6e-08 W=3.1e-07
MI0_MXNA3 ny C VSS VSS nm1p2_svt_lp L=6e-08 W=3.1e-07
MI1_MXNA1 Y ny VSS VSS nm1p2_svt_lp L=6e-08 W=2.95e-07
MI1_MXNA1_2 Y ny VSS VSS nm1p2_svt_lp L=6e-08 W=2.95e-07
MI0_MXPA3_2 XI0_p1__2 C VDD VDD pm1p2_svt_lp L=6e-08 W=5.7e-07
MI0_MXPA2_2 XI0_p2__2 B XI0_p1__2 VDD pm1p2_svt_lp L=6e-08 W=5.7e-07
MI0_MXPA1_2 ny A XI0_p2__2 VDD pm1p2_svt_lp L=6e-08 W=5.7e-07
MI0_MXPA1 ny A XI0_p2 VDD pm1p2_svt_lp L=6e-08 W=5.7e-07
MI0_MXPA2 XI0_p2 B XI0_p1 VDD pm1p2_svt_lp L=6e-08 W=5.7e-07
MI0_MXPA3 XI0_p1 C VDD VDD pm1p2_svt_lp L=6e-08 W=5.7e-07
MI1_MXPA1 Y ny VDD VDD pm1p2_svt_lp L=6e-08 W=4.15e-07
MI1_MXPA1_2 Y ny VDD VDD pm1p2_svt_lp L=6e-08 W=4.15e-07
.ENDS

.SUBCKT OR3X2H9R Y VDD VSS A B C
MI0_MXNA2 ny B VSS VSS nm1p2_svt_lp L=6e-08 W=2.1e-07
MI0_MXNA1 ny A VSS VSS nm1p2_svt_lp L=6e-08 W=2.1e-07
MI0_MXNA1_2 ny A VSS VSS nm1p2_svt_lp L=6e-08 W=2.1e-07
MI0_MXNA2_2 ny B VSS VSS nm1p2_svt_lp L=6e-08 W=2.1e-07
MI0_MXNA3 ny C VSS VSS nm1p2_svt_lp L=6e-08 W=2.1e-07
MI0_MXNA3_2 ny C VSS VSS nm1p2_svt_lp L=6e-08 W=2.1e-07
MI1_MXNA1 Y ny VSS VSS nm1p2_svt_lp L=6e-08 W=4.2e-07
MI1_MXNA1_2 Y ny VSS VSS nm1p2_svt_lp L=6e-08 W=4.2e-07
MI0_MXPA1_2 ny A XI0_p2__2 VDD pm1p2_svt_lp L=6e-08 W=5.2e-07
MI0_MXPA2_2 XI0_p2__2 B XI0_p1 VDD pm1p2_svt_lp L=6e-08 W=5.2e-07
MI0_MXPA2_3 XI0_p2__3 B XI0_p1 VDD pm1p2_svt_lp L=6e-08 W=5.2e-07
MI0_MXPA1_3 ny A XI0_p2__3 VDD pm1p2_svt_lp L=6e-08 W=5.2e-07
MI0_MXPA1 ny A XI0_p2 VDD pm1p2_svt_lp L=6e-08 W=5.2e-07
MI0_MXPA2 XI0_p2 B XI0_p1 VDD pm1p2_svt_lp L=6e-08 W=5.2e-07
MI0_MXPA3 XI0_p1 C VDD VDD pm1p2_svt_lp L=6e-08 W=5.2e-07
MI0_MXPA3_2 XI0_p1 C VDD VDD pm1p2_svt_lp L=6e-08 W=5.2e-07
MI0_MXPA3_3 XI0_p1 C VDD VDD pm1p2_svt_lp L=6e-08 W=5.2e-07
MI1_MXPA1 Y ny VDD VDD pm1p2_svt_lp L=6e-08 W=5.85e-07
MI1_MXPA1_2 Y ny VDD VDD pm1p2_svt_lp L=6e-08 W=5.85e-07
.ENDS

.SUBCKT OR3X3H9R Y VDD VSS A B C
MI0_MXNA2 ny B VSS VSS nm1p2_svt_lp L=6e-08 W=3e-07
MI0_MXNA1 ny A VSS VSS nm1p2_svt_lp L=6e-08 W=3e-07
MI0_MXNA1_2 ny A VSS VSS nm1p2_svt_lp L=6e-08 W=3e-07
MI0_MXNA2_2 ny B VSS VSS nm1p2_svt_lp L=6e-08 W=3e-07
MI0_MXNA3 ny C VSS VSS nm1p2_svt_lp L=6e-08 W=3e-07
MI0_MXNA3_2 ny C VSS VSS nm1p2_svt_lp L=6e-08 W=3e-07
MI1_MXNA1 Y ny VSS VSS nm1p2_svt_lp L=6e-08 W=3.15e-07
MI1_MXNA1_2 Y ny VSS VSS nm1p2_svt_lp L=6e-08 W=3.15e-07
MI1_MXNA1_3 Y ny VSS VSS nm1p2_svt_lp L=6e-08 W=3.15e-07
MI1_MXNA1_4 Y ny VSS VSS nm1p2_svt_lp L=6e-08 W=3.15e-07
MI0_MXPA1_2 ny A XI0_p2__2 VDD pm1p2_svt_lp L=6e-08 W=7.5e-07
MI0_MXPA2_2 XI0_p2__2 B XI0_p1 VDD pm1p2_svt_lp L=6e-08 W=7.5e-07
MI0_MXPA2_3 XI0_p2__3 B XI0_p1 VDD pm1p2_svt_lp L=6e-08 W=7.5e-07
MI0_MXPA1_3 ny A XI0_p2__3 VDD pm1p2_svt_lp L=6e-08 W=7.5e-07
MI0_MXPA1 ny A XI0_p2 VDD pm1p2_svt_lp L=6e-08 W=7.5e-07
MI0_MXPA2 XI0_p2 B XI0_p1 VDD pm1p2_svt_lp L=6e-08 W=7.5e-07
MI0_MXPA3 XI0_p1 C VDD VDD pm1p2_svt_lp L=6e-08 W=7.5e-07
MI0_MXPA3_2 XI0_p1 C VDD VDD pm1p2_svt_lp L=6e-08 W=7.5e-07
MI0_MXPA3_3 XI0_p1 C VDD VDD pm1p2_svt_lp L=6e-08 W=7.5e-07
MI1_MXPA1 Y ny VDD VDD pm1p2_svt_lp L=6e-08 W=5.85e-07
MI1_MXPA1_2 Y ny VDD VDD pm1p2_svt_lp L=6e-08 W=5.85e-07
MI1_MXPA1_3 Y ny VDD VDD pm1p2_svt_lp L=6e-08 W=5.85e-07
.ENDS

.SUBCKT OR3X4H9R Y VDD VSS A B C
MI0_MXNA2 ny B VSS VSS nm1p2_svt_lp L=6e-08 W=2.9e-07
MI0_MXNA1 ny A VSS VSS nm1p2_svt_lp L=6e-08 W=2.9e-07
MI0_MXNA2_2 ny B VSS VSS nm1p2_svt_lp L=6e-08 W=2.9e-07
MI0_MXNA1_2 ny A VSS VSS nm1p2_svt_lp L=6e-08 W=2.9e-07
MI0_MXNA1_3 ny A VSS VSS nm1p2_svt_lp L=6e-08 W=2.9e-07
MI0_MXNA2_3 ny B VSS VSS nm1p2_svt_lp L=6e-08 W=2.9e-07
MI0_MXNA3 ny C VSS VSS nm1p2_svt_lp L=6e-08 W=2.9e-07
MI0_MXNA3_2 ny C VSS VSS nm1p2_svt_lp L=6e-08 W=2.9e-07
MI0_MXNA3_3 ny C VSS VSS nm1p2_svt_lp L=6e-08 W=2.9e-07
MI1_MXNA1 Y ny VSS VSS nm1p2_svt_lp L=6e-08 W=4.2e-07
MI1_MXNA1_2 Y ny VSS VSS nm1p2_svt_lp L=6e-08 W=4.2e-07
MI1_MXNA1_3 Y ny VSS VSS nm1p2_svt_lp L=6e-08 W=4.2e-07
MI1_MXNA1_4 Y ny VSS VSS nm1p2_svt_lp L=6e-08 W=4.2e-07
MI0_MXPA1_2 ny A XI0_p2__2 VDD pm1p2_svt_lp L=6e-08 W=6.5e-07
MI0_MXPA2_2 XI0_p2__2 B XI0_p1 VDD pm1p2_svt_lp L=6e-08 W=6.5e-07
MI0_MXPA2_3 XI0_p2__3 B XI0_p1 VDD pm1p2_svt_lp L=6e-08 W=6.5e-07
MI0_MXPA1_3 ny A XI0_p2__3 VDD pm1p2_svt_lp L=6e-08 W=6.5e-07
MI0_MXPA1_4 ny A XI0_p2__4 VDD pm1p2_svt_lp L=6e-08 W=6.5e-07
MI0_MXPA2_4 XI0_p2__4 B XI0_p1 VDD pm1p2_svt_lp L=6e-08 W=6.5e-07
MI0_MXPA2_5 XI0_p2__5 B XI0_p1 VDD pm1p2_svt_lp L=6e-08 W=6.5e-07
MI0_MXPA1_5 ny A XI0_p2__5 VDD pm1p2_svt_lp L=6e-08 W=6.5e-07
MI0_MXPA1 ny A XI0_p2 VDD pm1p2_svt_lp L=6e-08 W=6.5e-07
MI0_MXPA2 XI0_p2 B XI0_p1 VDD pm1p2_svt_lp L=6e-08 W=6.5e-07
MI0_MXPA3 XI0_p1 C VDD VDD pm1p2_svt_lp L=6e-08 W=6.5e-07
MI0_MXPA3_2 XI0_p1 C VDD VDD pm1p2_svt_lp L=6e-08 W=6.5e-07
MI0_MXPA3_3 XI0_p1 C VDD VDD pm1p2_svt_lp L=6e-08 W=6.5e-07
MI0_MXPA3_4 XI0_p1 C VDD VDD pm1p2_svt_lp L=6e-08 W=6.5e-07
MI0_MXPA3_5 XI0_p1 C VDD VDD pm1p2_svt_lp L=6e-08 W=6.5e-07
MI1_MXPA1 Y ny VDD VDD pm1p2_svt_lp L=6e-08 W=5.85e-07
MI1_MXPA1_2 Y ny VDD VDD pm1p2_svt_lp L=6e-08 W=5.85e-07
MI1_MXPA1_3 Y ny VDD VDD pm1p2_svt_lp L=6e-08 W=5.85e-07
MI1_MXPA1_4 Y ny VDD VDD pm1p2_svt_lp L=6e-08 W=5.85e-07
.ENDS

.SUBCKT OR3X6H9R Y VDD VSS A B C
MI0_MXNA2 ny B VSS VSS nm1p2_svt_lp L=6e-08 W=2.55e-07
MI0_MXNA2_2 ny B VSS VSS nm1p2_svt_lp L=6e-08 W=2.55e-07
MI0_MXNA1 ny A VSS VSS nm1p2_svt_lp L=6e-08 W=2.55e-07
MI0_MXNA2_3 ny B VSS VSS nm1p2_svt_lp L=6e-08 W=2.55e-07
MI0_MXNA1_2 ny A VSS VSS nm1p2_svt_lp L=6e-08 W=2.55e-07
MI0_MXNA1_3 ny A VSS VSS nm1p2_svt_lp L=6e-08 W=2.55e-07
MI0_MXNA2_4 ny B VSS VSS nm1p2_svt_lp L=6e-08 W=2.55e-07
MI0_MXNA1_4 ny A VSS VSS nm1p2_svt_lp L=6e-08 W=2.55e-07
MI0_MXNA1_5 ny A VSS VSS nm1p2_svt_lp L=6e-08 W=2.55e-07
MI0_MXNA2_5 ny B VSS VSS nm1p2_svt_lp L=6e-08 W=2.55e-07
MI0_MXNA3 ny C VSS VSS nm1p2_svt_lp L=6e-08 W=2.55e-07
MI0_MXNA3_2 ny C VSS VSS nm1p2_svt_lp L=6e-08 W=2.55e-07
MI0_MXNA3_3 ny C VSS VSS nm1p2_svt_lp L=6e-08 W=2.55e-07
MI0_MXNA3_4 ny C VSS VSS nm1p2_svt_lp L=6e-08 W=2.55e-07
MI0_MXNA3_5 ny C VSS VSS nm1p2_svt_lp L=6e-08 W=2.55e-07
MI1_MXNA1 Y ny VSS VSS nm1p2_svt_lp L=6e-08 W=4.2e-07
MI1_MXNA1_2 Y ny VSS VSS nm1p2_svt_lp L=6e-08 W=4.2e-07
MI1_MXNA1_3 Y ny VSS VSS nm1p2_svt_lp L=6e-08 W=4.2e-07
MI1_MXNA1_4 Y ny VSS VSS nm1p2_svt_lp L=6e-08 W=4.2e-07
MI1_MXNA1_5 Y ny VSS VSS nm1p2_svt_lp L=6e-08 W=4.2e-07
MI1_MXNA1_6 Y ny VSS VSS nm1p2_svt_lp L=6e-08 W=4.2e-07
MI0_MXPA2_2 XI0_p2__2 B XI0_p1 VDD pm1p2_svt_lp L=6e-08 W=7.8e-07
MI0_MXPA1_2 ny A XI0_p2__2 VDD pm1p2_svt_lp L=6e-08 W=7.8e-07
MI0_MXPA1_3 ny A XI0_p2__3 VDD pm1p2_svt_lp L=6e-08 W=7.8e-07
MI0_MXPA2_3 XI0_p2__3 B XI0_p1 VDD pm1p2_svt_lp L=6e-08 W=7.8e-07
MI0_MXPA2_4 XI0_p2__4 B XI0_p1 VDD pm1p2_svt_lp L=6e-08 W=7.8e-07
MI0_MXPA1_4 ny A XI0_p2__4 VDD pm1p2_svt_lp L=6e-08 W=7.8e-07
MI0_MXPA1_5 ny A XI0_p2__5 VDD pm1p2_svt_lp L=6e-08 W=7.8e-07
MI0_MXPA2_5 XI0_p2__5 B XI0_p1 VDD pm1p2_svt_lp L=6e-08 W=7.8e-07
MI0_MXPA2_6 XI0_p2__6 B XI0_p1 VDD pm1p2_svt_lp L=6e-08 W=7.8e-07
MI0_MXPA1_6 ny A XI0_p2__6 VDD pm1p2_svt_lp L=6e-08 W=7.8e-07
MI0_MXPA1 ny A XI0_p2 VDD pm1p2_svt_lp L=6e-08 W=7.8e-07
MI0_MXPA2 XI0_p2 B XI0_p1 VDD pm1p2_svt_lp L=6e-08 W=7.8e-07
MI0_MXPA3 XI0_p1 C VDD VDD pm1p2_svt_lp L=6e-08 W=7.8e-07
MI0_MXPA3_2 XI0_p1 C VDD VDD pm1p2_svt_lp L=6e-08 W=7.8e-07
MI0_MXPA3_3 XI0_p1 C VDD VDD pm1p2_svt_lp L=6e-08 W=7.8e-07
MI0_MXPA3_4 XI0_p1 C VDD VDD pm1p2_svt_lp L=6e-08 W=7.8e-07
MI0_MXPA3_5 XI0_p1 C VDD VDD pm1p2_svt_lp L=6e-08 W=7.8e-07
MI0_MXPA3_6 XI0_p1 C VDD VDD pm1p2_svt_lp L=6e-08 W=7.8e-07
MI1_MXPA1 Y ny VDD VDD pm1p2_svt_lp L=6e-08 W=5.85e-07
MI1_MXPA1_2 Y ny VDD VDD pm1p2_svt_lp L=6e-08 W=5.85e-07
MI1_MXPA1_3 Y ny VDD VDD pm1p2_svt_lp L=6e-08 W=5.85e-07
MI1_MXPA1_4 Y ny VDD VDD pm1p2_svt_lp L=6e-08 W=5.85e-07
MI1_MXPA1_5 Y ny VDD VDD pm1p2_svt_lp L=6e-08 W=5.85e-07
MI1_MXPA1_6 Y ny VDD VDD pm1p2_svt_lp L=6e-08 W=5.85e-07
.ENDS

.SUBCKT OR3X8H9R Y VDD VSS A B C
MI0_MXNA2 ny B VSS VSS nm1p2_svt_lp L=6e-08 W=3.65e-07
MI0_MXNA2_2 ny B VSS VSS nm1p2_svt_lp L=6e-08 W=3.65e-07
MI0_MXNA1 ny A VSS VSS nm1p2_svt_lp L=6e-08 W=3.45e-07
MI0_MXNA2_3 ny B VSS VSS nm1p2_svt_lp L=6e-08 W=3.45e-07
MI0_MXNA1_2 ny A VSS VSS nm1p2_svt_lp L=6e-08 W=3.65e-07
MI0_MXNA1_3 ny A VSS VSS nm1p2_svt_lp L=6e-08 W=3.65e-07
MI0_MXNA2_4 ny B VSS VSS nm1p2_svt_lp L=6e-08 W=3.45e-07
MI0_MXNA1_4 ny A VSS VSS nm1p2_svt_lp L=6e-08 W=3.45e-07
MI0_MXNA1_5 ny A VSS VSS nm1p2_svt_lp L=6e-08 W=3.45e-07
MI0_MXNA2_5 ny B VSS VSS nm1p2_svt_lp L=6e-08 W=3.45e-07
MI0_MXNA3 ny C VSS VSS nm1p2_svt_lp L=6e-08 W=3.65e-07
MI0_MXNA3_2 ny C VSS VSS nm1p2_svt_lp L=6e-08 W=3.65e-07
MI0_MXNA3_3 ny C VSS VSS nm1p2_svt_lp L=6e-08 W=3.45e-07
MI0_MXNA3_4 ny C VSS VSS nm1p2_svt_lp L=6e-08 W=3.45e-07
MI0_MXNA3_5 ny C VSS VSS nm1p2_svt_lp L=6e-08 W=3.45e-07
MI1_MXNA1 Y ny VSS VSS nm1p2_svt_lp L=6e-08 W=4.2e-07
MI1_MXNA1_2 Y ny VSS VSS nm1p2_svt_lp L=6e-08 W=4.2e-07
MI1_MXNA1_3 Y ny VSS VSS nm1p2_svt_lp L=6e-08 W=4.2e-07
MI1_MXNA1_4 Y ny VSS VSS nm1p2_svt_lp L=6e-08 W=4.2e-07
MI1_MXNA1_5 Y ny VSS VSS nm1p2_svt_lp L=6e-08 W=4.2e-07
MI1_MXNA1_6 Y ny VSS VSS nm1p2_svt_lp L=6e-08 W=4.2e-07
MI1_MXNA1_7 Y ny VSS VSS nm1p2_svt_lp L=6e-08 W=4.2e-07
MI1_MXNA1_8 Y ny VSS VSS nm1p2_svt_lp L=6e-08 W=4.2e-07
MI0_MXPA1_2 ny A XI0_p2__2 VDD pm1p2_svt_lp L=6e-08 W=7.15e-07
MI0_MXPA2_2 XI0_p2__2 B XI0_p1 VDD pm1p2_svt_lp L=6e-08 W=7.15e-07
MI0_MXPA2_3 XI0_p2__3 B XI0_p1 VDD pm1p2_svt_lp L=6e-08 W=7.15e-07
MI0_MXPA1_3 ny A XI0_p2__3 VDD pm1p2_svt_lp L=6e-08 W=7.15e-07
MI0_MXPA1_4 ny A XI0_p2__4 VDD pm1p2_svt_lp L=6e-08 W=7.15e-07
MI0_MXPA2_4 XI0_p2__4 B XI0_p1 VDD pm1p2_svt_lp L=6e-08 W=7.15e-07
MI0_MXPA2_5 XI0_p2__5 B XI0_p1 VDD pm1p2_svt_lp L=6e-08 W=7.15e-07
MI0_MXPA1_5 ny A XI0_p2__5 VDD pm1p2_svt_lp L=6e-08 W=7.15e-07
MI0_MXPA1_6 ny A XI0_p2__6 VDD pm1p2_svt_lp L=6e-08 W=7.15e-07
MI0_MXPA2_6 XI0_p2__6 B XI0_p1 VDD pm1p2_svt_lp L=6e-08 W=7.15e-07
MI0_MXPA2_7 XI0_p2__7 B XI0_p1 VDD pm1p2_svt_lp L=6e-08 W=7.15e-07
MI0_MXPA1_7 ny A XI0_p2__7 VDD pm1p2_svt_lp L=6e-08 W=7.15e-07
MI0_MXPA1_8 ny A XI0_p2__8 VDD pm1p2_svt_lp L=6e-08 W=7.15e-07
MI0_MXPA2_8 XI0_p2__8 B XI0_p1 VDD pm1p2_svt_lp L=6e-08 W=7.15e-07
MI0_MXPA2_9 XI0_p2__9 B XI0_p1 VDD pm1p2_svt_lp L=6e-08 W=7.15e-07
MI0_MXPA1_9 ny A XI0_p2__9 VDD pm1p2_svt_lp L=6e-08 W=7.15e-07
MI0_MXPA1 ny A XI0_p2 VDD pm1p2_svt_lp L=6e-08 W=7.15e-07
MI0_MXPA2 XI0_p2 B XI0_p1 VDD pm1p2_svt_lp L=6e-08 W=7.15e-07
MI0_MXPA3 XI0_p1 C VDD VDD pm1p2_svt_lp L=6e-08 W=7.15e-07
MI0_MXPA3_2 XI0_p1 C VDD VDD pm1p2_svt_lp L=6e-08 W=7.15e-07
MI0_MXPA3_3 XI0_p1 C VDD VDD pm1p2_svt_lp L=6e-08 W=7.15e-07
MI0_MXPA3_4 XI0_p1 C VDD VDD pm1p2_svt_lp L=6e-08 W=7.15e-07
MI0_MXPA3_5 XI0_p1 C VDD VDD pm1p2_svt_lp L=6e-08 W=7.15e-07
MI0_MXPA3_6 XI0_p1 C VDD VDD pm1p2_svt_lp L=6e-08 W=7.15e-07
MI0_MXPA3_7 XI0_p1 C VDD VDD pm1p2_svt_lp L=6e-08 W=7.15e-07
MI0_MXPA3_8 XI0_p1 C VDD VDD pm1p2_svt_lp L=6e-08 W=7.15e-07
MI0_MXPA3_9 XI0_p1 C VDD VDD pm1p2_svt_lp L=6e-08 W=7.15e-07
MI1_MXPA1 Y ny VDD VDD pm1p2_svt_lp L=6e-08 W=5.85e-07
MI1_MXPA1_2 Y ny VDD VDD pm1p2_svt_lp L=6e-08 W=5.85e-07
MI1_MXPA1_3 Y ny VDD VDD pm1p2_svt_lp L=6e-08 W=5.85e-07
MI1_MXPA1_4 Y ny VDD VDD pm1p2_svt_lp L=6e-08 W=5.85e-07
MI1_MXPA1_5 Y ny VDD VDD pm1p2_svt_lp L=6e-08 W=5.85e-07
MI1_MXPA1_6 Y ny VDD VDD pm1p2_svt_lp L=6e-08 W=5.85e-07
MI1_MXPA1_7 Y ny VDD VDD pm1p2_svt_lp L=6e-08 W=5.85e-07
MI1_MXPA1_8 Y ny VDD VDD pm1p2_svt_lp L=6e-08 W=5.85e-07
.ENDS

.SUBCKT OR4X0P5H9R Y VDD VSS A B C D
MI0_MXNA2 ab B VSS VSS nm1p2_svt_lp L=6e-08 W=1.5e-07
MI0_MXNA1 ab A VSS VSS nm1p2_svt_lp L=6e-08 W=1.5e-07
MI2_MXNA1 Y ab XI2_n1 VSS nm1p2_svt_lp L=6e-08 W=2.5e-07
MI2_MXNA2 XI2_n1 cd VSS VSS nm1p2_svt_lp L=6e-08 W=2.5e-07
MI1_MXNA2 cd D VSS VSS nm1p2_svt_lp L=6e-08 W=1.5e-07
MI1_MXNA1 cd C VSS VSS nm1p2_svt_lp L=6e-08 W=1.5e-07
MI0_MXPA2 XI0_p1 B VDD VDD pm1p2_svt_lp L=6e-08 W=3.75e-07
MI0_MXPA1 ab A XI0_p1 VDD pm1p2_svt_lp L=6e-08 W=3.75e-07
MI2_MXPA1 Y ab VDD VDD pm1p2_svt_lp L=6e-08 W=2e-07
MI2_MXPA2 Y cd VDD VDD pm1p2_svt_lp L=6e-08 W=2e-07
MI1_MXPA2 XI1_p1 D VDD VDD pm1p2_svt_lp L=6e-08 W=3.75e-07
MI1_MXPA1 cd C XI1_p1 VDD pm1p2_svt_lp L=6e-08 W=3.75e-07
.ENDS

.SUBCKT OR4X0P7H9R Y VDD VSS A B C D
MI0_MXNA2 ab B VSS VSS nm1p2_svt_lp L=6e-08 W=1.5e-07
MI0_MXNA1 ab A VSS VSS nm1p2_svt_lp L=6e-08 W=1.5e-07
MI2_MXNA1 Y ab XI2_n1 VSS nm1p2_svt_lp L=6e-08 W=3.5e-07
MI2_MXNA2 XI2_n1 cd VSS VSS nm1p2_svt_lp L=6e-08 W=3.5e-07
MI1_MXNA2 cd D VSS VSS nm1p2_svt_lp L=6e-08 W=1.5e-07
MI1_MXNA1 cd C VSS VSS nm1p2_svt_lp L=6e-08 W=1.5e-07
MI0_MXPA2 XI0_p1 B VDD VDD pm1p2_svt_lp L=6e-08 W=3.75e-07
MI0_MXPA1 ab A XI0_p1 VDD pm1p2_svt_lp L=6e-08 W=3.75e-07
MI2_MXPA1 Y ab VDD VDD pm1p2_svt_lp L=6e-08 W=2.8e-07
MI2_MXPA2 Y cd VDD VDD pm1p2_svt_lp L=6e-08 W=2.8e-07
MI1_MXPA2 XI1_p1 D VDD VDD pm1p2_svt_lp L=6e-08 W=3.75e-07
MI1_MXPA1 cd C XI1_p1 VDD pm1p2_svt_lp L=6e-08 W=3.75e-07
.ENDS

.SUBCKT OR4X1H9R Y VDD VSS A B C D
MI0_MXNA2 ab B VSS VSS nm1p2_svt_lp L=6e-08 W=1.65e-07
MI0_MXNA1 ab A VSS VSS nm1p2_svt_lp L=6e-08 W=1.65e-07
MI2_MXNA1 Y ab XI2_n1 VSS nm1p2_svt_lp L=6e-08 W=4.95e-07
MI2_MXNA2 XI2_n1 cd VSS VSS nm1p2_svt_lp L=6e-08 W=4.95e-07
MI1_MXNA2 cd D VSS VSS nm1p2_svt_lp L=6e-08 W=1.65e-07
MI1_MXNA1 cd C VSS VSS nm1p2_svt_lp L=6e-08 W=1.65e-07
MI0_MXPA2 XI0_p1 B VDD VDD pm1p2_svt_lp L=6e-08 W=4.05e-07
MI0_MXPA1 ab A XI0_p1 VDD pm1p2_svt_lp L=6e-08 W=4.05e-07
MI2_MXPA1 Y ab VDD VDD pm1p2_svt_lp L=6e-08 W=3.95e-07
MI2_MXPA2 Y cd VDD VDD pm1p2_svt_lp L=6e-08 W=3.95e-07
MI1_MXPA2 XI1_p1 D VDD VDD pm1p2_svt_lp L=6e-08 W=4.05e-07
MI1_MXPA1 cd C XI1_p1 VDD pm1p2_svt_lp L=6e-08 W=4.05e-07
.ENDS

.SUBCKT OR4X1P4H9R Y VDD VSS A B C D
MI0_MXNA1 ab A VSS VSS nm1p2_svt_lp L=6e-08 W=2.15e-07
MI0_MXNA2 ab B VSS VSS nm1p2_svt_lp L=6e-08 W=2.15e-07
MI2_MXNA2_2 XI2_n1__2 cd VSS VSS nm1p2_svt_lp L=6e-08 W=3.5e-07
MI2_MXNA1_2 Y ab XI2_n1__2 VSS nm1p2_svt_lp L=6e-08 W=3.5e-07
MI2_MXNA1 Y ab XI2_n1 VSS nm1p2_svt_lp L=6e-08 W=3.5e-07
MI2_MXNA2 XI2_n1 cd VSS VSS nm1p2_svt_lp L=6e-08 W=3.5e-07
MI1_MXNA2 cd D VSS VSS nm1p2_svt_lp L=6e-08 W=2.15e-07
MI1_MXNA1 cd C VSS VSS nm1p2_svt_lp L=6e-08 W=2.15e-07
MI0_MXPA1 ab A XI0_p1 VDD pm1p2_svt_lp L=6e-08 W=5.4e-07
MI0_MXPA2 XI0_p1 B VDD VDD pm1p2_svt_lp L=6e-08 W=5.4e-07
MI2_MXPA2 Y cd VDD VDD pm1p2_svt_lp L=6e-08 W=5.6e-07
MI2_MXPA1 Y ab VDD VDD pm1p2_svt_lp L=6e-08 W=5.6e-07
MI1_MXPA2 XI1_p1 D VDD VDD pm1p2_svt_lp L=6e-08 W=5.4e-07
MI1_MXPA1 cd C XI1_p1 VDD pm1p2_svt_lp L=6e-08 W=5.4e-07
.ENDS

.SUBCKT OR4X2H9R Y VDD VSS A B C D
MI0_MXNA1 ab A VSS VSS nm1p2_svt_lp L=6e-08 W=3.2e-07
MI0_MXNA2 ab B VSS VSS nm1p2_svt_lp L=6e-08 W=3.2e-07
MI2_MXNA2_2 XI2_n1__2 cd VSS VSS nm1p2_svt_lp L=6e-08 W=4.95e-07
MI2_MXNA1_2 Y ab XI2_n1__2 VSS nm1p2_svt_lp L=6e-08 W=4.95e-07
MI2_MXNA1 Y ab XI2_n1 VSS nm1p2_svt_lp L=6e-08 W=4.95e-07
MI2_MXNA2 XI2_n1 cd VSS VSS nm1p2_svt_lp L=6e-08 W=4.95e-07
MI1_MXNA2 cd D VSS VSS nm1p2_svt_lp L=6e-08 W=3.2e-07
MI1_MXNA1 cd C VSS VSS nm1p2_svt_lp L=6e-08 W=3.2e-07
MI0_MXPA2_2 XI0_p1__2 B VDD VDD pm1p2_svt_lp L=6e-08 W=3.95e-07
MI0_MXPA1_2 ab A XI0_p1__2 VDD pm1p2_svt_lp L=6e-08 W=3.95e-07
MI0_MXPA1 ab A XI0_p1 VDD pm1p2_svt_lp L=6e-08 W=3.95e-07
MI0_MXPA2 XI0_p1 B VDD VDD pm1p2_svt_lp L=6e-08 W=3.95e-07
MI2_MXPA2 Y cd VDD VDD pm1p2_svt_lp L=6e-08 W=3.95e-07
MI2_MXPA1 Y ab VDD VDD pm1p2_svt_lp L=6e-08 W=3.95e-07
MI2_MXPA1_2 Y ab VDD VDD pm1p2_svt_lp L=6e-08 W=3.95e-07
MI2_MXPA2_2 Y cd VDD VDD pm1p2_svt_lp L=6e-08 W=3.95e-07
MI1_MXPA2_2 XI1_p1__2 D VDD VDD pm1p2_svt_lp L=6e-08 W=3.95e-07
MI1_MXPA1_2 cd C XI1_p1__2 VDD pm1p2_svt_lp L=6e-08 W=3.95e-07
MI1_MXPA1 cd C XI1_p1 VDD pm1p2_svt_lp L=6e-08 W=3.95e-07
MI1_MXPA2 XI1_p1 D VDD VDD pm1p2_svt_lp L=6e-08 W=3.95e-07
.ENDS

.SUBCKT OR4X3H9R Y VDD VSS A B C D
MI0_MXNA2 ab B VSS VSS nm1p2_svt_lp L=6e-08 W=4.4e-07
MI0_MXNA1 ab A VSS VSS nm1p2_svt_lp L=6e-08 W=4.4e-07
MI2_MXNA1 Y ab XI2_n1 VSS nm1p2_svt_lp L=6e-08 W=4.95e-07
MI2_MXNA1_2 Y ab XI2_n1 VSS nm1p2_svt_lp L=6e-08 W=4.95e-07
MI2_MXNA1_3 Y ab XI2_n1 VSS nm1p2_svt_lp L=6e-08 W=4.95e-07
MI2_MXNA2 XI2_n1 cd VSS VSS nm1p2_svt_lp L=6e-08 W=4.95e-07
MI2_MXNA2_2 XI2_n1 cd VSS VSS nm1p2_svt_lp L=6e-08 W=4.95e-07
MI2_MXNA2_3 XI2_n1 cd VSS VSS nm1p2_svt_lp L=6e-08 W=4.95e-07
MI1_MXNA1 cd C VSS VSS nm1p2_svt_lp L=6e-08 W=4.4e-07
MI1_MXNA2 cd D VSS VSS nm1p2_svt_lp L=6e-08 W=4.4e-07
MI0_MXPA2_2 XI0_p1__2 B VDD VDD pm1p2_svt_lp L=6e-08 W=5.4e-07
MI0_MXPA1_2 ab A XI0_p1__2 VDD pm1p2_svt_lp L=6e-08 W=5.4e-07
MI0_MXPA1 ab A XI0_p1 VDD pm1p2_svt_lp L=6e-08 W=5.4e-07
MI0_MXPA2 XI0_p1 B VDD VDD pm1p2_svt_lp L=6e-08 W=5.4e-07
MI2_MXPA1 Y ab VDD VDD pm1p2_svt_lp L=6e-08 W=3.95e-07
MI2_MXPA1_2 Y ab VDD VDD pm1p2_svt_lp L=6e-08 W=3.95e-07
MI2_MXPA1_3 Y ab VDD VDD pm1p2_svt_lp L=6e-08 W=3.95e-07
MI2_MXPA2 Y cd VDD VDD pm1p2_svt_lp L=6e-08 W=3.95e-07
MI2_MXPA2_2 Y cd VDD VDD pm1p2_svt_lp L=6e-08 W=3.95e-07
MI2_MXPA2_3 Y cd VDD VDD pm1p2_svt_lp L=6e-08 W=3.95e-07
MI1_MXPA2_2 XI1_p1__2 D VDD VDD pm1p2_svt_lp L=6e-08 W=5.4e-07
MI1_MXPA1_2 cd C XI1_p1__2 VDD pm1p2_svt_lp L=6e-08 W=5.4e-07
MI1_MXPA1 cd C XI1_p1 VDD pm1p2_svt_lp L=6e-08 W=5.4e-07
MI1_MXPA2 XI1_p1 D VDD VDD pm1p2_svt_lp L=6e-08 W=5.4e-07
.ENDS

.SUBCKT OR4X4H9R Y VDD VSS A B C D
MI0_MXNA2 ab B VSS VSS nm1p2_svt_lp L=6e-08 W=3.1e-07
MI0_MXNA1 ab A VSS VSS nm1p2_svt_lp L=6e-08 W=3.1e-07
MI0_MXNA1_2 ab A VSS VSS nm1p2_svt_lp L=6e-08 W=3.1e-07
MI0_MXNA2_2 ab B VSS VSS nm1p2_svt_lp L=6e-08 W=3.1e-07
MI2_MXNA2_2 XI2_n1__2 cd VSS VSS nm1p2_svt_lp L=6e-08 W=4.95e-07
MI2_MXNA1_2 Y ab XI2_n1__2 VSS nm1p2_svt_lp L=6e-08 W=4.95e-07
MI2_MXNA1_3 Y ab XI2_n1__3 VSS nm1p2_svt_lp L=6e-08 W=4.95e-07
MI2_MXNA2_3 XI2_n1__3 cd VSS VSS nm1p2_svt_lp L=6e-08 W=4.95e-07
MI2_MXNA2_4 XI2_n1__4 cd VSS VSS nm1p2_svt_lp L=6e-08 W=4.95e-07
MI2_MXNA1_4 Y ab XI2_n1__4 VSS nm1p2_svt_lp L=6e-08 W=4.95e-07
MI2_MXNA1 Y ab XI2_n1 VSS nm1p2_svt_lp L=6e-08 W=4.95e-07
MI2_MXNA2 XI2_n1 cd VSS VSS nm1p2_svt_lp L=6e-08 W=4.95e-07
MI1_MXNA2 cd D VSS VSS nm1p2_svt_lp L=6e-08 W=3.1e-07
MI1_MXNA1 cd C VSS VSS nm1p2_svt_lp L=6e-08 W=3.1e-07
MI1_MXNA1_2 cd C VSS VSS nm1p2_svt_lp L=6e-08 W=3.1e-07
MI1_MXNA2_2 cd D VSS VSS nm1p2_svt_lp L=6e-08 W=3.1e-07
MI0_MXPA1_2 ab A XI0_p1__2 VDD pm1p2_svt_lp L=6e-08 W=5.05e-07
MI0_MXPA2_2 XI0_p1__2 B VDD VDD pm1p2_svt_lp L=6e-08 W=5.05e-07
MI0_MXPA2_3 XI0_p1__3 B VDD VDD pm1p2_svt_lp L=6e-08 W=5.05e-07
MI0_MXPA1_3 ab A XI0_p1__3 VDD pm1p2_svt_lp L=6e-08 W=5.05e-07
MI0_MXPA1 ab A XI0_p1 VDD pm1p2_svt_lp L=6e-08 W=5.05e-07
MI0_MXPA2 XI0_p1 B VDD VDD pm1p2_svt_lp L=6e-08 W=5.05e-07
MI2_MXPA2 Y cd VDD VDD pm1p2_svt_lp L=6e-08 W=5.3e-07
MI2_MXPA1 Y ab VDD VDD pm1p2_svt_lp L=6e-08 W=5.3e-07
MI2_MXPA1_2 Y ab VDD VDD pm1p2_svt_lp L=6e-08 W=5.3e-07
MI2_MXPA2_2 Y cd VDD VDD pm1p2_svt_lp L=6e-08 W=5.3e-07
MI2_MXPA2_3 Y cd VDD VDD pm1p2_svt_lp L=6e-08 W=5.3e-07
MI2_MXPA1_3 Y ab VDD VDD pm1p2_svt_lp L=6e-08 W=5.3e-07
MI1_MXPA2_2 XI1_p1__2 D VDD VDD pm1p2_svt_lp L=6e-08 W=5.05e-07
MI1_MXPA1_2 cd C XI1_p1__2 VDD pm1p2_svt_lp L=6e-08 W=5.05e-07
MI1_MXPA1_3 cd C XI1_p1__3 VDD pm1p2_svt_lp L=6e-08 W=5.05e-07
MI1_MXPA2_3 XI1_p1__3 D VDD VDD pm1p2_svt_lp L=6e-08 W=5.05e-07
MI1_MXPA2 XI1_p1 D VDD VDD pm1p2_svt_lp L=6e-08 W=5.05e-07
MI1_MXPA1 cd C XI1_p1 VDD pm1p2_svt_lp L=6e-08 W=5.05e-07
.ENDS

.SUBCKT OR4X6H9R Y VDD VSS A B C D
MI1_MXNA2 cd D VSS VSS nm1p2_svt_lp L=6e-08 W=4.5e-07
MI1_MXNA2_2 cd D VSS VSS nm1p2_svt_lp L=6e-08 W=4.5e-07
MI1_MXNA1 cd C VSS VSS nm1p2_svt_lp L=6e-08 W=4.5e-07
MI1_MXNA1_2 cd C VSS VSS nm1p2_svt_lp L=6e-08 W=4.5e-07
MI2_MXNA2 XI2_n1 cd VSS VSS nm1p2_svt_lp L=6e-08 W=4.95e-07
MI2_MXNA2_2 XI2_n1 cd VSS VSS nm1p2_svt_lp L=6e-08 W=4.95e-07
MI2_MXNA2_3 XI2_n1 cd VSS VSS nm1p2_svt_lp L=6e-08 W=4.95e-07
MI2_MXNA2_4 XI2_n1 cd VSS VSS nm1p2_svt_lp L=6e-08 W=4.95e-07
MI2_MXNA2_5 XI2_n1 cd VSS VSS nm1p2_svt_lp L=6e-08 W=4.95e-07
MI2_MXNA2_6 XI2_n1 cd VSS VSS nm1p2_svt_lp L=6e-08 W=4.95e-07
MI2_MXNA1 Y ab XI2_n1 VSS nm1p2_svt_lp L=6e-08 W=4.95e-07
MI2_MXNA1_2 Y ab XI2_n1 VSS nm1p2_svt_lp L=6e-08 W=4.95e-07
MI2_MXNA1_3 Y ab XI2_n1 VSS nm1p2_svt_lp L=6e-08 W=4.95e-07
MI2_MXNA1_4 Y ab XI2_n1 VSS nm1p2_svt_lp L=6e-08 W=4.95e-07
MI2_MXNA1_5 Y ab XI2_n1 VSS nm1p2_svt_lp L=6e-08 W=4.95e-07
MI2_MXNA1_6 Y ab XI2_n1 VSS nm1p2_svt_lp L=6e-08 W=4.95e-07
MI0_MXNA1 ab A VSS VSS nm1p2_svt_lp L=6e-08 W=4.5e-07
MI0_MXNA1_2 ab A VSS VSS nm1p2_svt_lp L=6e-08 W=4.5e-07
MI0_MXNA2 ab B VSS VSS nm1p2_svt_lp L=6e-08 W=4.5e-07
MI0_MXNA2_2 ab B VSS VSS nm1p2_svt_lp L=6e-08 W=4.5e-07
MI1_MXPA2 XI1_p1 D VDD VDD pm1p2_svt_lp L=6e-08 W=5.55e-07
MI1_MXPA2_2 XI1_p1 D VDD VDD pm1p2_svt_lp L=6e-08 W=5.55e-07
MI1_MXPA2_3 XI1_p1 D VDD VDD pm1p2_svt_lp L=6e-08 W=5.55e-07
MI1_MXPA2_4 XI1_p1 D VDD VDD pm1p2_svt_lp L=6e-08 W=5.55e-07
MI1_MXPA1 cd C XI1_p1 VDD pm1p2_svt_lp L=6e-08 W=5.55e-07
MI1_MXPA1_2 cd C XI1_p1 VDD pm1p2_svt_lp L=6e-08 W=5.55e-07
MI1_MXPA1_3 cd C XI1_p1 VDD pm1p2_svt_lp L=6e-08 W=5.55e-07
MI1_MXPA1_4 cd C XI1_p1 VDD pm1p2_svt_lp L=6e-08 W=5.55e-07
MI2_MXPA2 Y cd VDD VDD pm1p2_svt_lp L=6e-08 W=4.75e-07
MI2_MXPA2_2 Y cd VDD VDD pm1p2_svt_lp L=6e-08 W=4.75e-07
MI2_MXPA2_3 Y cd VDD VDD pm1p2_svt_lp L=6e-08 W=4.75e-07
MI2_MXPA2_4 Y cd VDD VDD pm1p2_svt_lp L=6e-08 W=4.75e-07
MI2_MXPA2_5 Y cd VDD VDD pm1p2_svt_lp L=6e-08 W=4.75e-07
MI2_MXPA1 Y ab VDD VDD pm1p2_svt_lp L=6e-08 W=4.75e-07
MI2_MXPA1_2 Y ab VDD VDD pm1p2_svt_lp L=6e-08 W=4.75e-07
MI2_MXPA1_3 Y ab VDD VDD pm1p2_svt_lp L=6e-08 W=4.75e-07
MI2_MXPA1_4 Y ab VDD VDD pm1p2_svt_lp L=6e-08 W=4.75e-07
MI2_MXPA1_5 Y ab VDD VDD pm1p2_svt_lp L=6e-08 W=4.75e-07
MI0_MXPA1 ab A XI0_p1 VDD pm1p2_svt_lp L=6e-08 W=5.55e-07
MI0_MXPA1_2 ab A XI0_p1 VDD pm1p2_svt_lp L=6e-08 W=5.55e-07
MI0_MXPA1_3 ab A XI0_p1 VDD pm1p2_svt_lp L=6e-08 W=5.55e-07
MI0_MXPA1_4 ab A XI0_p1 VDD pm1p2_svt_lp L=6e-08 W=5.55e-07
MI0_MXPA2 XI0_p1 B VDD VDD pm1p2_svt_lp L=6e-08 W=5.55e-07
MI0_MXPA2_2 XI0_p1 B VDD VDD pm1p2_svt_lp L=6e-08 W=5.55e-07
MI0_MXPA2_3 XI0_p1 B VDD VDD pm1p2_svt_lp L=6e-08 W=5.55e-07
MI0_MXPA2_4 XI0_p1 B VDD VDD pm1p2_svt_lp L=6e-08 W=5.55e-07
.ENDS

.SUBCKT OR4X8H9R Y VDD VSS A B C D
MI0_MXNA2 ab B VSS VSS nm1p2_svt_lp L=6e-08 W=2.95e-07
MI0_MXNA2_2 ab B VSS VSS nm1p2_svt_lp L=6e-08 W=2.95e-07
MI0_MXNA2_3 ab B VSS VSS nm1p2_svt_lp L=6e-08 W=2.95e-07
MI0_MXNA2_4 ab B VSS VSS nm1p2_svt_lp L=6e-08 W=2.95e-07
MI0_MXNA1 ab A VSS VSS nm1p2_svt_lp L=6e-08 W=2.95e-07
MI0_MXNA1_2 ab A VSS VSS nm1p2_svt_lp L=6e-08 W=2.95e-07
MI0_MXNA1_3 ab A VSS VSS nm1p2_svt_lp L=6e-08 W=2.95e-07
MI0_MXNA1_4 ab A VSS VSS nm1p2_svt_lp L=6e-08 W=2.95e-07
MI2_MXNA1 Y ab XI2_n1 VSS nm1p2_svt_lp L=6e-08 W=5.7e-07
MI2_MXNA1_2 Y ab XI2_n1 VSS nm1p2_svt_lp L=6e-08 W=5.7e-07
MI2_MXNA1_3 Y ab XI2_n1 VSS nm1p2_svt_lp L=6e-08 W=5.7e-07
MI2_MXNA1_4 Y ab XI2_n1 VSS nm1p2_svt_lp L=6e-08 W=5.7e-07
MI2_MXNA1_5 Y ab XI2_n1 VSS nm1p2_svt_lp L=6e-08 W=5.7e-07
MI2_MXNA1_6 Y ab XI2_n1 VSS nm1p2_svt_lp L=6e-08 W=5.7e-07
MI2_MXNA1_7 Y ab XI2_n1 VSS nm1p2_svt_lp L=6e-08 W=5.7e-07
MI2_MXNA2 XI2_n1 cd VSS VSS nm1p2_svt_lp L=6e-08 W=5.7e-07
MI2_MXNA2_2 XI2_n1 cd VSS VSS nm1p2_svt_lp L=6e-08 W=5.7e-07
MI2_MXNA2_3 XI2_n1 cd VSS VSS nm1p2_svt_lp L=6e-08 W=5.7e-07
MI2_MXNA2_4 XI2_n1 cd VSS VSS nm1p2_svt_lp L=6e-08 W=5.7e-07
MI2_MXNA2_5 XI2_n1 cd VSS VSS nm1p2_svt_lp L=6e-08 W=5.7e-07
MI2_MXNA2_6 XI2_n1 cd VSS VSS nm1p2_svt_lp L=6e-08 W=5.7e-07
MI2_MXNA2_7 XI2_n1 cd VSS VSS nm1p2_svt_lp L=6e-08 W=5.7e-07
MI1_MXNA2 cd D VSS VSS nm1p2_svt_lp L=6e-08 W=2.95e-07
MI1_MXNA2_2 cd D VSS VSS nm1p2_svt_lp L=6e-08 W=2.95e-07
MI1_MXNA2_3 cd D VSS VSS nm1p2_svt_lp L=6e-08 W=2.95e-07
MI1_MXNA2_4 cd D VSS VSS nm1p2_svt_lp L=6e-08 W=2.95e-07
MI1_MXNA1 cd C VSS VSS nm1p2_svt_lp L=6e-08 W=2.95e-07
MI1_MXNA1_2 cd C VSS VSS nm1p2_svt_lp L=6e-08 W=2.95e-07
MI1_MXNA1_3 cd C VSS VSS nm1p2_svt_lp L=6e-08 W=2.95e-07
MI1_MXNA1_4 cd C VSS VSS nm1p2_svt_lp L=6e-08 W=2.95e-07
MI0_MXPA2 XI0_p1 B VDD VDD pm1p2_svt_lp L=6e-08 W=7.35e-07
MI0_MXPA2_2 XI0_p1 B VDD VDD pm1p2_svt_lp L=6e-08 W=7.35e-07
MI0_MXPA2_3 XI0_p1 B VDD VDD pm1p2_svt_lp L=6e-08 W=7.35e-07
MI0_MXPA2_4 XI0_p1 B VDD VDD pm1p2_svt_lp L=6e-08 W=7.35e-07
MI0_MXPA1 ab A XI0_p1 VDD pm1p2_svt_lp L=6e-08 W=7.35e-07
MI0_MXPA1_2 ab A XI0_p1 VDD pm1p2_svt_lp L=6e-08 W=7.35e-07
MI0_MXPA1_3 ab A XI0_p1 VDD pm1p2_svt_lp L=6e-08 W=7.35e-07
MI0_MXPA1_4 ab A XI0_p1 VDD pm1p2_svt_lp L=6e-08 W=7.35e-07
MI2_MXPA1 Y ab VDD VDD pm1p2_svt_lp L=6e-08 W=4.55e-07
MI2_MXPA1_2 Y ab VDD VDD pm1p2_svt_lp L=6e-08 W=4.55e-07
MI2_MXPA1_3 Y ab VDD VDD pm1p2_svt_lp L=6e-08 W=4.55e-07
MI2_MXPA1_4 Y ab VDD VDD pm1p2_svt_lp L=6e-08 W=4.55e-07
MI2_MXPA1_5 Y ab VDD VDD pm1p2_svt_lp L=6e-08 W=4.55e-07
MI2_MXPA1_6 Y ab VDD VDD pm1p2_svt_lp L=6e-08 W=4.55e-07
MI2_MXPA1_7 Y ab VDD VDD pm1p2_svt_lp L=6e-08 W=4.55e-07
MI2_MXPA2 Y cd VDD VDD pm1p2_svt_lp L=6e-08 W=4.55e-07
MI2_MXPA2_2 Y cd VDD VDD pm1p2_svt_lp L=6e-08 W=4.55e-07
MI2_MXPA2_3 Y cd VDD VDD pm1p2_svt_lp L=6e-08 W=4.55e-07
MI2_MXPA2_4 Y cd VDD VDD pm1p2_svt_lp L=6e-08 W=4.55e-07
MI2_MXPA2_5 Y cd VDD VDD pm1p2_svt_lp L=6e-08 W=4.55e-07
MI2_MXPA2_6 Y cd VDD VDD pm1p2_svt_lp L=6e-08 W=4.55e-07
MI2_MXPA2_7 Y cd VDD VDD pm1p2_svt_lp L=6e-08 W=4.55e-07
MI1_MXPA2 XI1_p1 D VDD VDD pm1p2_svt_lp L=6e-08 W=7.35e-07
MI1_MXPA2_2 XI1_p1 D VDD VDD pm1p2_svt_lp L=6e-08 W=7.35e-07
MI1_MXPA2_3 XI1_p1 D VDD VDD pm1p2_svt_lp L=6e-08 W=7.35e-07
MI1_MXPA2_4 XI1_p1 D VDD VDD pm1p2_svt_lp L=6e-08 W=7.35e-07
MI1_MXPA1 cd C XI1_p1 VDD pm1p2_svt_lp L=6e-08 W=7.35e-07
MI1_MXPA1_2 cd C XI1_p1 VDD pm1p2_svt_lp L=6e-08 W=7.35e-07
MI1_MXPA1_3 cd C XI1_p1 VDD pm1p2_svt_lp L=6e-08 W=7.35e-07
MI1_MXPA1_4 cd C XI1_p1 VDD pm1p2_svt_lp L=6e-08 W=7.35e-07
.ENDS

.SUBCKT XNOR2X0P5H9R Y VDD VSS A B
MI0_MXNA1 na A VSS VSS nm1p2_svt_lp L=6e-08 W=2.8e-07
MI1_MXNA1 nb B VSS VSS nm1p2_svt_lp L=6e-08 W=2.55e-07
MI2_MXNOE Y na nb VSS nm1p2_svt_lp L=6e-08 W=2.25e-07
MI4_MXNOE Y A bb VSS nm1p2_svt_lp L=6e-08 W=2.25e-07
MI3_MXNA1 bb nb VSS VSS nm1p2_svt_lp L=6e-08 W=2.55e-07
MI0_MXPA1 na A VDD VDD pm1p2_svt_lp L=6e-08 W=3.9e-07
MI1_MXPA1 nb B VDD VDD pm1p2_svt_lp L=6e-08 W=3.15e-07
MI2_MXPOEN Y A nb VDD pm1p2_svt_lp L=6e-08 W=2.25e-07
MI4_MXPOEN Y na bb VDD pm1p2_svt_lp L=6e-08 W=2.25e-07
MI3_MXPA1 bb nb VDD VDD pm1p2_svt_lp L=6e-08 W=3.15e-07
.ENDS

.SUBCKT XNOR2X0P7H9R Y VDD VSS A B
MI0_MXNA1 na A VSS VSS nm1p2_svt_lp L=6e-08 W=3.4e-07
MI1_MXNA1 nb B VSS VSS nm1p2_svt_lp L=6e-08 W=3.15e-07
MI2_MXNOE Y na nb VSS nm1p2_svt_lp L=6e-08 W=3.15e-07
MI4_MXNOE Y A bb VSS nm1p2_svt_lp L=6e-08 W=3.15e-07
MI3_MXNA1 bb nb VSS VSS nm1p2_svt_lp L=6e-08 W=3.15e-07
MI0_MXPA1 na A VDD VDD pm1p2_svt_lp L=6e-08 W=4.75e-07
MI1_MXPA1 nb B VDD VDD pm1p2_svt_lp L=6e-08 W=4.4e-07
MI2_MXPOEN Y A nb VDD pm1p2_svt_lp L=6e-08 W=3.15e-07
MI4_MXPOEN Y na bb VDD pm1p2_svt_lp L=6e-08 W=3.15e-07
MI3_MXPA1 bb nb VDD VDD pm1p2_svt_lp L=6e-08 W=4.4e-07
.ENDS

.SUBCKT XNOR2X1H9R Y VDD VSS A B
MI0_MXNA1 na A VSS VSS nm1p2_svt_lp L=6e-08 W=4.15e-07
MI1_MXNA1 nb B VSS VSS nm1p2_svt_lp L=6e-08 W=4.5e-07
MI2_MXNOE Y na nb VSS nm1p2_svt_lp L=6e-08 W=4.5e-07
MI4_MXNOE Y A bb VSS nm1p2_svt_lp L=6e-08 W=4.5e-07
MI3_MXNA1 bb nb VSS VSS nm1p2_svt_lp L=6e-08 W=4.5e-07
MI0_MXPA1 na A VDD VDD pm1p2_svt_lp L=6e-08 W=5.85e-07
MI1_MXPA1 nb B VDD VDD pm1p2_svt_lp L=6e-08 W=5.85e-07
MI2_MXPOEN Y A nb VDD pm1p2_svt_lp L=6e-08 W=4.5e-07
MI4_MXPOEN Y na bb VDD pm1p2_svt_lp L=6e-08 W=4.5e-07
MI3_MXPA1 bb nb VDD VDD pm1p2_svt_lp L=6e-08 W=5.85e-07
.ENDS

.SUBCKT XNOR2X1P4H9R Y VDD VSS A B
MI1_MXNA1 nb B VSS VSS nm1p2_svt_lp L=6e-08 W=3.15e-07
MI1_MXNA1_2 nb B VSS VSS nm1p2_svt_lp L=6e-08 W=3.15e-07
MI0_MXNA1 na A VSS VSS nm1p2_svt_lp L=6e-08 W=2.7e-07
MI0_MXNA1_2 na A VSS VSS nm1p2_svt_lp L=6e-08 W=2.7e-07
MI2_MXNOE Y na nb VSS nm1p2_svt_lp L=6e-08 W=3.15e-07
MI2_MXNOE_2 Y na nb VSS nm1p2_svt_lp L=6e-08 W=3.15e-07
MI4_MXNOE Y A bb VSS nm1p2_svt_lp L=6e-08 W=3.15e-07
MI4_MXNOE_2 Y A bb VSS nm1p2_svt_lp L=6e-08 W=3.15e-07
MI3_MXNA1 bb nb VSS VSS nm1p2_svt_lp L=6e-08 W=3.15e-07
MI3_MXNA1_2 bb nb VSS VSS nm1p2_svt_lp L=6e-08 W=3.15e-07
MI1_MXPA1 nb B VDD VDD pm1p2_svt_lp L=6e-08 W=4.4e-07
MI1_MXPA1_2 nb B VDD VDD pm1p2_svt_lp L=6e-08 W=4.4e-07
MI0_MXPA1 na A VDD VDD pm1p2_svt_lp L=6e-08 W=3.75e-07
MI0_MXPA1_2 na A VDD VDD pm1p2_svt_lp L=6e-08 W=3.75e-07
MI4_MXPOEN Y na bb VDD pm1p2_svt_lp L=6e-08 W=3.15e-07
MI4_MXPOEN_2 Y na bb VDD pm1p2_svt_lp L=6e-08 W=3.15e-07
MI2_MXPOEN Y A nb VDD pm1p2_svt_lp L=6e-08 W=3.15e-07
MI2_MXPOEN_2 Y A nb VDD pm1p2_svt_lp L=6e-08 W=3.15e-07
MI3_MXPA1 bb nb VDD VDD pm1p2_svt_lp L=6e-08 W=4.4e-07
MI3_MXPA1_2 bb nb VDD VDD pm1p2_svt_lp L=6e-08 W=4.4e-07
.ENDS

.SUBCKT XNOR2X2H9R Y VDD VSS A B
MI1_MXNA1 nb B VSS VSS nm1p2_svt_lp L=6e-08 W=4.4e-07
MI1_MXNA1_2 nb B VSS VSS nm1p2_svt_lp L=6e-08 W=4.4e-07
MI0_MXNA1 na A VSS VSS nm1p2_svt_lp L=6e-08 W=3.2e-07
MI0_MXNA1_2 na A VSS VSS nm1p2_svt_lp L=6e-08 W=3.2e-07
MI2_MXNOE Y na nb VSS nm1p2_svt_lp L=6e-08 W=4.4e-07
MI2_MXNOE_2 Y na nb VSS nm1p2_svt_lp L=6e-08 W=4.4e-07
MI4_MXNOE Y A bb VSS nm1p2_svt_lp L=6e-08 W=4.4e-07
MI4_MXNOE_2 Y A bb VSS nm1p2_svt_lp L=6e-08 W=4.4e-07
MI3_MXNA1 bb nb VSS VSS nm1p2_svt_lp L=6e-08 W=4.4e-07
MI3_MXNA1_2 bb nb VSS VSS nm1p2_svt_lp L=6e-08 W=4.4e-07
MI1_MXPA1 nb B VDD VDD pm1p2_svt_lp L=6e-08 W=5.85e-07
MI1_MXPA1_2 nb B VDD VDD pm1p2_svt_lp L=6e-08 W=5.85e-07
MI0_MXPA1 na A VDD VDD pm1p2_svt_lp L=6e-08 W=4.45e-07
MI0_MXPA1_2 na A VDD VDD pm1p2_svt_lp L=6e-08 W=4.45e-07
MI4_MXPOEN Y na bb VDD pm1p2_svt_lp L=6e-08 W=4.4e-07
MI4_MXPOEN_2 Y na bb VDD pm1p2_svt_lp L=6e-08 W=4.4e-07
MI2_MXPOEN Y A nb VDD pm1p2_svt_lp L=6e-08 W=4.4e-07
MI2_MXPOEN_2 Y A nb VDD pm1p2_svt_lp L=6e-08 W=4.4e-07
MI3_MXPA1 bb nb VDD VDD pm1p2_svt_lp L=6e-08 W=5.85e-07
MI3_MXPA1_2 bb nb VDD VDD pm1p2_svt_lp L=6e-08 W=5.85e-07
.ENDS

.SUBCKT XNOR2X3H9R Y VDD VSS A B
MI1_MXNA1 nb B VSS VSS nm1p2_svt_lp L=6e-08 W=4.4e-07
MI1_MXNA1_2 nb B VSS VSS nm1p2_svt_lp L=6e-08 W=4.4e-07
MI1_MXNA1_3 nb B VSS VSS nm1p2_svt_lp L=6e-08 W=4.4e-07
MI0_MXNA1 na A VSS VSS nm1p2_svt_lp L=6e-08 W=4.15e-07
MI0_MXNA1_2 na A VSS VSS nm1p2_svt_lp L=6e-08 W=4.15e-07
MI2_MXNOE Y na nb VSS nm1p2_svt_lp L=6e-08 W=4.4e-07
MI2_MXNOE_2 Y na nb VSS nm1p2_svt_lp L=6e-08 W=4.4e-07
MI2_MXNOE_3 Y na nb VSS nm1p2_svt_lp L=6e-08 W=4.4e-07
MI4_MXNOE Y A bb VSS nm1p2_svt_lp L=6e-08 W=4.4e-07
MI4_MXNOE_2 Y A bb VSS nm1p2_svt_lp L=6e-08 W=4.4e-07
MI4_MXNOE_3 Y A bb VSS nm1p2_svt_lp L=6e-08 W=4.4e-07
MI3_MXNA1 bb nb VSS VSS nm1p2_svt_lp L=6e-08 W=4.4e-07
MI3_MXNA1_2 bb nb VSS VSS nm1p2_svt_lp L=6e-08 W=4.4e-07
MI3_MXNA1_3 bb nb VSS VSS nm1p2_svt_lp L=6e-08 W=4.4e-07
MI1_MXPA1 nb B VDD VDD pm1p2_svt_lp L=6e-08 W=5.85e-07
MI1_MXPA1_2 nb B VDD VDD pm1p2_svt_lp L=6e-08 W=5.85e-07
MI1_MXPA1_3 nb B VDD VDD pm1p2_svt_lp L=6e-08 W=5.85e-07
MI0_MXPA1 na A VDD VDD pm1p2_svt_lp L=6e-08 W=5.8e-07
MI0_MXPA1_2 na A VDD VDD pm1p2_svt_lp L=6e-08 W=5.8e-07
MI4_MXPOEN Y na bb VDD pm1p2_svt_lp L=6e-08 W=4.4e-07
MI4_MXPOEN_2 Y na bb VDD pm1p2_svt_lp L=6e-08 W=4.4e-07
MI4_MXPOEN_3 Y na bb VDD pm1p2_svt_lp L=6e-08 W=4.4e-07
MI2_MXPOEN Y A nb VDD pm1p2_svt_lp L=6e-08 W=4.4e-07
MI2_MXPOEN_2 Y A nb VDD pm1p2_svt_lp L=6e-08 W=4.4e-07
MI2_MXPOEN_3 Y A nb VDD pm1p2_svt_lp L=6e-08 W=4.4e-07
MI3_MXPA1 bb nb VDD VDD pm1p2_svt_lp L=6e-08 W=5.85e-07
MI3_MXPA1_2 bb nb VDD VDD pm1p2_svt_lp L=6e-08 W=5.85e-07
MI3_MXPA1_3 bb nb VDD VDD pm1p2_svt_lp L=6e-08 W=5.85e-07
.ENDS

.SUBCKT XNOR2X4H9R Y VDD VSS A B
MI1_MXNA1 nb B VSS VSS nm1p2_svt_lp L=6e-08 W=4.4e-07
MI1_MXNA1_2 nb B VSS VSS nm1p2_svt_lp L=6e-08 W=4.4e-07
MI1_MXNA1_3 nb B VSS VSS nm1p2_svt_lp L=6e-08 W=4.4e-07
MI1_MXNA1_4 nb B VSS VSS nm1p2_svt_lp L=6e-08 W=4.4e-07
MI0_MXNA1 na A VSS VSS nm1p2_svt_lp L=6e-08 W=4.2e-07
MI0_MXNA1_2 na A VSS VSS nm1p2_svt_lp L=6e-08 W=4.2e-07
MI2_MXNOE Y na nb VSS nm1p2_svt_lp L=6e-08 W=4.4e-07
MI2_MXNOE_2 Y na nb VSS nm1p2_svt_lp L=6e-08 W=4.4e-07
MI2_MXNOE_3 Y na nb VSS nm1p2_svt_lp L=6e-08 W=4.4e-07
MI2_MXNOE_4 Y na nb VSS nm1p2_svt_lp L=6e-08 W=4.4e-07
MI4_MXNOE Y A bb VSS nm1p2_svt_lp L=6e-08 W=4.4e-07
MI4_MXNOE_2 Y A bb VSS nm1p2_svt_lp L=6e-08 W=4.4e-07
MI4_MXNOE_3 Y A bb VSS nm1p2_svt_lp L=6e-08 W=4.4e-07
MI4_MXNOE_4 Y A bb VSS nm1p2_svt_lp L=6e-08 W=4.4e-07
MI3_MXNA1 bb nb VSS VSS nm1p2_svt_lp L=6e-08 W=4.4e-07
MI3_MXNA1_2 bb nb VSS VSS nm1p2_svt_lp L=6e-08 W=4.4e-07
MI3_MXNA1_3 bb nb VSS VSS nm1p2_svt_lp L=6e-08 W=4.4e-07
MI3_MXNA1_4 bb nb VSS VSS nm1p2_svt_lp L=6e-08 W=4.4e-07
MI1_MXPA1 nb B VDD VDD pm1p2_svt_lp L=6e-08 W=5.85e-07
MI1_MXPA1_2 nb B VDD VDD pm1p2_svt_lp L=6e-08 W=5.85e-07
MI1_MXPA1_3 nb B VDD VDD pm1p2_svt_lp L=6e-08 W=5.85e-07
MI1_MXPA1_4 nb B VDD VDD pm1p2_svt_lp L=6e-08 W=5.85e-07
MI0_MXPA1 na A VDD VDD pm1p2_svt_lp L=6e-08 W=5.85e-07
MI0_MXPA1_2 na A VDD VDD pm1p2_svt_lp L=6e-08 W=5.85e-07
MI4_MXPOEN Y na bb VDD pm1p2_svt_lp L=6e-08 W=4.4e-07
MI4_MXPOEN_2 Y na bb VDD pm1p2_svt_lp L=6e-08 W=4.4e-07
MI4_MXPOEN_3 Y na bb VDD pm1p2_svt_lp L=6e-08 W=4.4e-07
MI4_MXPOEN_4 Y na bb VDD pm1p2_svt_lp L=6e-08 W=4.4e-07
MI2_MXPOEN Y A nb VDD pm1p2_svt_lp L=6e-08 W=4.4e-07
MI2_MXPOEN_2 Y A nb VDD pm1p2_svt_lp L=6e-08 W=4.4e-07
MI2_MXPOEN_3 Y A nb VDD pm1p2_svt_lp L=6e-08 W=4.4e-07
MI2_MXPOEN_4 Y A nb VDD pm1p2_svt_lp L=6e-08 W=4.4e-07
MI3_MXPA1 bb nb VDD VDD pm1p2_svt_lp L=6e-08 W=5.85e-07
MI3_MXPA1_2 bb nb VDD VDD pm1p2_svt_lp L=6e-08 W=5.85e-07
MI3_MXPA1_3 bb nb VDD VDD pm1p2_svt_lp L=6e-08 W=5.85e-07
MI3_MXPA1_4 bb nb VDD VDD pm1p2_svt_lp L=6e-08 W=5.85e-07
.ENDS

.SUBCKT XNOR3X0P5H9R Y VDD VSS A B C
MI1_MXNA1 nb B VSS VSS nm1p2_svt_lp L=6e-08 W=2.8e-07
MI2_MXNA1 nc C VSS VSS nm1p2_svt_lp L=6e-08 W=2.25e-07
MI3_MXNOE bnc B nc VSS nm1p2_svt_lp L=6e-08 W=2.25e-07
MI6_MXNOE bnc nb bc VSS nm1p2_svt_lp L=6e-08 W=2.25e-07
MI5_MXNA1 bc nc VSS VSS nm1p2_svt_lp L=6e-08 W=2.25e-07
MI7_MXNA1 nbnc bnc VSS VSS nm1p2_svt_lp L=6e-08 W=2.25e-07
MI8_MXNOE ny A nbnc VSS nm1p2_svt_lp L=6e-08 W=2.25e-07
MI4_MXNOE ny na bnc VSS nm1p2_svt_lp L=6e-08 W=2.25e-07
MI0_MXNA1 na A VSS VSS nm1p2_svt_lp L=6e-08 W=1.5e-07
MI9_MXNA1 Y ny VSS VSS nm1p2_svt_lp L=6e-08 W=2.1e-07
MI1_MXPA1 nb B VDD VDD pm1p2_svt_lp L=6e-08 W=3.9e-07
MI2_MXPA1 nc C VDD VDD pm1p2_svt_lp L=6e-08 W=3.15e-07
MI3_MXPOEN bnc nb nc VDD pm1p2_svt_lp L=6e-08 W=2.25e-07
MI6_MXPOEN bnc B bc VDD pm1p2_svt_lp L=6e-08 W=2.25e-07
MI5_MXPA1 bc nc VDD VDD pm1p2_svt_lp L=6e-08 W=3.15e-07
MI7_MXPA1 nbnc bnc VDD VDD pm1p2_svt_lp L=6e-08 W=3.1e-07
MI8_MXPOEN ny na nbnc VDD pm1p2_svt_lp L=6e-08 W=2.25e-07
MI4_MXPOEN ny A bnc VDD pm1p2_svt_lp L=6e-08 W=2.25e-07
MI0_MXPA1 na A VDD VDD pm1p2_svt_lp L=6e-08 W=2.1e-07
MI9_MXPA1 Y ny VDD VDD pm1p2_svt_lp L=6e-08 W=2.95e-07
.ENDS

.SUBCKT XNOR3X0P7H9R Y VDD VSS A B C
MI1_MXNA1 nb B VSS VSS nm1p2_svt_lp L=6e-08 W=3.4e-07
MI2_MXNA1 nc C VSS VSS nm1p2_svt_lp L=6e-08 W=3.15e-07
MI3_MXNOE bnc B nc VSS nm1p2_svt_lp L=6e-08 W=3.15e-07
MI6_MXNOE bnc nb bc VSS nm1p2_svt_lp L=6e-08 W=3.15e-07
MI5_MXNA1 bc nc VSS VSS nm1p2_svt_lp L=6e-08 W=3.15e-07
MI7_MXNA1 nbnc bnc VSS VSS nm1p2_svt_lp L=6e-08 W=2.6e-07
MI8_MXNOE ny A nbnc VSS nm1p2_svt_lp L=6e-08 W=2.6e-07
MI4_MXNOE ny na bnc VSS nm1p2_svt_lp L=6e-08 W=2.6e-07
MI0_MXNA1 na A VSS VSS nm1p2_svt_lp L=6e-08 W=2.4e-07
MI9_MXNA1 Y ny VSS VSS nm1p2_svt_lp L=6e-08 W=2.95e-07
MI1_MXPA1 nb B VDD VDD pm1p2_svt_lp L=6e-08 W=4.75e-07
MI2_MXPA1 nc C VDD VDD pm1p2_svt_lp L=6e-08 W=4.4e-07
MI3_MXPOEN bnc nb nc VDD pm1p2_svt_lp L=6e-08 W=3.15e-07
MI6_MXPOEN bnc B bc VDD pm1p2_svt_lp L=6e-08 W=3.15e-07
MI5_MXPA1 bc nc VDD VDD pm1p2_svt_lp L=6e-08 W=4.4e-07
MI7_MXPA1 nbnc bnc VDD VDD pm1p2_svt_lp L=6e-08 W=3.65e-07
MI8_MXPOEN ny na nbnc VDD pm1p2_svt_lp L=6e-08 W=2.6e-07
MI4_MXPOEN ny A bnc VDD pm1p2_svt_lp L=6e-08 W=2.6e-07
MI0_MXPA1 na A VDD VDD pm1p2_svt_lp L=6e-08 W=3.35e-07
MI9_MXPA1 Y ny VDD VDD pm1p2_svt_lp L=6e-08 W=4.15e-07
.ENDS

.SUBCKT XNOR3X1H9R Y VDD VSS A B C
MI1_MXNA1 nb B VSS VSS nm1p2_svt_lp L=6e-08 W=4.15e-07
MI2_MXNA1 nc C VSS VSS nm1p2_svt_lp L=6e-08 W=4.5e-07
MI3_MXNOE bnc B nc VSS nm1p2_svt_lp L=6e-08 W=4.5e-07
MI6_MXNOE bnc nb bc VSS nm1p2_svt_lp L=6e-08 W=4.5e-07
MI5_MXNA1 bc nc VSS VSS nm1p2_svt_lp L=6e-08 W=4.5e-07
MI7_MXNA1 nbnc bnc VSS VSS nm1p2_svt_lp L=6e-08 W=3.1e-07
MI8_MXNOE ny A nbnc VSS nm1p2_svt_lp L=6e-08 W=3.1e-07
MI4_MXNOE ny na bnc VSS nm1p2_svt_lp L=6e-08 W=3.1e-07
MI0_MXNA1 na A VSS VSS nm1p2_svt_lp L=6e-08 W=2.75e-07
MI9_MXNA1 Y ny VSS VSS nm1p2_svt_lp L=6e-08 W=4.2e-07
MI1_MXPA1 nb B VDD VDD pm1p2_svt_lp L=6e-08 W=5.85e-07
MI2_MXPA1 nc C VDD VDD pm1p2_svt_lp L=6e-08 W=5.85e-07
MI3_MXPOEN bnc nb nc VDD pm1p2_svt_lp L=6e-08 W=4.5e-07
MI6_MXPOEN bnc B bc VDD pm1p2_svt_lp L=6e-08 W=4.5e-07
MI5_MXPA1 bc nc VDD VDD pm1p2_svt_lp L=6e-08 W=5.85e-07
MI7_MXPA1 nbnc bnc VDD VDD pm1p2_svt_lp L=6e-08 W=4.4e-07
MI8_MXPOEN ny na nbnc VDD pm1p2_svt_lp L=6e-08 W=3.1e-07
MI4_MXPOEN ny A bnc VDD pm1p2_svt_lp L=6e-08 W=3.1e-07
MI0_MXPA1 na A VDD VDD pm1p2_svt_lp L=6e-08 W=3.85e-07
MI9_MXPA1 Y ny VDD VDD pm1p2_svt_lp L=6e-08 W=5.85e-07
.ENDS

.SUBCKT XNOR3X1P4H9R Y VDD VSS A B C
MI1_MXNA1 nb B VSS VSS nm1p2_svt_lp L=6e-08 W=2.7e-07
MI1_MXNA1_2 nb B VSS VSS nm1p2_svt_lp L=6e-08 W=2.7e-07
MI2_MXNA1 nc C VSS VSS nm1p2_svt_lp L=6e-08 W=3.15e-07
MI2_MXNA1_2 nc C VSS VSS nm1p2_svt_lp L=6e-08 W=3.15e-07
MI3_MXNOE bnc B nc VSS nm1p2_svt_lp L=6e-08 W=3.15e-07
MI3_MXNOE_2 bnc B nc VSS nm1p2_svt_lp L=6e-08 W=3.15e-07
MI6_MXNOE bnc nb bc VSS nm1p2_svt_lp L=6e-08 W=3.15e-07
MI6_MXNOE_2 bnc nb bc VSS nm1p2_svt_lp L=6e-08 W=3.15e-07
MI5_MXNA1 bc nc VSS VSS nm1p2_svt_lp L=6e-08 W=3.15e-07
MI5_MXNA1_2 bc nc VSS VSS nm1p2_svt_lp L=6e-08 W=3.15e-07
MI0_MXNA1 na A VSS VSS nm1p2_svt_lp L=6e-08 W=3.45e-07
MI4_MXNOE ny na bnc VSS nm1p2_svt_lp L=6e-08 W=4.1e-07
MI8_MXNOE ny A nbnc VSS nm1p2_svt_lp L=6e-08 W=4.1e-07
MI7_MXNA1 nbnc bnc VSS VSS nm1p2_svt_lp L=6e-08 W=4.1e-07
MI9_MXNA1 Y ny VSS VSS nm1p2_svt_lp L=6e-08 W=2.95e-07
MI9_MXNA1_2 Y ny VSS VSS nm1p2_svt_lp L=6e-08 W=2.95e-07
MI1_MXPA1 nb B VDD VDD pm1p2_svt_lp L=6e-08 W=3.75e-07
MI1_MXPA1_2 nb B VDD VDD pm1p2_svt_lp L=6e-08 W=3.75e-07
MI2_MXPA1 nc C VDD VDD pm1p2_svt_lp L=6e-08 W=4.4e-07
MI2_MXPA1_2 nc C VDD VDD pm1p2_svt_lp L=6e-08 W=4.4e-07
MI3_MXPOEN bnc nb nc VDD pm1p2_svt_lp L=6e-08 W=3.15e-07
MI3_MXPOEN_2 bnc nb nc VDD pm1p2_svt_lp L=6e-08 W=3.15e-07
MI6_MXPOEN bnc B bc VDD pm1p2_svt_lp L=6e-08 W=3.15e-07
MI6_MXPOEN_2 bnc B bc VDD pm1p2_svt_lp L=6e-08 W=3.15e-07
MI5_MXPA1 bc nc VDD VDD pm1p2_svt_lp L=6e-08 W=4.4e-07
MI5_MXPA1_2 bc nc VDD VDD pm1p2_svt_lp L=6e-08 W=4.4e-07
MI0_MXPA1 na A VDD VDD pm1p2_svt_lp L=6e-08 W=4.8e-07
MI4_MXPOEN ny A bnc VDD pm1p2_svt_lp L=6e-08 W=4.1e-07
MI8_MXPOEN ny na nbnc VDD pm1p2_svt_lp L=6e-08 W=4.1e-07
MI7_MXPA1 nbnc bnc VDD VDD pm1p2_svt_lp L=6e-08 W=5.7e-07
MI9_MXPA1 Y ny VDD VDD pm1p2_svt_lp L=6e-08 W=4.15e-07
MI9_MXPA1_2 Y ny VDD VDD pm1p2_svt_lp L=6e-08 W=4.15e-07
.ENDS

.SUBCKT XNOR3X2H9R Y VDD VSS A B C
MI1_MXNA1 nb B VSS VSS nm1p2_svt_lp L=6e-08 W=3.2e-07
MI1_MXNA1_2 nb B VSS VSS nm1p2_svt_lp L=6e-08 W=3.2e-07
MI2_MXNA1 nc C VSS VSS nm1p2_svt_lp L=6e-08 W=4.4e-07
MI2_MXNA1_2 nc C VSS VSS nm1p2_svt_lp L=6e-08 W=4.4e-07
MI3_MXNOE bnc B nc VSS nm1p2_svt_lp L=6e-08 W=4.4e-07
MI3_MXNOE_2 bnc B nc VSS nm1p2_svt_lp L=6e-08 W=4.4e-07
MI6_MXNOE bnc nb bc VSS nm1p2_svt_lp L=6e-08 W=4.4e-07
MI6_MXNOE_2 bnc nb bc VSS nm1p2_svt_lp L=6e-08 W=4.4e-07
MI5_MXNA1 bc nc VSS VSS nm1p2_svt_lp L=6e-08 W=4.4e-07
MI5_MXNA1_2 bc nc VSS VSS nm1p2_svt_lp L=6e-08 W=4.4e-07
MI0_MXNA1 na A VSS VSS nm1p2_svt_lp L=6e-08 W=4.1e-07
MI4_MXNOE ny na bnc VSS nm1p2_svt_lp L=6e-08 W=2.6e-07
MI4_MXNOE_2 ny na bnc VSS nm1p2_svt_lp L=6e-08 W=2.6e-07
MI8_MXNOE ny A nbnc VSS nm1p2_svt_lp L=6e-08 W=2.6e-07
MI8_MXNOE_2 ny A nbnc VSS nm1p2_svt_lp L=6e-08 W=2.6e-07
MI7_MXNA1 nbnc bnc VSS VSS nm1p2_svt_lp L=6e-08 W=2.6e-07
MI7_MXNA1_2 nbnc bnc VSS VSS nm1p2_svt_lp L=6e-08 W=2.6e-07
MI9_MXNA1 Y ny VSS VSS nm1p2_svt_lp L=6e-08 W=4.2e-07
MI9_MXNA1_2 Y ny VSS VSS nm1p2_svt_lp L=6e-08 W=4.2e-07
MI1_MXPA1 nb B VDD VDD pm1p2_svt_lp L=6e-08 W=4.45e-07
MI1_MXPA1_2 nb B VDD VDD pm1p2_svt_lp L=6e-08 W=4.45e-07
MI2_MXPA1 nc C VDD VDD pm1p2_svt_lp L=6e-08 W=5.85e-07
MI2_MXPA1_2 nc C VDD VDD pm1p2_svt_lp L=6e-08 W=5.85e-07
MI3_MXPOEN bnc nb nc VDD pm1p2_svt_lp L=6e-08 W=4.4e-07
MI3_MXPOEN_2 bnc nb nc VDD pm1p2_svt_lp L=6e-08 W=4.4e-07
MI6_MXPOEN bnc B bc VDD pm1p2_svt_lp L=6e-08 W=4.4e-07
MI6_MXPOEN_2 bnc B bc VDD pm1p2_svt_lp L=6e-08 W=4.4e-07
MI5_MXPA1 bc nc VDD VDD pm1p2_svt_lp L=6e-08 W=5.85e-07
MI5_MXPA1_2 bc nc VDD VDD pm1p2_svt_lp L=6e-08 W=5.85e-07
MI0_MXPA1 na A VDD VDD pm1p2_svt_lp L=6e-08 W=5.8e-07
MI4_MXPOEN ny A bnc VDD pm1p2_svt_lp L=6e-08 W=2.6e-07
MI4_MXPOEN_2 ny A bnc VDD pm1p2_svt_lp L=6e-08 W=2.6e-07
MI8_MXPOEN ny na nbnc VDD pm1p2_svt_lp L=6e-08 W=2.6e-07
MI8_MXPOEN_2 ny na nbnc VDD pm1p2_svt_lp L=6e-08 W=2.6e-07
MI7_MXPA1 nbnc bnc VDD VDD pm1p2_svt_lp L=6e-08 W=3.55e-07
MI7_MXPA1_2 nbnc bnc VDD VDD pm1p2_svt_lp L=6e-08 W=3.55e-07
MI9_MXPA1 Y ny VDD VDD pm1p2_svt_lp L=6e-08 W=5.85e-07
MI9_MXPA1_2 Y ny VDD VDD pm1p2_svt_lp L=6e-08 W=5.85e-07
.ENDS

.SUBCKT XNOR3X3H9R Y VDD VSS A B C
MI1_MXNA1 nb B VSS VSS nm1p2_svt_lp L=6e-08 W=4.15e-07
MI1_MXNA1_2 nb B VSS VSS nm1p2_svt_lp L=6e-08 W=4.15e-07
MI2_MXNA1 nc C VSS VSS nm1p2_svt_lp L=6e-08 W=4.4e-07
MI2_MXNA1_2 nc C VSS VSS nm1p2_svt_lp L=6e-08 W=4.4e-07
MI2_MXNA1_3 nc C VSS VSS nm1p2_svt_lp L=6e-08 W=4.4e-07
MI3_MXNOE bnc B nc VSS nm1p2_svt_lp L=6e-08 W=4.4e-07
MI3_MXNOE_2 bnc B nc VSS nm1p2_svt_lp L=6e-08 W=4.4e-07
MI3_MXNOE_3 bnc B nc VSS nm1p2_svt_lp L=6e-08 W=4.4e-07
MI6_MXNOE bnc nb bc VSS nm1p2_svt_lp L=6e-08 W=4.4e-07
MI6_MXNOE_2 bnc nb bc VSS nm1p2_svt_lp L=6e-08 W=4.4e-07
MI6_MXNOE_3 bnc nb bc VSS nm1p2_svt_lp L=6e-08 W=4.4e-07
MI5_MXNA1 bc nc VSS VSS nm1p2_svt_lp L=6e-08 W=4.4e-07
MI5_MXNA1_2 bc nc VSS VSS nm1p2_svt_lp L=6e-08 W=4.4e-07
MI5_MXNA1_3 bc nc VSS VSS nm1p2_svt_lp L=6e-08 W=4.4e-07
MI0_MXNA1 na A VSS VSS nm1p2_svt_lp L=6e-08 W=2.65e-07
MI0_MXNA1_2 na A VSS VSS nm1p2_svt_lp L=6e-08 W=2.65e-07
MI4_MXNOE ny na bnc VSS nm1p2_svt_lp L=6e-08 W=3.9e-07
MI4_MXNOE_2 ny na bnc VSS nm1p2_svt_lp L=6e-08 W=3.9e-07
MI8_MXNOE ny A nbnc VSS nm1p2_svt_lp L=6e-08 W=3.9e-07
MI8_MXNOE_2 ny A nbnc VSS nm1p2_svt_lp L=6e-08 W=3.9e-07
MI7_MXNA1 nbnc bnc VSS VSS nm1p2_svt_lp L=6e-08 W=3.9e-07
MI7_MXNA1_2 nbnc bnc VSS VSS nm1p2_svt_lp L=6e-08 W=3.9e-07
MI9_MXNA1 Y ny VSS VSS nm1p2_svt_lp L=6e-08 W=4.2e-07
MI9_MXNA1_2 Y ny VSS VSS nm1p2_svt_lp L=6e-08 W=4.2e-07
MI9_MXNA1_3 Y ny VSS VSS nm1p2_svt_lp L=6e-08 W=4.2e-07
MI1_MXPA1 nb B VDD VDD pm1p2_svt_lp L=6e-08 W=5.8e-07
MI1_MXPA1_2 nb B VDD VDD pm1p2_svt_lp L=6e-08 W=5.8e-07
MI2_MXPA1 nc C VDD VDD pm1p2_svt_lp L=6e-08 W=5.85e-07
MI2_MXPA1_2 nc C VDD VDD pm1p2_svt_lp L=6e-08 W=5.85e-07
MI2_MXPA1_3 nc C VDD VDD pm1p2_svt_lp L=6e-08 W=5.85e-07
MI3_MXPOEN bnc nb nc VDD pm1p2_svt_lp L=6e-08 W=4.4e-07
MI3_MXPOEN_2 bnc nb nc VDD pm1p2_svt_lp L=6e-08 W=4.4e-07
MI3_MXPOEN_3 bnc nb nc VDD pm1p2_svt_lp L=6e-08 W=4.4e-07
MI6_MXPOEN bnc B bc VDD pm1p2_svt_lp L=6e-08 W=4.4e-07
MI6_MXPOEN_2 bnc B bc VDD pm1p2_svt_lp L=6e-08 W=4.4e-07
MI6_MXPOEN_3 bnc B bc VDD pm1p2_svt_lp L=6e-08 W=4.4e-07
MI5_MXPA1 bc nc VDD VDD pm1p2_svt_lp L=6e-08 W=5.85e-07
MI5_MXPA1_2 bc nc VDD VDD pm1p2_svt_lp L=6e-08 W=5.85e-07
MI5_MXPA1_3 bc nc VDD VDD pm1p2_svt_lp L=6e-08 W=5.85e-07
MI0_MXPA1 na A VDD VDD pm1p2_svt_lp L=6e-08 W=3.7e-07
MI0_MXPA1_2 na A VDD VDD pm1p2_svt_lp L=6e-08 W=3.7e-07
MI4_MXPOEN ny A bnc VDD pm1p2_svt_lp L=6e-08 W=3.9e-07
MI4_MXPOEN_2 ny A bnc VDD pm1p2_svt_lp L=6e-08 W=3.9e-07
MI8_MXPOEN ny na nbnc VDD pm1p2_svt_lp L=6e-08 W=3.9e-07
MI8_MXPOEN_2 ny na nbnc VDD pm1p2_svt_lp L=6e-08 W=3.9e-07
MI7_MXPA1 nbnc bnc VDD VDD pm1p2_svt_lp L=6e-08 W=5.45e-07
MI7_MXPA1_2 nbnc bnc VDD VDD pm1p2_svt_lp L=6e-08 W=5.45e-07
MI9_MXPA1 Y ny VDD VDD pm1p2_svt_lp L=6e-08 W=5.85e-07
MI9_MXPA1_2 Y ny VDD VDD pm1p2_svt_lp L=6e-08 W=5.85e-07
MI9_MXPA1_3 Y ny VDD VDD pm1p2_svt_lp L=6e-08 W=5.85e-07
.ENDS

.SUBCKT XNOR3X4H9R Y VDD VSS A B C
MI1_MXNA1 nb B VSS VSS nm1p2_svt_lp L=6e-08 W=4.2e-07
MI1_MXNA1_2 nb B VSS VSS nm1p2_svt_lp L=6e-08 W=4.2e-07
MI2_MXNA1 nc C VSS VSS nm1p2_svt_lp L=6e-08 W=4.4e-07
MI2_MXNA1_2 nc C VSS VSS nm1p2_svt_lp L=6e-08 W=4.4e-07
MI2_MXNA1_3 nc C VSS VSS nm1p2_svt_lp L=6e-08 W=4.4e-07
MI2_MXNA1_4 nc C VSS VSS nm1p2_svt_lp L=6e-08 W=4.4e-07
MI3_MXNOE bnc B nc VSS nm1p2_svt_lp L=6e-08 W=4.4e-07
MI3_MXNOE_2 bnc B nc VSS nm1p2_svt_lp L=6e-08 W=4.4e-07
MI3_MXNOE_3 bnc B nc VSS nm1p2_svt_lp L=6e-08 W=4.4e-07
MI3_MXNOE_4 bnc B nc VSS nm1p2_svt_lp L=6e-08 W=4.4e-07
MI6_MXNOE bnc nb bc VSS nm1p2_svt_lp L=6e-08 W=4.4e-07
MI6_MXNOE_2 bnc nb bc VSS nm1p2_svt_lp L=6e-08 W=4.4e-07
MI6_MXNOE_3 bnc nb bc VSS nm1p2_svt_lp L=6e-08 W=4.4e-07
MI6_MXNOE_4 bnc nb bc VSS nm1p2_svt_lp L=6e-08 W=4.4e-07
MI5_MXNA1 bc nc VSS VSS nm1p2_svt_lp L=6e-08 W=4.4e-07
MI5_MXNA1_2 bc nc VSS VSS nm1p2_svt_lp L=6e-08 W=4.4e-07
MI5_MXNA1_3 bc nc VSS VSS nm1p2_svt_lp L=6e-08 W=4.4e-07
MI5_MXNA1_4 bc nc VSS VSS nm1p2_svt_lp L=6e-08 W=4.4e-07
MI0_MXNA1 na A VSS VSS nm1p2_svt_lp L=6e-08 W=3.7e-07
MI0_MXNA1_2 na A VSS VSS nm1p2_svt_lp L=6e-08 W=3.7e-07
MI4_MXNOE ny na bnc VSS nm1p2_svt_lp L=6e-08 W=4.15e-07
MI4_MXNOE_2 ny na bnc VSS nm1p2_svt_lp L=6e-08 W=4.15e-07
MI4_MXNOE_3 ny na bnc VSS nm1p2_svt_lp L=6e-08 W=4.15e-07
MI8_MXNOE ny A nbnc VSS nm1p2_svt_lp L=6e-08 W=4.15e-07
MI8_MXNOE_2 ny A nbnc VSS nm1p2_svt_lp L=6e-08 W=4.15e-07
MI8_MXNOE_3 ny A nbnc VSS nm1p2_svt_lp L=6e-08 W=4.15e-07
MI7_MXNA1 nbnc bnc VSS VSS nm1p2_svt_lp L=6e-08 W=4.15e-07
MI7_MXNA1_2 nbnc bnc VSS VSS nm1p2_svt_lp L=6e-08 W=4.15e-07
MI7_MXNA1_3 nbnc bnc VSS VSS nm1p2_svt_lp L=6e-08 W=4.15e-07
MI9_MXNA1 Y ny VSS VSS nm1p2_svt_lp L=6e-08 W=4.2e-07
MI9_MXNA1_2 Y ny VSS VSS nm1p2_svt_lp L=6e-08 W=4.2e-07
MI9_MXNA1_3 Y ny VSS VSS nm1p2_svt_lp L=6e-08 W=4.2e-07
MI9_MXNA1_4 Y ny VSS VSS nm1p2_svt_lp L=6e-08 W=4.2e-07
MI1_MXPA1 nb B VDD VDD pm1p2_svt_lp L=6e-08 W=5.85e-07
MI1_MXPA1_2 nb B VDD VDD pm1p2_svt_lp L=6e-08 W=5.85e-07
MI2_MXPA1 nc C VDD VDD pm1p2_svt_lp L=6e-08 W=5.85e-07
MI2_MXPA1_2 nc C VDD VDD pm1p2_svt_lp L=6e-08 W=5.85e-07
MI2_MXPA1_3 nc C VDD VDD pm1p2_svt_lp L=6e-08 W=5.85e-07
MI2_MXPA1_4 nc C VDD VDD pm1p2_svt_lp L=6e-08 W=5.85e-07
MI3_MXPOEN bnc nb nc VDD pm1p2_svt_lp L=6e-08 W=4.4e-07
MI3_MXPOEN_2 bnc nb nc VDD pm1p2_svt_lp L=6e-08 W=4.4e-07
MI3_MXPOEN_3 bnc nb nc VDD pm1p2_svt_lp L=6e-08 W=4.4e-07
MI3_MXPOEN_4 bnc nb nc VDD pm1p2_svt_lp L=6e-08 W=4.4e-07
MI6_MXPOEN bnc B bc VDD pm1p2_svt_lp L=6e-08 W=4.4e-07
MI6_MXPOEN_2 bnc B bc VDD pm1p2_svt_lp L=6e-08 W=4.4e-07
MI6_MXPOEN_3 bnc B bc VDD pm1p2_svt_lp L=6e-08 W=4.4e-07
MI6_MXPOEN_4 bnc B bc VDD pm1p2_svt_lp L=6e-08 W=4.4e-07
MI5_MXPA1 bc nc VDD VDD pm1p2_svt_lp L=6e-08 W=5.85e-07
MI5_MXPA1_2 bc nc VDD VDD pm1p2_svt_lp L=6e-08 W=5.85e-07
MI5_MXPA1_3 bc nc VDD VDD pm1p2_svt_lp L=6e-08 W=5.85e-07
MI5_MXPA1_4 bc nc VDD VDD pm1p2_svt_lp L=6e-08 W=5.85e-07
MI0_MXPA1 na A VDD VDD pm1p2_svt_lp L=6e-08 W=5.2e-07
MI0_MXPA1_2 na A VDD VDD pm1p2_svt_lp L=6e-08 W=5.2e-07
MI4_MXPOEN ny A bnc VDD pm1p2_svt_lp L=6e-08 W=4.15e-07
MI4_MXPOEN_2 ny A bnc VDD pm1p2_svt_lp L=6e-08 W=4.15e-07
MI4_MXPOEN_3 ny A bnc VDD pm1p2_svt_lp L=6e-08 W=4.15e-07
MI8_MXPOEN ny na nbnc VDD pm1p2_svt_lp L=6e-08 W=4.15e-07
MI8_MXPOEN_2 ny na nbnc VDD pm1p2_svt_lp L=6e-08 W=4.15e-07
MI8_MXPOEN_3 ny na nbnc VDD pm1p2_svt_lp L=6e-08 W=4.15e-07
MI7_MXPA1 nbnc bnc VDD VDD pm1p2_svt_lp L=6e-08 W=5.85e-07
MI7_MXPA1_2 nbnc bnc VDD VDD pm1p2_svt_lp L=6e-08 W=5.85e-07
MI7_MXPA1_3 nbnc bnc VDD VDD pm1p2_svt_lp L=6e-08 W=5.85e-07
MI9_MXPA1 Y ny VDD VDD pm1p2_svt_lp L=6e-08 W=5.85e-07
MI9_MXPA1_2 Y ny VDD VDD pm1p2_svt_lp L=6e-08 W=5.85e-07
MI9_MXPA1_3 Y ny VDD VDD pm1p2_svt_lp L=6e-08 W=5.85e-07
MI9_MXPA1_4 Y ny VDD VDD pm1p2_svt_lp L=6e-08 W=5.85e-07
.ENDS

.SUBCKT XOR2X0P5H9R Y VDD VSS A B
MI0_MXNA1 na A VSS VSS nm1p2_svt_lp L=6e-08 W=2.8e-07
MI1_MXNA1 nb B VSS VSS nm1p2_svt_lp L=6e-08 W=2.25e-07
MI2_MXNOE Y A nb VSS nm1p2_svt_lp L=6e-08 W=2.25e-07
MI4_MXNOE Y na bb VSS nm1p2_svt_lp L=6e-08 W=2.25e-07
MI3_MXNA1 bb nb VSS VSS nm1p2_svt_lp L=6e-08 W=2.25e-07
MI0_MXPA1 na A VDD VDD pm1p2_svt_lp L=6e-08 W=3.9e-07
MI1_MXPA1 nb B VDD VDD pm1p2_svt_lp L=6e-08 W=3.15e-07
MI2_MXPOEN Y na nb VDD pm1p2_svt_lp L=6e-08 W=2.25e-07
MI4_MXPOEN Y A bb VDD pm1p2_svt_lp L=6e-08 W=2.25e-07
MI3_MXPA1 bb nb VDD VDD pm1p2_svt_lp L=6e-08 W=3.15e-07
.ENDS

.SUBCKT XOR2X0P7H9R Y VDD VSS A B
MI0_MXNA1 na A VSS VSS nm1p2_svt_lp L=6e-08 W=3.4e-07
MI1_MXNA1 nb B VSS VSS nm1p2_svt_lp L=6e-08 W=3.15e-07
MI2_MXNOE Y A nb VSS nm1p2_svt_lp L=6e-08 W=3.15e-07
MI4_MXNOE Y na bb VSS nm1p2_svt_lp L=6e-08 W=3.15e-07
MI3_MXNA1 bb nb VSS VSS nm1p2_svt_lp L=6e-08 W=3.15e-07
MI0_MXPA1 na A VDD VDD pm1p2_svt_lp L=6e-08 W=4.75e-07
MI1_MXPA1 nb B VDD VDD pm1p2_svt_lp L=6e-08 W=4.4e-07
MI2_MXPOEN Y na nb VDD pm1p2_svt_lp L=6e-08 W=3.15e-07
MI4_MXPOEN Y A bb VDD pm1p2_svt_lp L=6e-08 W=3.15e-07
MI3_MXPA1 bb nb VDD VDD pm1p2_svt_lp L=6e-08 W=4.4e-07
.ENDS

.SUBCKT XOR2X1H9R Y VDD VSS A B
MI0_MXNA1 na A VSS VSS nm1p2_svt_lp L=6e-08 W=4.15e-07
MI1_MXNA1 nb B VSS VSS nm1p2_svt_lp L=6e-08 W=4.5e-07
MI2_MXNOE Y A nb VSS nm1p2_svt_lp L=6e-08 W=4.5e-07
MI4_MXNOE Y na bb VSS nm1p2_svt_lp L=6e-08 W=4.5e-07
MI3_MXNA1 bb nb VSS VSS nm1p2_svt_lp L=6e-08 W=4.5e-07
MI0_MXPA1 na A VDD VDD pm1p2_svt_lp L=6e-08 W=5.85e-07
MI1_MXPA1 nb B VDD VDD pm1p2_svt_lp L=6e-08 W=5.85e-07
MI2_MXPOEN Y na nb VDD pm1p2_svt_lp L=6e-08 W=4.5e-07
MI4_MXPOEN Y A bb VDD pm1p2_svt_lp L=6e-08 W=4.5e-07
MI3_MXPA1 bb nb VDD VDD pm1p2_svt_lp L=6e-08 W=5.85e-07
.ENDS

.SUBCKT XOR2X1P4H9R Y VDD VSS A B
MI1_MXNA1 nb B VSS VSS nm1p2_svt_lp L=6e-08 W=3.15e-07
MI1_MXNA1_2 nb B VSS VSS nm1p2_svt_lp L=6e-08 W=3.15e-07
MI0_MXNA1 na A VSS VSS nm1p2_svt_lp L=6e-08 W=2.7e-07
MI0_MXNA1_2 na A VSS VSS nm1p2_svt_lp L=6e-08 W=2.7e-07
MI2_MXNOE Y A nb VSS nm1p2_svt_lp L=6e-08 W=3.15e-07
MI2_MXNOE_2 Y A nb VSS nm1p2_svt_lp L=6e-08 W=3.15e-07
MI4_MXNOE Y na bb VSS nm1p2_svt_lp L=6e-08 W=3.15e-07
MI4_MXNOE_2 Y na bb VSS nm1p2_svt_lp L=6e-08 W=3.15e-07
MI3_MXNA1 bb nb VSS VSS nm1p2_svt_lp L=6e-08 W=3.15e-07
MI3_MXNA1_2 bb nb VSS VSS nm1p2_svt_lp L=6e-08 W=3.15e-07
MI1_MXPA1 nb B VDD VDD pm1p2_svt_lp L=6e-08 W=4.4e-07
MI1_MXPA1_2 nb B VDD VDD pm1p2_svt_lp L=6e-08 W=4.4e-07
MI0_MXPA1 na A VDD VDD pm1p2_svt_lp L=6e-08 W=3.75e-07
MI0_MXPA1_2 na A VDD VDD pm1p2_svt_lp L=6e-08 W=3.75e-07
MI4_MXPOEN Y A bb VDD pm1p2_svt_lp L=6e-08 W=3.15e-07
MI4_MXPOEN_2 Y A bb VDD pm1p2_svt_lp L=6e-08 W=3.15e-07
MI2_MXPOEN Y na nb VDD pm1p2_svt_lp L=6e-08 W=3.15e-07
MI2_MXPOEN_2 Y na nb VDD pm1p2_svt_lp L=6e-08 W=3.15e-07
MI3_MXPA1 bb nb VDD VDD pm1p2_svt_lp L=6e-08 W=4.4e-07
MI3_MXPA1_2 bb nb VDD VDD pm1p2_svt_lp L=6e-08 W=4.4e-07
.ENDS

.SUBCKT XOR2X2H9R Y VDD VSS A B
MI1_MXNA1 nb B VSS VSS nm1p2_svt_lp L=6e-08 W=4.4e-07
MI1_MXNA1_2 nb B VSS VSS nm1p2_svt_lp L=6e-08 W=4.4e-07
MI0_MXNA1 na A VSS VSS nm1p2_svt_lp L=6e-08 W=3.2e-07
MI0_MXNA1_2 na A VSS VSS nm1p2_svt_lp L=6e-08 W=3.2e-07
MI2_MXNOE Y A nb VSS nm1p2_svt_lp L=6e-08 W=4.4e-07
MI2_MXNOE_2 Y A nb VSS nm1p2_svt_lp L=6e-08 W=4.4e-07
MI4_MXNOE Y na bb VSS nm1p2_svt_lp L=6e-08 W=4.4e-07
MI4_MXNOE_2 Y na bb VSS nm1p2_svt_lp L=6e-08 W=4.4e-07
MI3_MXNA1 bb nb VSS VSS nm1p2_svt_lp L=6e-08 W=4.4e-07
MI3_MXNA1_2 bb nb VSS VSS nm1p2_svt_lp L=6e-08 W=4.4e-07
MI1_MXPA1 nb B VDD VDD pm1p2_svt_lp L=6e-08 W=5.85e-07
MI1_MXPA1_2 nb B VDD VDD pm1p2_svt_lp L=6e-08 W=5.85e-07
MI0_MXPA1 na A VDD VDD pm1p2_svt_lp L=6e-08 W=4.45e-07
MI0_MXPA1_2 na A VDD VDD pm1p2_svt_lp L=6e-08 W=4.45e-07
MI4_MXPOEN Y A bb VDD pm1p2_svt_lp L=6e-08 W=4.4e-07
MI4_MXPOEN_2 Y A bb VDD pm1p2_svt_lp L=6e-08 W=4.4e-07
MI2_MXPOEN Y na nb VDD pm1p2_svt_lp L=6e-08 W=4.4e-07
MI2_MXPOEN_2 Y na nb VDD pm1p2_svt_lp L=6e-08 W=4.4e-07
MI3_MXPA1 bb nb VDD VDD pm1p2_svt_lp L=6e-08 W=5.85e-07
MI3_MXPA1_2 bb nb VDD VDD pm1p2_svt_lp L=6e-08 W=5.85e-07
.ENDS

.SUBCKT XOR2X3H9R Y VDD VSS A B
MI1_MXNA1 nb B VSS VSS nm1p2_svt_lp L=6e-08 W=4.4e-07
MI1_MXNA1_2 nb B VSS VSS nm1p2_svt_lp L=6e-08 W=4.4e-07
MI1_MXNA1_3 nb B VSS VSS nm1p2_svt_lp L=6e-08 W=4.4e-07
MI0_MXNA1 na A VSS VSS nm1p2_svt_lp L=6e-08 W=4.15e-07
MI0_MXNA1_2 na A VSS VSS nm1p2_svt_lp L=6e-08 W=4.15e-07
MI2_MXNOE Y A nb VSS nm1p2_svt_lp L=6e-08 W=4.4e-07
MI2_MXNOE_2 Y A nb VSS nm1p2_svt_lp L=6e-08 W=4.4e-07
MI2_MXNOE_3 Y A nb VSS nm1p2_svt_lp L=6e-08 W=4.4e-07
MI4_MXNOE Y na bb VSS nm1p2_svt_lp L=6e-08 W=4.4e-07
MI4_MXNOE_2 Y na bb VSS nm1p2_svt_lp L=6e-08 W=4.4e-07
MI4_MXNOE_3 Y na bb VSS nm1p2_svt_lp L=6e-08 W=4.4e-07
MI3_MXNA1 bb nb VSS VSS nm1p2_svt_lp L=6e-08 W=4.4e-07
MI3_MXNA1_2 bb nb VSS VSS nm1p2_svt_lp L=6e-08 W=4.4e-07
MI3_MXNA1_3 bb nb VSS VSS nm1p2_svt_lp L=6e-08 W=4.4e-07
MI1_MXPA1 nb B VDD VDD pm1p2_svt_lp L=6e-08 W=5.85e-07
MI1_MXPA1_2 nb B VDD VDD pm1p2_svt_lp L=6e-08 W=5.85e-07
MI1_MXPA1_3 nb B VDD VDD pm1p2_svt_lp L=6e-08 W=5.85e-07
MI0_MXPA1 na A VDD VDD pm1p2_svt_lp L=6e-08 W=5.8e-07
MI0_MXPA1_2 na A VDD VDD pm1p2_svt_lp L=6e-08 W=5.8e-07
MI4_MXPOEN Y A bb VDD pm1p2_svt_lp L=6e-08 W=4.4e-07
MI4_MXPOEN_2 Y A bb VDD pm1p2_svt_lp L=6e-08 W=4.4e-07
MI4_MXPOEN_3 Y A bb VDD pm1p2_svt_lp L=6e-08 W=4.4e-07
MI2_MXPOEN Y na nb VDD pm1p2_svt_lp L=6e-08 W=4.4e-07
MI2_MXPOEN_2 Y na nb VDD pm1p2_svt_lp L=6e-08 W=4.4e-07
MI2_MXPOEN_3 Y na nb VDD pm1p2_svt_lp L=6e-08 W=4.4e-07
MI3_MXPA1 bb nb VDD VDD pm1p2_svt_lp L=6e-08 W=5.85e-07
MI3_MXPA1_2 bb nb VDD VDD pm1p2_svt_lp L=6e-08 W=5.85e-07
MI3_MXPA1_3 bb nb VDD VDD pm1p2_svt_lp L=6e-08 W=5.85e-07
.ENDS

.SUBCKT XOR2X4H9R Y VDD VSS A B
MI1_MXNA1 nb B VSS VSS nm1p2_svt_lp L=6e-08 W=4.4e-07
MI1_MXNA1_2 nb B VSS VSS nm1p2_svt_lp L=6e-08 W=4.4e-07
MI1_MXNA1_3 nb B VSS VSS nm1p2_svt_lp L=6e-08 W=4.4e-07
MI1_MXNA1_4 nb B VSS VSS nm1p2_svt_lp L=6e-08 W=4.4e-07
MI0_MXNA1 na A VSS VSS nm1p2_svt_lp L=6e-08 W=4.2e-07
MI0_MXNA1_2 na A VSS VSS nm1p2_svt_lp L=6e-08 W=4.2e-07
MI2_MXNOE Y A nb VSS nm1p2_svt_lp L=6e-08 W=4.4e-07
MI2_MXNOE_2 Y A nb VSS nm1p2_svt_lp L=6e-08 W=4.4e-07
MI2_MXNOE_3 Y A nb VSS nm1p2_svt_lp L=6e-08 W=4.4e-07
MI2_MXNOE_4 Y A nb VSS nm1p2_svt_lp L=6e-08 W=4.4e-07
MI4_MXNOE Y na bb VSS nm1p2_svt_lp L=6e-08 W=4.4e-07
MI4_MXNOE_2 Y na bb VSS nm1p2_svt_lp L=6e-08 W=4.4e-07
MI4_MXNOE_3 Y na bb VSS nm1p2_svt_lp L=6e-08 W=4.4e-07
MI4_MXNOE_4 Y na bb VSS nm1p2_svt_lp L=6e-08 W=4.4e-07
MI3_MXNA1 bb nb VSS VSS nm1p2_svt_lp L=6e-08 W=4.4e-07
MI3_MXNA1_2 bb nb VSS VSS nm1p2_svt_lp L=6e-08 W=4.4e-07
MI3_MXNA1_3 bb nb VSS VSS nm1p2_svt_lp L=6e-08 W=4.4e-07
MI3_MXNA1_4 bb nb VSS VSS nm1p2_svt_lp L=6e-08 W=4.4e-07
MI1_MXPA1 nb B VDD VDD pm1p2_svt_lp L=6e-08 W=5.85e-07
MI1_MXPA1_2 nb B VDD VDD pm1p2_svt_lp L=6e-08 W=5.85e-07
MI1_MXPA1_3 nb B VDD VDD pm1p2_svt_lp L=6e-08 W=5.85e-07
MI1_MXPA1_4 nb B VDD VDD pm1p2_svt_lp L=6e-08 W=5.85e-07
MI0_MXPA1 na A VDD VDD pm1p2_svt_lp L=6e-08 W=5.85e-07
MI0_MXPA1_2 na A VDD VDD pm1p2_svt_lp L=6e-08 W=5.85e-07
MI4_MXPOEN Y A bb VDD pm1p2_svt_lp L=6e-08 W=4.4e-07
MI4_MXPOEN_2 Y A bb VDD pm1p2_svt_lp L=6e-08 W=4.4e-07
MI4_MXPOEN_3 Y A bb VDD pm1p2_svt_lp L=6e-08 W=4.4e-07
MI4_MXPOEN_4 Y A bb VDD pm1p2_svt_lp L=6e-08 W=4.4e-07
MI2_MXPOEN Y na nb VDD pm1p2_svt_lp L=6e-08 W=4.4e-07
MI2_MXPOEN_2 Y na nb VDD pm1p2_svt_lp L=6e-08 W=4.4e-07
MI2_MXPOEN_3 Y na nb VDD pm1p2_svt_lp L=6e-08 W=4.4e-07
MI2_MXPOEN_4 Y na nb VDD pm1p2_svt_lp L=6e-08 W=4.4e-07
MI3_MXPA1 bb nb VDD VDD pm1p2_svt_lp L=6e-08 W=5.85e-07
MI3_MXPA1_2 bb nb VDD VDD pm1p2_svt_lp L=6e-08 W=5.85e-07
MI3_MXPA1_3 bb nb VDD VDD pm1p2_svt_lp L=6e-08 W=5.85e-07
MI3_MXPA1_4 bb nb VDD VDD pm1p2_svt_lp L=6e-08 W=5.85e-07
.ENDS

.SUBCKT XOR3X0P5H9R Y VDD VSS A B C
MI1_MXNA1 nb B VSS VSS nm1p2_svt_lp L=6e-08 W=2.8e-07
MI2_MXNA1 nc C VSS VSS nm1p2_svt_lp L=6e-08 W=2.25e-07
MI3_MXNOE bnc B nc VSS nm1p2_svt_lp L=6e-08 W=2.25e-07
MI6_MXNOE bnc nb bc VSS nm1p2_svt_lp L=6e-08 W=2.25e-07
MI5_MXNA1 bc nc VSS VSS nm1p2_svt_lp L=6e-08 W=2.25e-07
MI7_MXNA1 nbnc bnc VSS VSS nm1p2_svt_lp L=6e-08 W=2.2e-07
MI8_MXNOE ny na nbnc VSS nm1p2_svt_lp L=6e-08 W=2.25e-07
MI4_MXNOE ny A bnc VSS nm1p2_svt_lp L=6e-08 W=2.25e-07
MI0_MXNA1 na A VSS VSS nm1p2_svt_lp L=6e-08 W=1.5e-07
MI9_MXNA1 Y ny VSS VSS nm1p2_svt_lp L=6e-08 W=2.1e-07
MI1_MXPA1 nb B VDD VDD pm1p2_svt_lp L=6e-08 W=3.9e-07
MI2_MXPA1 nc C VDD VDD pm1p2_svt_lp L=6e-08 W=3.15e-07
MI3_MXPOEN bnc nb nc VDD pm1p2_svt_lp L=6e-08 W=2.25e-07
MI6_MXPOEN bnc B bc VDD pm1p2_svt_lp L=6e-08 W=2.25e-07
MI5_MXPA1 bc nc VDD VDD pm1p2_svt_lp L=6e-08 W=3.15e-07
MI7_MXPA1 nbnc bnc VDD VDD pm1p2_svt_lp L=6e-08 W=3.1e-07
MI8_MXPOEN ny A nbnc VDD pm1p2_svt_lp L=6e-08 W=2.25e-07
MI4_MXPOEN ny na bnc VDD pm1p2_svt_lp L=6e-08 W=2.25e-07
MI0_MXPA1 na A VDD VDD pm1p2_svt_lp L=6e-08 W=2.1e-07
MI9_MXPA1 Y ny VDD VDD pm1p2_svt_lp L=6e-08 W=2.95e-07
.ENDS

.SUBCKT XOR3X0P7H9R Y VDD VSS A B C
MI1_MXNA1 nb B VSS VSS nm1p2_svt_lp L=6e-08 W=3.4e-07
MI2_MXNA1 nc C VSS VSS nm1p2_svt_lp L=6e-08 W=3.15e-07
MI3_MXNOE bnc B nc VSS nm1p2_svt_lp L=6e-08 W=3.15e-07
MI6_MXNOE bnc nb bc VSS nm1p2_svt_lp L=6e-08 W=3.15e-07
MI5_MXNA1 bc nc VSS VSS nm1p2_svt_lp L=6e-08 W=3.15e-07
MI7_MXNA1 nbnc bnc VSS VSS nm1p2_svt_lp L=6e-08 W=2.6e-07
MI8_MXNOE ny na nbnc VSS nm1p2_svt_lp L=6e-08 W=2.6e-07
MI4_MXNOE ny A bnc VSS nm1p2_svt_lp L=6e-08 W=2.6e-07
MI0_MXNA1 na A VSS VSS nm1p2_svt_lp L=6e-08 W=2.4e-07
MI9_MXNA1 Y ny VSS VSS nm1p2_svt_lp L=6e-08 W=2.95e-07
MI1_MXPA1 nb B VDD VDD pm1p2_svt_lp L=6e-08 W=4.75e-07
MI2_MXPA1 nc C VDD VDD pm1p2_svt_lp L=6e-08 W=4.4e-07
MI3_MXPOEN bnc nb nc VDD pm1p2_svt_lp L=6e-08 W=3.15e-07
MI6_MXPOEN bnc B bc VDD pm1p2_svt_lp L=6e-08 W=3.15e-07
MI5_MXPA1 bc nc VDD VDD pm1p2_svt_lp L=6e-08 W=4.4e-07
MI7_MXPA1 nbnc bnc VDD VDD pm1p2_svt_lp L=6e-08 W=3.65e-07
MI8_MXPOEN ny A nbnc VDD pm1p2_svt_lp L=6e-08 W=2.6e-07
MI4_MXPOEN ny na bnc VDD pm1p2_svt_lp L=6e-08 W=2.6e-07
MI0_MXPA1 na A VDD VDD pm1p2_svt_lp L=6e-08 W=3.35e-07
MI9_MXPA1 Y ny VDD VDD pm1p2_svt_lp L=6e-08 W=4.15e-07
.ENDS

.SUBCKT XOR3X1H9R Y VDD VSS A B C
MI1_MXNA1 nb B VSS VSS nm1p2_svt_lp L=6e-08 W=4.15e-07
MI2_MXNA1 nc C VSS VSS nm1p2_svt_lp L=6e-08 W=4.5e-07
MI3_MXNOE bnc B nc VSS nm1p2_svt_lp L=6e-08 W=4.5e-07
MI6_MXNOE bnc nb bc VSS nm1p2_svt_lp L=6e-08 W=4.5e-07
MI5_MXNA1 bc nc VSS VSS nm1p2_svt_lp L=6e-08 W=4.5e-07
MI7_MXNA1 nbnc bnc VSS VSS nm1p2_svt_lp L=6e-08 W=3.1e-07
MI8_MXNOE ny na nbnc VSS nm1p2_svt_lp L=6e-08 W=3.1e-07
MI4_MXNOE ny A bnc VSS nm1p2_svt_lp L=6e-08 W=3.1e-07
MI0_MXNA1 na A VSS VSS nm1p2_svt_lp L=6e-08 W=2.75e-07
MI9_MXNA1 Y ny VSS VSS nm1p2_svt_lp L=6e-08 W=4.2e-07
MI1_MXPA1 nb B VDD VDD pm1p2_svt_lp L=6e-08 W=5.85e-07
MI2_MXPA1 nc C VDD VDD pm1p2_svt_lp L=6e-08 W=5.85e-07
MI3_MXPOEN bnc nb nc VDD pm1p2_svt_lp L=6e-08 W=4.5e-07
MI6_MXPOEN bnc B bc VDD pm1p2_svt_lp L=6e-08 W=4.5e-07
MI5_MXPA1 bc nc VDD VDD pm1p2_svt_lp L=6e-08 W=5.85e-07
MI7_MXPA1 nbnc bnc VDD VDD pm1p2_svt_lp L=6e-08 W=4.4e-07
MI8_MXPOEN ny A nbnc VDD pm1p2_svt_lp L=6e-08 W=3.1e-07
MI4_MXPOEN ny na bnc VDD pm1p2_svt_lp L=6e-08 W=3.1e-07
MI0_MXPA1 na A VDD VDD pm1p2_svt_lp L=6e-08 W=3.85e-07
MI9_MXPA1 Y ny VDD VDD pm1p2_svt_lp L=6e-08 W=5.85e-07
.ENDS

.SUBCKT XOR3X1P4H9R Y VDD VSS A B C
MI1_MXNA1 nb B VSS VSS nm1p2_svt_lp L=6e-08 W=2.7e-07
MI1_MXNA1_2 nb B VSS VSS nm1p2_svt_lp L=6e-08 W=2.7e-07
MI2_MXNA1 nc C VSS VSS nm1p2_svt_lp L=6e-08 W=3.15e-07
MI2_MXNA1_2 nc C VSS VSS nm1p2_svt_lp L=6e-08 W=3.15e-07
MI3_MXNOE bnc B nc VSS nm1p2_svt_lp L=6e-08 W=3.15e-07
MI3_MXNOE_2 bnc B nc VSS nm1p2_svt_lp L=6e-08 W=3.15e-07
MI6_MXNOE bnc nb bc VSS nm1p2_svt_lp L=6e-08 W=3.15e-07
MI6_MXNOE_2 bnc nb bc VSS nm1p2_svt_lp L=6e-08 W=3.15e-07
MI5_MXNA1 bc nc VSS VSS nm1p2_svt_lp L=6e-08 W=3.15e-07
MI5_MXNA1_2 bc nc VSS VSS nm1p2_svt_lp L=6e-08 W=3.15e-07
MI0_MXNA1 na A VSS VSS nm1p2_svt_lp L=6e-08 W=3.45e-07
MI4_MXNOE ny A bnc VSS nm1p2_svt_lp L=6e-08 W=4.1e-07
MI8_MXNOE ny na nbnc VSS nm1p2_svt_lp L=6e-08 W=4.1e-07
MI7_MXNA1 nbnc bnc VSS VSS nm1p2_svt_lp L=6e-08 W=4.1e-07
MI9_MXNA1 Y ny VSS VSS nm1p2_svt_lp L=6e-08 W=2.95e-07
MI9_MXNA1_2 Y ny VSS VSS nm1p2_svt_lp L=6e-08 W=2.95e-07
MI1_MXPA1 nb B VDD VDD pm1p2_svt_lp L=6e-08 W=3.75e-07
MI1_MXPA1_2 nb B VDD VDD pm1p2_svt_lp L=6e-08 W=3.75e-07
MI2_MXPA1 nc C VDD VDD pm1p2_svt_lp L=6e-08 W=4.4e-07
MI2_MXPA1_2 nc C VDD VDD pm1p2_svt_lp L=6e-08 W=4.4e-07
MI3_MXPOEN bnc nb nc VDD pm1p2_svt_lp L=6e-08 W=3.15e-07
MI3_MXPOEN_2 bnc nb nc VDD pm1p2_svt_lp L=6e-08 W=3.15e-07
MI6_MXPOEN bnc B bc VDD pm1p2_svt_lp L=6e-08 W=3.15e-07
MI6_MXPOEN_2 bnc B bc VDD pm1p2_svt_lp L=6e-08 W=3.15e-07
MI5_MXPA1 bc nc VDD VDD pm1p2_svt_lp L=6e-08 W=4.4e-07
MI5_MXPA1_2 bc nc VDD VDD pm1p2_svt_lp L=6e-08 W=4.4e-07
MI0_MXPA1 na A VDD VDD pm1p2_svt_lp L=6e-08 W=4.8e-07
MI4_MXPOEN ny na bnc VDD pm1p2_svt_lp L=6e-08 W=4.1e-07
MI8_MXPOEN ny A nbnc VDD pm1p2_svt_lp L=6e-08 W=4.1e-07
MI7_MXPA1 nbnc bnc VDD VDD pm1p2_svt_lp L=6e-08 W=5.7e-07
MI9_MXPA1 Y ny VDD VDD pm1p2_svt_lp L=6e-08 W=4.15e-07
MI9_MXPA1_2 Y ny VDD VDD pm1p2_svt_lp L=6e-08 W=4.15e-07
.ENDS

.SUBCKT XOR3X2H9R Y VDD VSS A B C
MI1_MXNA1 nb B VSS VSS nm1p2_svt_lp L=6e-08 W=3.2e-07
MI1_MXNA1_2 nb B VSS VSS nm1p2_svt_lp L=6e-08 W=3.2e-07
MI2_MXNA1 nc C VSS VSS nm1p2_svt_lp L=6e-08 W=4.4e-07
MI2_MXNA1_2 nc C VSS VSS nm1p2_svt_lp L=6e-08 W=4.4e-07
MI3_MXNOE bnc B nc VSS nm1p2_svt_lp L=6e-08 W=4.4e-07
MI3_MXNOE_2 bnc B nc VSS nm1p2_svt_lp L=6e-08 W=4.4e-07
MI6_MXNOE bnc nb bc VSS nm1p2_svt_lp L=6e-08 W=4.4e-07
MI6_MXNOE_2 bnc nb bc VSS nm1p2_svt_lp L=6e-08 W=4.4e-07
MI5_MXNA1 bc nc VSS VSS nm1p2_svt_lp L=6e-08 W=4.4e-07
MI5_MXNA1_2 bc nc VSS VSS nm1p2_svt_lp L=6e-08 W=4.4e-07
MI0_MXNA1 na A VSS VSS nm1p2_svt_lp L=6e-08 W=4.1e-07
MI4_MXNOE ny A bnc VSS nm1p2_svt_lp L=6e-08 W=2.6e-07
MI4_MXNOE_2 ny A bnc VSS nm1p2_svt_lp L=6e-08 W=2.6e-07
MI8_MXNOE ny na nbnc VSS nm1p2_svt_lp L=6e-08 W=2.6e-07
MI8_MXNOE_2 ny na nbnc VSS nm1p2_svt_lp L=6e-08 W=2.6e-07
MI7_MXNA1 nbnc bnc VSS VSS nm1p2_svt_lp L=6e-08 W=2.6e-07
MI7_MXNA1_2 nbnc bnc VSS VSS nm1p2_svt_lp L=6e-08 W=2.6e-07
MI9_MXNA1 Y ny VSS VSS nm1p2_svt_lp L=6e-08 W=4.2e-07
MI9_MXNA1_2 Y ny VSS VSS nm1p2_svt_lp L=6e-08 W=4.2e-07
MI1_MXPA1 nb B VDD VDD pm1p2_svt_lp L=6e-08 W=4.45e-07
MI1_MXPA1_2 nb B VDD VDD pm1p2_svt_lp L=6e-08 W=4.45e-07
MI2_MXPA1 nc C VDD VDD pm1p2_svt_lp L=6e-08 W=5.85e-07
MI2_MXPA1_2 nc C VDD VDD pm1p2_svt_lp L=6e-08 W=5.85e-07
MI3_MXPOEN bnc nb nc VDD pm1p2_svt_lp L=6e-08 W=4.4e-07
MI3_MXPOEN_2 bnc nb nc VDD pm1p2_svt_lp L=6e-08 W=4.4e-07
MI6_MXPOEN bnc B bc VDD pm1p2_svt_lp L=6e-08 W=4.4e-07
MI6_MXPOEN_2 bnc B bc VDD pm1p2_svt_lp L=6e-08 W=4.4e-07
MI5_MXPA1 bc nc VDD VDD pm1p2_svt_lp L=6e-08 W=5.85e-07
MI5_MXPA1_2 bc nc VDD VDD pm1p2_svt_lp L=6e-08 W=5.85e-07
MI0_MXPA1 na A VDD VDD pm1p2_svt_lp L=6e-08 W=5.8e-07
MI4_MXPOEN ny na bnc VDD pm1p2_svt_lp L=6e-08 W=2.6e-07
MI4_MXPOEN_2 ny na bnc VDD pm1p2_svt_lp L=6e-08 W=2.6e-07
MI8_MXPOEN ny A nbnc VDD pm1p2_svt_lp L=6e-08 W=2.6e-07
MI8_MXPOEN_2 ny A nbnc VDD pm1p2_svt_lp L=6e-08 W=2.6e-07
MI7_MXPA1 nbnc bnc VDD VDD pm1p2_svt_lp L=6e-08 W=3.55e-07
MI7_MXPA1_2 nbnc bnc VDD VDD pm1p2_svt_lp L=6e-08 W=3.55e-07
MI9_MXPA1 Y ny VDD VDD pm1p2_svt_lp L=6e-08 W=5.85e-07
MI9_MXPA1_2 Y ny VDD VDD pm1p2_svt_lp L=6e-08 W=5.85e-07
.ENDS

.SUBCKT XOR3X3H9R Y VDD VSS A B C
MI1_MXNA1 nb B VSS VSS nm1p2_svt_lp L=6e-08 W=4.15e-07
MI1_MXNA1_2 nb B VSS VSS nm1p2_svt_lp L=6e-08 W=4.15e-07
MI2_MXNA1 nc C VSS VSS nm1p2_svt_lp L=6e-08 W=4.4e-07
MI2_MXNA1_2 nc C VSS VSS nm1p2_svt_lp L=6e-08 W=4.4e-07
MI2_MXNA1_3 nc C VSS VSS nm1p2_svt_lp L=6e-08 W=4.4e-07
MI3_MXNOE bnc B nc VSS nm1p2_svt_lp L=6e-08 W=4.4e-07
MI3_MXNOE_2 bnc B nc VSS nm1p2_svt_lp L=6e-08 W=4.4e-07
MI3_MXNOE_3 bnc B nc VSS nm1p2_svt_lp L=6e-08 W=4.4e-07
MI6_MXNOE bnc nb bc VSS nm1p2_svt_lp L=6e-08 W=4.4e-07
MI6_MXNOE_2 bnc nb bc VSS nm1p2_svt_lp L=6e-08 W=4.4e-07
MI6_MXNOE_3 bnc nb bc VSS nm1p2_svt_lp L=6e-08 W=4.4e-07
MI5_MXNA1 bc nc VSS VSS nm1p2_svt_lp L=6e-08 W=4.4e-07
MI5_MXNA1_2 bc nc VSS VSS nm1p2_svt_lp L=6e-08 W=4.4e-07
MI5_MXNA1_3 bc nc VSS VSS nm1p2_svt_lp L=6e-08 W=4.4e-07
MI0_MXNA1 na A VSS VSS nm1p2_svt_lp L=6e-08 W=2.65e-07
MI0_MXNA1_2 na A VSS VSS nm1p2_svt_lp L=6e-08 W=2.65e-07
MI4_MXNOE ny A bnc VSS nm1p2_svt_lp L=6e-08 W=3.9e-07
MI4_MXNOE_2 ny A bnc VSS nm1p2_svt_lp L=6e-08 W=3.9e-07
MI8_MXNOE ny na nbnc VSS nm1p2_svt_lp L=6e-08 W=3.9e-07
MI8_MXNOE_2 ny na nbnc VSS nm1p2_svt_lp L=6e-08 W=3.9e-07
MI7_MXNA1 nbnc bnc VSS VSS nm1p2_svt_lp L=6e-08 W=3.9e-07
MI7_MXNA1_2 nbnc bnc VSS VSS nm1p2_svt_lp L=6e-08 W=3.9e-07
MI9_MXNA1 Y ny VSS VSS nm1p2_svt_lp L=6e-08 W=4.2e-07
MI9_MXNA1_2 Y ny VSS VSS nm1p2_svt_lp L=6e-08 W=4.2e-07
MI9_MXNA1_3 Y ny VSS VSS nm1p2_svt_lp L=6e-08 W=4.2e-07
MI1_MXPA1 nb B VDD VDD pm1p2_svt_lp L=6e-08 W=5.8e-07
MI1_MXPA1_2 nb B VDD VDD pm1p2_svt_lp L=6e-08 W=5.8e-07
MI2_MXPA1 nc C VDD VDD pm1p2_svt_lp L=6e-08 W=5.85e-07
MI2_MXPA1_2 nc C VDD VDD pm1p2_svt_lp L=6e-08 W=5.85e-07
MI2_MXPA1_3 nc C VDD VDD pm1p2_svt_lp L=6e-08 W=5.85e-07
MI3_MXPOEN bnc nb nc VDD pm1p2_svt_lp L=6e-08 W=4.4e-07
MI3_MXPOEN_2 bnc nb nc VDD pm1p2_svt_lp L=6e-08 W=4.4e-07
MI3_MXPOEN_3 bnc nb nc VDD pm1p2_svt_lp L=6e-08 W=4.4e-07
MI6_MXPOEN bnc B bc VDD pm1p2_svt_lp L=6e-08 W=4.4e-07
MI6_MXPOEN_2 bnc B bc VDD pm1p2_svt_lp L=6e-08 W=4.4e-07
MI6_MXPOEN_3 bnc B bc VDD pm1p2_svt_lp L=6e-08 W=4.4e-07
MI5_MXPA1 bc nc VDD VDD pm1p2_svt_lp L=6e-08 W=5.85e-07
MI5_MXPA1_2 bc nc VDD VDD pm1p2_svt_lp L=6e-08 W=5.85e-07
MI5_MXPA1_3 bc nc VDD VDD pm1p2_svt_lp L=6e-08 W=5.85e-07
MI0_MXPA1 na A VDD VDD pm1p2_svt_lp L=6e-08 W=3.7e-07
MI0_MXPA1_2 na A VDD VDD pm1p2_svt_lp L=6e-08 W=3.7e-07
MI4_MXPOEN ny na bnc VDD pm1p2_svt_lp L=6e-08 W=3.9e-07
MI4_MXPOEN_2 ny na bnc VDD pm1p2_svt_lp L=6e-08 W=3.9e-07
MI8_MXPOEN ny A nbnc VDD pm1p2_svt_lp L=6e-08 W=3.9e-07
MI8_MXPOEN_2 ny A nbnc VDD pm1p2_svt_lp L=6e-08 W=3.9e-07
MI7_MXPA1 nbnc bnc VDD VDD pm1p2_svt_lp L=6e-08 W=5.45e-07
MI7_MXPA1_2 nbnc bnc VDD VDD pm1p2_svt_lp L=6e-08 W=5.45e-07
MI9_MXPA1 Y ny VDD VDD pm1p2_svt_lp L=6e-08 W=5.85e-07
MI9_MXPA1_2 Y ny VDD VDD pm1p2_svt_lp L=6e-08 W=5.85e-07
MI9_MXPA1_3 Y ny VDD VDD pm1p2_svt_lp L=6e-08 W=5.85e-07
.ENDS

.SUBCKT XOR3X4H9R Y VDD VSS A B C
MI1_MXNA1 nb B VSS VSS nm1p2_svt_lp L=6e-08 W=4.2e-07
MI1_MXNA1_2 nb B VSS VSS nm1p2_svt_lp L=6e-08 W=4.2e-07
MI2_MXNA1 nc C VSS VSS nm1p2_svt_lp L=6e-08 W=4.4e-07
MI2_MXNA1_2 nc C VSS VSS nm1p2_svt_lp L=6e-08 W=4.4e-07
MI2_MXNA1_3 nc C VSS VSS nm1p2_svt_lp L=6e-08 W=4.4e-07
MI2_MXNA1_4 nc C VSS VSS nm1p2_svt_lp L=6e-08 W=4.4e-07
MI3_MXNOE bnc B nc VSS nm1p2_svt_lp L=6e-08 W=4.4e-07
MI3_MXNOE_2 bnc B nc VSS nm1p2_svt_lp L=6e-08 W=4.4e-07
MI3_MXNOE_3 bnc B nc VSS nm1p2_svt_lp L=6e-08 W=4.4e-07
MI3_MXNOE_4 bnc B nc VSS nm1p2_svt_lp L=6e-08 W=4.4e-07
MI6_MXNOE bnc nb bc VSS nm1p2_svt_lp L=6e-08 W=4.4e-07
MI6_MXNOE_2 bnc nb bc VSS nm1p2_svt_lp L=6e-08 W=4.4e-07
MI6_MXNOE_3 bnc nb bc VSS nm1p2_svt_lp L=6e-08 W=4.4e-07
MI6_MXNOE_4 bnc nb bc VSS nm1p2_svt_lp L=6e-08 W=4.4e-07
MI5_MXNA1 bc nc VSS VSS nm1p2_svt_lp L=6e-08 W=4.4e-07
MI5_MXNA1_2 bc nc VSS VSS nm1p2_svt_lp L=6e-08 W=4.4e-07
MI5_MXNA1_3 bc nc VSS VSS nm1p2_svt_lp L=6e-08 W=4.4e-07
MI5_MXNA1_4 bc nc VSS VSS nm1p2_svt_lp L=6e-08 W=4.4e-07
MI0_MXNA1 na A VSS VSS nm1p2_svt_lp L=6e-08 W=3.7e-07
MI0_MXNA1_2 na A VSS VSS nm1p2_svt_lp L=6e-08 W=3.7e-07
MI4_MXNOE ny A bnc VSS nm1p2_svt_lp L=6e-08 W=4.15e-07
MI4_MXNOE_2 ny A bnc VSS nm1p2_svt_lp L=6e-08 W=4.15e-07
MI4_MXNOE_3 ny A bnc VSS nm1p2_svt_lp L=6e-08 W=4.15e-07
MI8_MXNOE ny na nbnc VSS nm1p2_svt_lp L=6e-08 W=4.15e-07
MI8_MXNOE_2 ny na nbnc VSS nm1p2_svt_lp L=6e-08 W=4.15e-07
MI8_MXNOE_3 ny na nbnc VSS nm1p2_svt_lp L=6e-08 W=4.15e-07
MI7_MXNA1 nbnc bnc VSS VSS nm1p2_svt_lp L=6e-08 W=4.15e-07
MI7_MXNA1_2 nbnc bnc VSS VSS nm1p2_svt_lp L=6e-08 W=4.15e-07
MI7_MXNA1_3 nbnc bnc VSS VSS nm1p2_svt_lp L=6e-08 W=4.15e-07
MI9_MXNA1 Y ny VSS VSS nm1p2_svt_lp L=6e-08 W=4.2e-07
MI9_MXNA1_2 Y ny VSS VSS nm1p2_svt_lp L=6e-08 W=4.2e-07
MI9_MXNA1_3 Y ny VSS VSS nm1p2_svt_lp L=6e-08 W=4.2e-07
MI9_MXNA1_4 Y ny VSS VSS nm1p2_svt_lp L=6e-08 W=4.2e-07
MI1_MXPA1 nb B VDD VDD pm1p2_svt_lp L=6e-08 W=5.85e-07
MI1_MXPA1_2 nb B VDD VDD pm1p2_svt_lp L=6e-08 W=5.85e-07
MI2_MXPA1 nc C VDD VDD pm1p2_svt_lp L=6e-08 W=5.85e-07
MI2_MXPA1_2 nc C VDD VDD pm1p2_svt_lp L=6e-08 W=5.85e-07
MI2_MXPA1_3 nc C VDD VDD pm1p2_svt_lp L=6e-08 W=5.85e-07
MI2_MXPA1_4 nc C VDD VDD pm1p2_svt_lp L=6e-08 W=5.85e-07
MI3_MXPOEN bnc nb nc VDD pm1p2_svt_lp L=6e-08 W=4.4e-07
MI3_MXPOEN_2 bnc nb nc VDD pm1p2_svt_lp L=6e-08 W=4.4e-07
MI3_MXPOEN_3 bnc nb nc VDD pm1p2_svt_lp L=6e-08 W=4.4e-07
MI3_MXPOEN_4 bnc nb nc VDD pm1p2_svt_lp L=6e-08 W=4.4e-07
MI6_MXPOEN bnc B bc VDD pm1p2_svt_lp L=6e-08 W=4.4e-07
MI6_MXPOEN_2 bnc B bc VDD pm1p2_svt_lp L=6e-08 W=4.4e-07
MI6_MXPOEN_3 bnc B bc VDD pm1p2_svt_lp L=6e-08 W=4.4e-07
MI6_MXPOEN_4 bnc B bc VDD pm1p2_svt_lp L=6e-08 W=4.4e-07
MI5_MXPA1 bc nc VDD VDD pm1p2_svt_lp L=6e-08 W=5.85e-07
MI5_MXPA1_2 bc nc VDD VDD pm1p2_svt_lp L=6e-08 W=5.85e-07
MI5_MXPA1_3 bc nc VDD VDD pm1p2_svt_lp L=6e-08 W=5.85e-07
MI5_MXPA1_4 bc nc VDD VDD pm1p2_svt_lp L=6e-08 W=5.85e-07
MI0_MXPA1 na A VDD VDD pm1p2_svt_lp L=6e-08 W=5.2e-07
MI0_MXPA1_2 na A VDD VDD pm1p2_svt_lp L=6e-08 W=5.2e-07
MI4_MXPOEN ny na bnc VDD pm1p2_svt_lp L=6e-08 W=4.15e-07
MI4_MXPOEN_2 ny na bnc VDD pm1p2_svt_lp L=6e-08 W=4.15e-07
MI4_MXPOEN_3 ny na bnc VDD pm1p2_svt_lp L=6e-08 W=4.15e-07
MI8_MXPOEN ny A nbnc VDD pm1p2_svt_lp L=6e-08 W=4.15e-07
MI8_MXPOEN_2 ny A nbnc VDD pm1p2_svt_lp L=6e-08 W=4.15e-07
MI8_MXPOEN_3 ny A nbnc VDD pm1p2_svt_lp L=6e-08 W=4.15e-07
MI7_MXPA1 nbnc bnc VDD VDD pm1p2_svt_lp L=6e-08 W=5.85e-07
MI7_MXPA1_2 nbnc bnc VDD VDD pm1p2_svt_lp L=6e-08 W=5.85e-07
MI7_MXPA1_3 nbnc bnc VDD VDD pm1p2_svt_lp L=6e-08 W=5.85e-07
MI9_MXPA1 Y ny VDD VDD pm1p2_svt_lp L=6e-08 W=5.85e-07
MI9_MXPA1_2 Y ny VDD VDD pm1p2_svt_lp L=6e-08 W=5.85e-07
MI9_MXPA1_3 Y ny VDD VDD pm1p2_svt_lp L=6e-08 W=5.85e-07
MI9_MXPA1_4 Y ny VDD VDD pm1p2_svt_lp L=6e-08 W=5.85e-07
.ENDS

.SUBCKT MUX2X0P5H9R Y VDD VSS A B S0
MI5_MXNA1 bs0 B XI5_n1 VSS nm1p2_svt_lp L=6e-08 W=1.8e-07
MI5_MXNA2 XI5_n1 S0 VSS VSS nm1p2_svt_lp L=6e-08 W=1.8e-07
MI3_MXNA2 XI3_n1 bs0 VSS VSS nm1p2_svt_lp L=6e-08 W=2.5e-07
MI3_MXNA1 Y ans0 XI3_n1 VSS nm1p2_svt_lp L=6e-08 W=2.5e-07
MI4_MXNA1 ans0 A XI4_n1 VSS nm1p2_svt_lp L=6e-08 W=1.8e-07
MI4_MXNA2 XI4_n1 ns0 VSS VSS nm1p2_svt_lp L=6e-08 W=1.8e-07
MI2_MXNA1 ns0 S0 VSS VSS nm1p2_svt_lp L=6e-08 W=1.9e-07
MI5_MXPA1 bs0 B VDD VDD pm1p2_svt_lp L=6e-08 W=2e-07
MI5_MXPA2 bs0 S0 VDD VDD pm1p2_svt_lp L=6e-08 W=2e-07
MI3_MXPA2 Y bs0 VDD VDD pm1p2_svt_lp L=6e-08 W=2e-07
MI3_MXPA1 Y ans0 VDD VDD pm1p2_svt_lp L=6e-08 W=2e-07
MI4_MXPA1 ans0 A VDD VDD pm1p2_svt_lp L=6e-08 W=2e-07
MI4_MXPA2 ans0 ns0 VDD VDD pm1p2_svt_lp L=6e-08 W=2e-07
MI2_MXPA1 ns0 S0 VDD VDD pm1p2_svt_lp L=6e-08 W=2.9e-07
.ENDS

.SUBCKT MUX2X0P7H9R Y VDD VSS A B S0
MI5_MXNA1 bs0 B XI5_n1 VSS nm1p2_svt_lp L=6e-08 W=2.3e-07
MI5_MXNA2 XI5_n1 S0 VSS VSS nm1p2_svt_lp L=6e-08 W=2.3e-07
MI3_MXNA2 XI3_n1 bs0 VSS VSS nm1p2_svt_lp L=6e-08 W=3.5e-07
MI3_MXNA1 Y ans0 XI3_n1 VSS nm1p2_svt_lp L=6e-08 W=3.5e-07
MI4_MXNA1 ans0 A XI4_n1 VSS nm1p2_svt_lp L=6e-08 W=2.3e-07
MI4_MXNA2 XI4_n1 ns0 VSS VSS nm1p2_svt_lp L=6e-08 W=2.3e-07
MI2_MXNA1 ns0 S0 VSS VSS nm1p2_svt_lp L=6e-08 W=2.3e-07
MI5_MXPA1 bs0 B VDD VDD pm1p2_svt_lp L=6e-08 W=2.5e-07
MI5_MXPA2 bs0 S0 VDD VDD pm1p2_svt_lp L=6e-08 W=2.5e-07
MI3_MXPA2 Y bs0 VDD VDD pm1p2_svt_lp L=6e-08 W=2.8e-07
MI3_MXPA1 Y ans0 VDD VDD pm1p2_svt_lp L=6e-08 W=2.8e-07
MI4_MXPA1 ans0 A VDD VDD pm1p2_svt_lp L=6e-08 W=2.5e-07
MI4_MXPA2 ans0 ns0 VDD VDD pm1p2_svt_lp L=6e-08 W=2.5e-07
MI2_MXPA1 ns0 S0 VDD VDD pm1p2_svt_lp L=6e-08 W=3.4e-07
.ENDS

.SUBCKT MUX2X1H9R Y VDD VSS A B S0
MI5_MXNA1 bs0 B XI5_n1 VSS nm1p2_svt_lp L=6e-08 W=2.9e-07
MI5_MXNA2 XI5_n1 S0 VSS VSS nm1p2_svt_lp L=6e-08 W=2.9e-07
MI3_MXNA2 XI3_n1 bs0 VSS VSS nm1p2_svt_lp L=6e-08 W=4.95e-07
MI3_MXNA1 Y ans0 XI3_n1 VSS nm1p2_svt_lp L=6e-08 W=4.95e-07
MI4_MXNA1 ans0 A XI4_n1 VSS nm1p2_svt_lp L=6e-08 W=2.9e-07
MI4_MXNA2 XI4_n1 ns0 VSS VSS nm1p2_svt_lp L=6e-08 W=2.9e-07
MI2_MXNA1 ns0 S0 VSS VSS nm1p2_svt_lp L=6e-08 W=2.3e-07
MI5_MXPA1 bs0 B VDD VDD pm1p2_svt_lp L=6e-08 W=3.2e-07
MI5_MXPA2 bs0 S0 VDD VDD pm1p2_svt_lp L=6e-08 W=3.2e-07
MI3_MXPA2 Y bs0 VDD VDD pm1p2_svt_lp L=6e-08 W=3.95e-07
MI3_MXPA1 Y ans0 VDD VDD pm1p2_svt_lp L=6e-08 W=3.95e-07
MI4_MXPA1 ans0 A VDD VDD pm1p2_svt_lp L=6e-08 W=3.2e-07
MI4_MXPA2 ans0 ns0 VDD VDD pm1p2_svt_lp L=6e-08 W=3.2e-07
MI2_MXPA1 ns0 S0 VDD VDD pm1p2_svt_lp L=6e-08 W=3.5e-07
.ENDS

.SUBCKT MUX2X1P4H9R Y VDD VSS A B S0
MI5_MXNA1 bs0 B XI5_n1 VSS nm1p2_svt_lp L=6e-08 W=3.6e-07
MI5_MXNA2 XI5_n1 S0 VSS VSS nm1p2_svt_lp L=6e-08 W=3.6e-07
MI2_MXNA1 ns0 S0 VSS VSS nm1p2_svt_lp L=6e-08 W=2.7e-07
MI4_MXNA1 ans0 A XI4_n1 VSS nm1p2_svt_lp L=6e-08 W=3.6e-07
MI4_MXNA2 XI4_n1 ns0 VSS VSS nm1p2_svt_lp L=6e-08 W=3.6e-07
MI3_MXNA2_2 XI3_n1__2 bs0 VSS VSS nm1p2_svt_lp L=6e-08 W=3.5e-07
MI3_MXNA1_2 Y ans0 XI3_n1__2 VSS nm1p2_svt_lp L=6e-08 W=3.5e-07
MI3_MXNA1 Y ans0 XI3_n1 VSS nm1p2_svt_lp L=6e-08 W=3.5e-07
MI3_MXNA2 XI3_n1 bs0 VSS VSS nm1p2_svt_lp L=6e-08 W=3.5e-07
MI5_MXPA1 bs0 B VDD VDD pm1p2_svt_lp L=6e-08 W=3.9e-07
MI5_MXPA2 bs0 S0 VDD VDD pm1p2_svt_lp L=6e-08 W=3.9e-07
MI2_MXPA1 ns0 S0 VDD VDD pm1p2_svt_lp L=6e-08 W=4.1e-07
MI4_MXPA1 ans0 A VDD VDD pm1p2_svt_lp L=6e-08 W=3.9e-07
MI4_MXPA2 ans0 ns0 VDD VDD pm1p2_svt_lp L=6e-08 W=3.9e-07
MI3_MXPA2 Y bs0 VDD VDD pm1p2_svt_lp L=6e-08 W=2.8e-07
MI3_MXPA1 Y ans0 VDD VDD pm1p2_svt_lp L=6e-08 W=2.8e-07
MI3_MXPA1_2 Y ans0 VDD VDD pm1p2_svt_lp L=6e-08 W=2.8e-07
MI3_MXPA2_2 Y bs0 VDD VDD pm1p2_svt_lp L=6e-08 W=2.8e-07
.ENDS

.SUBCKT MUX2X2H9R Y VDD VSS A B S0
MI5_MXNA1 bs0 B XI5_n1 VSS nm1p2_svt_lp L=6e-08 W=4.45e-07
MI5_MXNA2 XI5_n1 S0 VSS VSS nm1p2_svt_lp L=6e-08 W=4.45e-07
MI2_MXNA1 ns0 S0 VSS VSS nm1p2_svt_lp L=6e-08 W=3e-07
MI4_MXNA1 ans0 A XI4_n1 VSS nm1p2_svt_lp L=6e-08 W=4.45e-07
MI4_MXNA2 XI4_n1 ns0 VSS VSS nm1p2_svt_lp L=6e-08 W=4.45e-07
MI3_MXNA2_2 XI3_n1__2 bs0 VSS VSS nm1p2_svt_lp L=6e-08 W=4.95e-07
MI3_MXNA1_2 Y ans0 XI3_n1__2 VSS nm1p2_svt_lp L=6e-08 W=4.95e-07
MI3_MXNA1 Y ans0 XI3_n1 VSS nm1p2_svt_lp L=6e-08 W=4.95e-07
MI3_MXNA2 XI3_n1 bs0 VSS VSS nm1p2_svt_lp L=6e-08 W=4.95e-07
MI5_MXPA1 bs0 B VDD VDD pm1p2_svt_lp L=6e-08 W=4.8e-07
MI5_MXPA2 bs0 S0 VDD VDD pm1p2_svt_lp L=6e-08 W=4.8e-07
MI2_MXPA1 ns0 S0 VDD VDD pm1p2_svt_lp L=6e-08 W=4.65e-07
MI4_MXPA1 ans0 A VDD VDD pm1p2_svt_lp L=6e-08 W=4.8e-07
MI4_MXPA2 ans0 ns0 VDD VDD pm1p2_svt_lp L=6e-08 W=4.8e-07
MI3_MXPA2 Y bs0 VDD VDD pm1p2_svt_lp L=6e-08 W=3.95e-07
MI3_MXPA1 Y ans0 VDD VDD pm1p2_svt_lp L=6e-08 W=3.95e-07
MI3_MXPA1_2 Y ans0 VDD VDD pm1p2_svt_lp L=6e-08 W=3.95e-07
MI3_MXPA2_2 Y bs0 VDD VDD pm1p2_svt_lp L=6e-08 W=3.95e-07
.ENDS

.SUBCKT MUX2X3H9R Y VDD VSS A B S0
MI5_MXNA2_2 XI5_n1__2 S0 VSS VSS nm1p2_svt_lp L=6e-08 W=3.5e-07
MI5_MXNA1_2 bs0 B XI5_n1__2 VSS nm1p2_svt_lp L=6e-08 W=3.5e-07
MI5_MXNA1 bs0 B XI5_n1 VSS nm1p2_svt_lp L=6e-08 W=3.5e-07
MI5_MXNA2 XI5_n1 S0 VSS VSS nm1p2_svt_lp L=6e-08 W=3.5e-07
MI2_MXNA1 ns0 S0 VSS VSS nm1p2_svt_lp L=6e-08 W=2.4e-07
MI2_MXNA1_2 ns0 S0 VSS VSS nm1p2_svt_lp L=6e-08 W=2.4e-07
MI4_MXNA2_2 XI4_n1__2 ns0 VSS VSS nm1p2_svt_lp L=6e-08 W=3.5e-07
MI4_MXNA1_2 ans0 A XI4_n1__2 VSS nm1p2_svt_lp L=6e-08 W=3.5e-07
MI4_MXNA1 ans0 A XI4_n1 VSS nm1p2_svt_lp L=6e-08 W=3.5e-07
MI4_MXNA2 XI4_n1 ns0 VSS VSS nm1p2_svt_lp L=6e-08 W=3.5e-07
MI3_MXNA2_2 XI3_n1__2 bs0 VSS VSS nm1p2_svt_lp L=6e-08 W=4.95e-07
MI3_MXNA1_2 Y ans0 XI3_n1__2 VSS nm1p2_svt_lp L=6e-08 W=4.95e-07
MI3_MXNA1_3 Y ans0 XI3_n1__3 VSS nm1p2_svt_lp L=6e-08 W=4.95e-07
MI3_MXNA2_3 XI3_n1__3 bs0 VSS VSS nm1p2_svt_lp L=6e-08 W=4.95e-07
MI3_MXNA2 XI3_n1 bs0 VSS VSS nm1p2_svt_lp L=6e-08 W=4.95e-07
MI3_MXNA1 Y ans0 XI3_n1 VSS nm1p2_svt_lp L=6e-08 W=4.95e-07
MI5_MXPA2 bs0 S0 VDD VDD pm1p2_svt_lp L=6e-08 W=3.85e-07
MI5_MXPA1 bs0 B VDD VDD pm1p2_svt_lp L=6e-08 W=3.85e-07
MI5_MXPA1_2 bs0 B VDD VDD pm1p2_svt_lp L=6e-08 W=3.85e-07
MI5_MXPA2_2 bs0 S0 VDD VDD pm1p2_svt_lp L=6e-08 W=3.85e-07
MI2_MXPA1 ns0 S0 VDD VDD pm1p2_svt_lp L=6e-08 W=3.65e-07
MI2_MXPA1_2 ns0 S0 VDD VDD pm1p2_svt_lp L=6e-08 W=3.65e-07
MI4_MXPA2 ans0 ns0 VDD VDD pm1p2_svt_lp L=6e-08 W=3.85e-07
MI4_MXPA1 ans0 A VDD VDD pm1p2_svt_lp L=6e-08 W=3.85e-07
MI4_MXPA1_2 ans0 A VDD VDD pm1p2_svt_lp L=6e-08 W=3.85e-07
MI4_MXPA2_2 ans0 ns0 VDD VDD pm1p2_svt_lp L=6e-08 W=3.85e-07
MI3_MXPA2 Y bs0 VDD VDD pm1p2_svt_lp L=6e-08 W=3.95e-07
MI3_MXPA1 Y ans0 VDD VDD pm1p2_svt_lp L=6e-08 W=3.95e-07
MI3_MXPA1_2 Y ans0 VDD VDD pm1p2_svt_lp L=6e-08 W=3.95e-07
MI3_MXPA2_2 Y bs0 VDD VDD pm1p2_svt_lp L=6e-08 W=3.95e-07
MI3_MXPA2_3 Y bs0 VDD VDD pm1p2_svt_lp L=6e-08 W=3.95e-07
MI3_MXPA1_3 Y ans0 VDD VDD pm1p2_svt_lp L=6e-08 W=3.95e-07
.ENDS

.SUBCKT MUX2X4H9R Y VDD VSS A B S0
MI5_MXNA2_2 XI5_n1__2 S0 VSS VSS nm1p2_svt_lp L=6e-08 W=4.45e-07
MI5_MXNA1_2 bs0 B XI5_n1__2 VSS nm1p2_svt_lp L=6e-08 W=4.45e-07
MI5_MXNA1 bs0 B XI5_n1 VSS nm1p2_svt_lp L=6e-08 W=4.45e-07
MI5_MXNA2 XI5_n1 S0 VSS VSS nm1p2_svt_lp L=6e-08 W=4.45e-07
MI2_MXNA1 ns0 S0 VSS VSS nm1p2_svt_lp L=6e-08 W=2.85e-07
MI2_MXNA1_2 ns0 S0 VSS VSS nm1p2_svt_lp L=6e-08 W=2.85e-07
MI4_MXNA2_2 XI4_n1__2 ns0 VSS VSS nm1p2_svt_lp L=6e-08 W=4.45e-07
MI4_MXNA1_2 ans0 A XI4_n1__2 VSS nm1p2_svt_lp L=6e-08 W=4.45e-07
MI4_MXNA1 ans0 A XI4_n1 VSS nm1p2_svt_lp L=6e-08 W=4.45e-07
MI4_MXNA2 XI4_n1 ns0 VSS VSS nm1p2_svt_lp L=6e-08 W=4.45e-07
MI3_MXNA2_2 XI3_n1__2 bs0 VSS VSS nm1p2_svt_lp L=6e-08 W=4.95e-07
MI3_MXNA1_2 Y ans0 XI3_n1__2 VSS nm1p2_svt_lp L=6e-08 W=4.95e-07
MI3_MXNA1_3 Y ans0 XI3_n1__3 VSS nm1p2_svt_lp L=6e-08 W=4.95e-07
MI3_MXNA2_3 XI3_n1__3 bs0 VSS VSS nm1p2_svt_lp L=6e-08 W=4.95e-07
MI3_MXNA2_4 XI3_n1__4 bs0 VSS VSS nm1p2_svt_lp L=6e-08 W=4.95e-07
MI3_MXNA1_4 Y ans0 XI3_n1__4 VSS nm1p2_svt_lp L=6e-08 W=4.95e-07
MI3_MXNA1 Y ans0 XI3_n1 VSS nm1p2_svt_lp L=6e-08 W=4.95e-07
MI3_MXNA2 XI3_n1 bs0 VSS VSS nm1p2_svt_lp L=6e-08 W=4.95e-07
MI5_MXPA2 bs0 S0 VDD VDD pm1p2_svt_lp L=6e-08 W=4.9e-07
MI5_MXPA1 bs0 B VDD VDD pm1p2_svt_lp L=6e-08 W=4.9e-07
MI5_MXPA1_2 bs0 B VDD VDD pm1p2_svt_lp L=6e-08 W=4.9e-07
MI5_MXPA2_2 bs0 S0 VDD VDD pm1p2_svt_lp L=6e-08 W=4.9e-07
MI2_MXPA1 ns0 S0 VDD VDD pm1p2_svt_lp L=6e-08 W=4.35e-07
MI2_MXPA1_2 ns0 S0 VDD VDD pm1p2_svt_lp L=6e-08 W=4.35e-07
MI4_MXPA2 ans0 ns0 VDD VDD pm1p2_svt_lp L=6e-08 W=4.9e-07
MI4_MXPA1 ans0 A VDD VDD pm1p2_svt_lp L=6e-08 W=4.9e-07
MI4_MXPA1_2 ans0 A VDD VDD pm1p2_svt_lp L=6e-08 W=4.9e-07
MI4_MXPA2_2 ans0 ns0 VDD VDD pm1p2_svt_lp L=6e-08 W=4.9e-07
MI3_MXPA2 Y bs0 VDD VDD pm1p2_svt_lp L=6e-08 W=3.95e-07
MI3_MXPA1 Y ans0 VDD VDD pm1p2_svt_lp L=6e-08 W=3.95e-07
MI3_MXPA1_2 Y ans0 VDD VDD pm1p2_svt_lp L=6e-08 W=3.95e-07
MI3_MXPA2_2 Y bs0 VDD VDD pm1p2_svt_lp L=6e-08 W=3.95e-07
MI3_MXPA2_3 Y bs0 VDD VDD pm1p2_svt_lp L=6e-08 W=3.95e-07
MI3_MXPA1_3 Y ans0 VDD VDD pm1p2_svt_lp L=6e-08 W=3.95e-07
MI3_MXPA1_4 Y ans0 VDD VDD pm1p2_svt_lp L=6e-08 W=3.95e-07
MI3_MXPA2_4 Y bs0 VDD VDD pm1p2_svt_lp L=6e-08 W=3.95e-07
.ENDS

.SUBCKT MUX2X6H9R Y VDD VSS A B S0
MI5_MXNA1_2 bs0 B XI5_n1__2 VSS nm1p2_svt_lp L=6e-08 W=4.5e-07
MI5_MXNA2_2 XI5_n1__2 S0 VSS VSS nm1p2_svt_lp L=6e-08 W=4.5e-07
MI5_MXNA2_3 XI5_n1__3 S0 VSS VSS nm1p2_svt_lp L=6e-08 W=4.5e-07
MI5_MXNA1_3 bs0 B XI5_n1__3 VSS nm1p2_svt_lp L=6e-08 W=4.5e-07
MI5_MXNA1 bs0 B XI5_n1 VSS nm1p2_svt_lp L=6e-08 W=4.5e-07
MI5_MXNA2 XI5_n1 S0 VSS VSS nm1p2_svt_lp L=6e-08 W=4.5e-07
MI2_MXNA1 ns0 S0 VSS VSS nm1p2_svt_lp L=6e-08 W=4.2e-07
MI2_MXNA1_2 ns0 S0 VSS VSS nm1p2_svt_lp L=6e-08 W=4.2e-07
MI4_MXNA2_2 XI4_n1__2 ns0 VSS VSS nm1p2_svt_lp L=6e-08 W=4.5e-07
MI4_MXNA1_2 ans0 A XI4_n1__2 VSS nm1p2_svt_lp L=6e-08 W=4.5e-07
MI4_MXNA1_3 ans0 A XI4_n1__3 VSS nm1p2_svt_lp L=6e-08 W=4.5e-07
MI4_MXNA2_3 XI4_n1__3 ns0 VSS VSS nm1p2_svt_lp L=6e-08 W=4.5e-07
MI4_MXNA2 XI4_n1 ns0 VSS VSS nm1p2_svt_lp L=6e-08 W=4.5e-07
MI4_MXNA1 ans0 A XI4_n1 VSS nm1p2_svt_lp L=6e-08 W=4.5e-07
MI3_MXNA2_2 XI3_n1__2 bs0 VSS VSS nm1p2_svt_lp L=6e-08 W=4.95e-07
MI3_MXNA1_2 Y ans0 XI3_n1__2 VSS nm1p2_svt_lp L=6e-08 W=4.95e-07
MI3_MXNA1_3 Y ans0 XI3_n1__3 VSS nm1p2_svt_lp L=6e-08 W=4.95e-07
MI3_MXNA2_3 XI3_n1__3 bs0 VSS VSS nm1p2_svt_lp L=6e-08 W=4.95e-07
MI3_MXNA2_4 XI3_n1__4 bs0 VSS VSS nm1p2_svt_lp L=6e-08 W=4.95e-07
MI3_MXNA1_4 Y ans0 XI3_n1__4 VSS nm1p2_svt_lp L=6e-08 W=4.95e-07
MI3_MXNA1_5 Y ans0 XI3_n1__5 VSS nm1p2_svt_lp L=6e-08 W=4.95e-07
MI3_MXNA2_5 XI3_n1__5 bs0 VSS VSS nm1p2_svt_lp L=6e-08 W=4.95e-07
MI3_MXNA2_6 XI3_n1__6 bs0 VSS VSS nm1p2_svt_lp L=6e-08 W=4.95e-07
MI3_MXNA1_6 Y ans0 XI3_n1__6 VSS nm1p2_svt_lp L=6e-08 W=4.95e-07
MI3_MXNA1 Y ans0 XI3_n1 VSS nm1p2_svt_lp L=6e-08 W=4.95e-07
MI3_MXNA2 XI3_n1 bs0 VSS VSS nm1p2_svt_lp L=6e-08 W=4.95e-07
MI5_MXPA1 bs0 B VDD VDD pm1p2_svt_lp L=6e-08 W=4.9e-07
MI5_MXPA2 bs0 S0 VDD VDD pm1p2_svt_lp L=6e-08 W=4.9e-07
MI5_MXPA2_2 bs0 S0 VDD VDD pm1p2_svt_lp L=6e-08 W=4.9e-07
MI5_MXPA1_2 bs0 B VDD VDD pm1p2_svt_lp L=6e-08 W=4.9e-07
MI5_MXPA1_3 bs0 B VDD VDD pm1p2_svt_lp L=6e-08 W=4.9e-07
MI5_MXPA2_3 bs0 S0 VDD VDD pm1p2_svt_lp L=6e-08 W=4.9e-07
MI2_MXPA1 ns0 S0 VDD VDD pm1p2_svt_lp L=6e-08 W=5.85e-07
MI2_MXPA1_2 ns0 S0 VDD VDD pm1p2_svt_lp L=6e-08 W=5.85e-07
MI4_MXPA2 ans0 ns0 VDD VDD pm1p2_svt_lp L=6e-08 W=4.9e-07
MI4_MXPA1 ans0 A VDD VDD pm1p2_svt_lp L=6e-08 W=4.9e-07
MI4_MXPA1_2 ans0 A VDD VDD pm1p2_svt_lp L=6e-08 W=4.9e-07
MI4_MXPA2_2 ans0 ns0 VDD VDD pm1p2_svt_lp L=6e-08 W=4.9e-07
MI4_MXPA2_3 ans0 ns0 VDD VDD pm1p2_svt_lp L=6e-08 W=4.9e-07
MI4_MXPA1_3 ans0 A VDD VDD pm1p2_svt_lp L=6e-08 W=4.9e-07
MI3_MXPA2 Y bs0 VDD VDD pm1p2_svt_lp L=6e-08 W=3.95e-07
MI3_MXPA1 Y ans0 VDD VDD pm1p2_svt_lp L=6e-08 W=3.95e-07
MI3_MXPA1_2 Y ans0 VDD VDD pm1p2_svt_lp L=6e-08 W=3.95e-07
MI3_MXPA2_2 Y bs0 VDD VDD pm1p2_svt_lp L=6e-08 W=3.95e-07
MI3_MXPA2_3 Y bs0 VDD VDD pm1p2_svt_lp L=6e-08 W=3.95e-07
MI3_MXPA1_3 Y ans0 VDD VDD pm1p2_svt_lp L=6e-08 W=3.95e-07
MI3_MXPA1_4 Y ans0 VDD VDD pm1p2_svt_lp L=6e-08 W=3.95e-07
MI3_MXPA2_4 Y bs0 VDD VDD pm1p2_svt_lp L=6e-08 W=3.95e-07
MI3_MXPA2_5 Y bs0 VDD VDD pm1p2_svt_lp L=6e-08 W=3.95e-07
MI3_MXPA1_5 Y ans0 VDD VDD pm1p2_svt_lp L=6e-08 W=3.95e-07
MI3_MXPA1_6 Y ans0 VDD VDD pm1p2_svt_lp L=6e-08 W=3.95e-07
MI3_MXPA2_6 Y bs0 VDD VDD pm1p2_svt_lp L=6e-08 W=3.95e-07
.ENDS

.SUBCKT MUXT2X0P5H9R Y VDD VSS A B S0
MI5_MXNA1 ns0 S0 VSS VSS nm1p2_svt_lp L=6e-08 W=2.5e-07
MI2_MXNA1 nb B VSS VSS nm1p2_svt_lp L=6e-08 W=2.2e-07
MI3_MXNOE ny S0 nb VSS nm1p2_svt_lp L=6e-08 W=2.2e-07
MI1_MXNOE ny ns0 na VSS nm1p2_svt_lp L=6e-08 W=2.2e-07
MI0_MXNA1 na A VSS VSS nm1p2_svt_lp L=6e-08 W=2.2e-07
MI4_MXNA1 Y ny VSS VSS nm1p2_svt_lp L=6e-08 W=2.1e-07
MI5_MXPA1 ns0 S0 VDD VDD pm1p2_svt_lp L=6e-08 W=3.5e-07
MI2_MXPA1 nb B VDD VDD pm1p2_svt_lp L=6e-08 W=3.1e-07
MI3_MXPOEN ny ns0 nb VDD pm1p2_svt_lp L=6e-08 W=2.2e-07
MI1_MXPOEN ny S0 na VDD pm1p2_svt_lp L=6e-08 W=2.2e-07
MI0_MXPA1 na A VDD VDD pm1p2_svt_lp L=6e-08 W=3.1e-07
MI4_MXPA1 Y ny VDD VDD pm1p2_svt_lp L=6e-08 W=2.95e-07
.ENDS

.SUBCKT MUXT2X0P7H9R Y VDD VSS A B S0
MI5_MXNA1 ns0 S0 VSS VSS nm1p2_svt_lp L=6e-08 W=2.75e-07
MI2_MXNA1 nb B VSS VSS nm1p2_svt_lp L=6e-08 W=2.6e-07
MI3_MXNOE ny S0 nb VSS nm1p2_svt_lp L=6e-08 W=2.6e-07
MI1_MXNOE ny ns0 na VSS nm1p2_svt_lp L=6e-08 W=2.6e-07
MI0_MXNA1 na A VSS VSS nm1p2_svt_lp L=6e-08 W=2.6e-07
MI4_MXNA1 Y ny VSS VSS nm1p2_svt_lp L=6e-08 W=2.95e-07
MI5_MXPA1 ns0 S0 VDD VDD pm1p2_svt_lp L=6e-08 W=3.8e-07
MI2_MXPA1 nb B VDD VDD pm1p2_svt_lp L=6e-08 W=3.65e-07
MI3_MXPOEN ny ns0 nb VDD pm1p2_svt_lp L=6e-08 W=2.6e-07
MI1_MXPOEN ny S0 na VDD pm1p2_svt_lp L=6e-08 W=2.6e-07
MI0_MXPA1 na A VDD VDD pm1p2_svt_lp L=6e-08 W=3.65e-07
MI4_MXPA1 Y ny VDD VDD pm1p2_svt_lp L=6e-08 W=4.15e-07
.ENDS

.SUBCKT MUXT2X1H9R Y VDD VSS A B S0
MI5_MXNA1 ns0 S0 VSS VSS nm1p2_svt_lp L=6e-08 W=3e-07
MI2_MXNA1 nb B VSS VSS nm1p2_svt_lp L=6e-08 W=3.05e-07
MI3_MXNOE ny S0 nb VSS nm1p2_svt_lp L=6e-08 W=3.05e-07
MI1_MXNOE ny ns0 na VSS nm1p2_svt_lp L=6e-08 W=3.05e-07
MI0_MXNA1 na A VSS VSS nm1p2_svt_lp L=6e-08 W=3.05e-07
MI4_MXNA1 Y ny VSS VSS nm1p2_svt_lp L=6e-08 W=4.2e-07
MI5_MXPA1 ns0 S0 VDD VDD pm1p2_svt_lp L=6e-08 W=4.2e-07
MI2_MXPA1 nb B VDD VDD pm1p2_svt_lp L=6e-08 W=4.25e-07
MI3_MXPOEN ny ns0 nb VDD pm1p2_svt_lp L=6e-08 W=3.05e-07
MI1_MXPOEN ny S0 na VDD pm1p2_svt_lp L=6e-08 W=3.05e-07
MI0_MXPA1 na A VDD VDD pm1p2_svt_lp L=6e-08 W=4.25e-07
MI4_MXPA1 Y ny VDD VDD pm1p2_svt_lp L=6e-08 W=5.85e-07
.ENDS

.SUBCKT MUXT2X1P4H9R Y VDD VSS A B S0
MI5_MXNA1 ns0 S0 VSS VSS nm1p2_svt_lp L=6e-08 W=3.4e-07
MI2_MXNA1 nb B VSS VSS nm1p2_svt_lp L=6e-08 W=4.2e-07
MI3_MXNOE ny S0 nb VSS nm1p2_svt_lp L=6e-08 W=4.2e-07
MI1_MXNOE ny ns0 na VSS nm1p2_svt_lp L=6e-08 W=4.2e-07
MI0_MXNA1 na A VSS VSS nm1p2_svt_lp L=6e-08 W=4.2e-07
MI4_MXNA1 Y ny VSS VSS nm1p2_svt_lp L=6e-08 W=2.95e-07
MI4_MXNA1_2 Y ny VSS VSS nm1p2_svt_lp L=6e-08 W=2.95e-07
MI5_MXPA1 ns0 S0 VDD VDD pm1p2_svt_lp L=6e-08 W=4.8e-07
MI2_MXPA1 nb B VDD VDD pm1p2_svt_lp L=6e-08 W=5.85e-07
MI3_MXPOEN ny ns0 nb VDD pm1p2_svt_lp L=6e-08 W=4.2e-07
MI1_MXPOEN ny S0 na VDD pm1p2_svt_lp L=6e-08 W=4.2e-07
MI0_MXPA1 na A VDD VDD pm1p2_svt_lp L=6e-08 W=5.85e-07
MI4_MXPA1 Y ny VDD VDD pm1p2_svt_lp L=6e-08 W=4.15e-07
MI4_MXPA1_2 Y ny VDD VDD pm1p2_svt_lp L=6e-08 W=4.15e-07
.ENDS

.SUBCKT MUXT2X2H9R Y VDD VSS A B S0
MI5_MXNA1 ns0 S0 VSS VSS nm1p2_svt_lp L=6e-08 W=3.9e-07
MI2_MXNA1 nb B VSS VSS nm1p2_svt_lp L=6e-08 W=2.5e-07
MI2_MXNA1_2 nb B VSS VSS nm1p2_svt_lp L=6e-08 W=2.5e-07
MI3_MXNOE ny S0 nb VSS nm1p2_svt_lp L=6e-08 W=5e-07
MI1_MXNOE ny ns0 na VSS nm1p2_svt_lp L=6e-08 W=5e-07
MI0_MXNA1 na A VSS VSS nm1p2_svt_lp L=6e-08 W=5e-07
MI4_MXNA1 Y ny VSS VSS nm1p2_svt_lp L=6e-08 W=4.2e-07
MI4_MXNA1_2 Y ny VSS VSS nm1p2_svt_lp L=6e-08 W=4.2e-07
MI5_MXPA1 ns0 S0 VDD VDD pm1p2_svt_lp L=6e-08 W=5.45e-07
MI2_MXPA1 nb B VDD VDD pm1p2_svt_lp L=6e-08 W=3.5e-07
MI2_MXPA1_2 nb B VDD VDD pm1p2_svt_lp L=6e-08 W=3.5e-07
MI3_MXPOEN ny ns0 nb VDD pm1p2_svt_lp L=6e-08 W=5e-07
MI1_MXPOEN ny S0 na VDD pm1p2_svt_lp L=6e-08 W=5e-07
MI0_MXPA1 na A VDD VDD pm1p2_svt_lp L=6e-08 W=3.5e-07
MI0_MXPA1_2 na A VDD VDD pm1p2_svt_lp L=6e-08 W=3.5e-07
MI4_MXPA1 Y ny VDD VDD pm1p2_svt_lp L=6e-08 W=5.85e-07
MI4_MXPA1_2 Y ny VDD VDD pm1p2_svt_lp L=6e-08 W=5.85e-07
.ENDS

.SUBCKT MUXT2X3H9R Y VDD VSS A B S0
MI5_MXNA1 ns0 S0 VSS VSS nm1p2_svt_lp L=6e-08 W=3.35e-07
MI5_MXNA1_2 ns0 S0 VSS VSS nm1p2_svt_lp L=6e-08 W=3.35e-07
MI0_MXNA1 na A VSS VSS nm1p2_svt_lp L=6e-08 W=4e-07
MI0_MXNA1_2 na A VSS VSS nm1p2_svt_lp L=6e-08 W=4e-07
MI1_MXNOE ny ns0 na VSS nm1p2_svt_lp L=6e-08 W=4e-07
MI1_MXNOE_2 ny ns0 na VSS nm1p2_svt_lp L=6e-08 W=4e-07
MI3_MXNOE ny S0 nb VSS nm1p2_svt_lp L=6e-08 W=4e-07
MI3_MXNOE_2 ny S0 nb VSS nm1p2_svt_lp L=6e-08 W=4e-07
MI2_MXNA1 nb B VSS VSS nm1p2_svt_lp L=6e-08 W=4e-07
MI2_MXNA1_2 nb B VSS VSS nm1p2_svt_lp L=6e-08 W=4e-07
MI4_MXNA1 Y ny VSS VSS nm1p2_svt_lp L=6e-08 W=4.2e-07
MI4_MXNA1_2 Y ny VSS VSS nm1p2_svt_lp L=6e-08 W=4.2e-07
MI4_MXNA1_3 Y ny VSS VSS nm1p2_svt_lp L=6e-08 W=4.2e-07
MI5_MXPA1 ns0 S0 VDD VDD pm1p2_svt_lp L=6e-08 W=4.7e-07
MI5_MXPA1_2 ns0 S0 VDD VDD pm1p2_svt_lp L=6e-08 W=4.7e-07
MI0_MXPA1 na A VDD VDD pm1p2_svt_lp L=6e-08 W=5.6e-07
MI0_MXPA1_2 na A VDD VDD pm1p2_svt_lp L=6e-08 W=5.6e-07
MI1_MXPOEN ny S0 na VDD pm1p2_svt_lp L=6e-08 W=4e-07
MI1_MXPOEN_2 ny S0 na VDD pm1p2_svt_lp L=6e-08 W=4e-07
MI3_MXPOEN ny ns0 nb VDD pm1p2_svt_lp L=6e-08 W=4e-07
MI3_MXPOEN_2 ny ns0 nb VDD pm1p2_svt_lp L=6e-08 W=4e-07
MI2_MXPA1 nb B VDD VDD pm1p2_svt_lp L=6e-08 W=5.6e-07
MI2_MXPA1_2 nb B VDD VDD pm1p2_svt_lp L=6e-08 W=5.6e-07
MI4_MXPA1 Y ny VDD VDD pm1p2_svt_lp L=6e-08 W=5.85e-07
MI4_MXPA1_2 Y ny VDD VDD pm1p2_svt_lp L=6e-08 W=5.85e-07
MI4_MXPA1_3 Y ny VDD VDD pm1p2_svt_lp L=6e-08 W=5.85e-07
.ENDS

.SUBCKT MUXT2X4H9R Y VDD VSS A B S0
MI5_MXNA1 ns0 S0 VSS VSS nm1p2_svt_lp L=6e-08 W=4.1e-07
MI5_MXNA1_2 ns0 S0 VSS VSS nm1p2_svt_lp L=6e-08 W=4.1e-07
MI0_MXNA1 na A VSS VSS nm1p2_svt_lp L=6e-08 W=3.45e-07
MI0_MXNA1_2 na A VSS VSS nm1p2_svt_lp L=6e-08 W=3.45e-07
MI0_MXNA1_3 na A VSS VSS nm1p2_svt_lp L=6e-08 W=3.45e-07
MI1_MXNOE ny ns0 na VSS nm1p2_svt_lp L=6e-08 W=3.45e-07
MI1_MXNOE_2 ny ns0 na VSS nm1p2_svt_lp L=6e-08 W=3.45e-07
MI1_MXNOE_3 ny ns0 na VSS nm1p2_svt_lp L=6e-08 W=3.45e-07
MI3_MXNOE ny S0 nb VSS nm1p2_svt_lp L=6e-08 W=3.45e-07
MI3_MXNOE_2 ny S0 nb VSS nm1p2_svt_lp L=6e-08 W=3.45e-07
MI3_MXNOE_3 ny S0 nb VSS nm1p2_svt_lp L=6e-08 W=3.45e-07
MI2_MXNA1 nb B VSS VSS nm1p2_svt_lp L=6e-08 W=3.45e-07
MI2_MXNA1_2 nb B VSS VSS nm1p2_svt_lp L=6e-08 W=3.45e-07
MI2_MXNA1_3 nb B VSS VSS nm1p2_svt_lp L=6e-08 W=3.45e-07
MI4_MXNA1 Y ny VSS VSS nm1p2_svt_lp L=6e-08 W=4.2e-07
MI4_MXNA1_2 Y ny VSS VSS nm1p2_svt_lp L=6e-08 W=4.2e-07
MI4_MXNA1_3 Y ny VSS VSS nm1p2_svt_lp L=6e-08 W=4.2e-07
MI4_MXNA1_4 Y ny VSS VSS nm1p2_svt_lp L=6e-08 W=4.2e-07
MI5_MXPA1 ns0 S0 VDD VDD pm1p2_svt_lp L=6e-08 W=5.65e-07
MI5_MXPA1_2 ns0 S0 VDD VDD pm1p2_svt_lp L=6e-08 W=5.65e-07
MI0_MXPA1 na A VDD VDD pm1p2_svt_lp L=6e-08 W=4.8e-07
MI0_MXPA1_2 na A VDD VDD pm1p2_svt_lp L=6e-08 W=4.8e-07
MI0_MXPA1_3 na A VDD VDD pm1p2_svt_lp L=6e-08 W=4.8e-07
MI1_MXPOEN ny S0 na VDD pm1p2_svt_lp L=6e-08 W=3.45e-07
MI1_MXPOEN_2 ny S0 na VDD pm1p2_svt_lp L=6e-08 W=3.45e-07
MI1_MXPOEN_3 ny S0 na VDD pm1p2_svt_lp L=6e-08 W=3.45e-07
MI3_MXPOEN ny ns0 nb VDD pm1p2_svt_lp L=6e-08 W=3.45e-07
MI3_MXPOEN_2 ny ns0 nb VDD pm1p2_svt_lp L=6e-08 W=3.45e-07
MI3_MXPOEN_3 ny ns0 nb VDD pm1p2_svt_lp L=6e-08 W=3.45e-07
MI2_MXPA1 nb B VDD VDD pm1p2_svt_lp L=6e-08 W=4.8e-07
MI2_MXPA1_2 nb B VDD VDD pm1p2_svt_lp L=6e-08 W=4.8e-07
MI2_MXPA1_3 nb B VDD VDD pm1p2_svt_lp L=6e-08 W=4.8e-07
MI4_MXPA1 Y ny VDD VDD pm1p2_svt_lp L=6e-08 W=5.85e-07
MI4_MXPA1_2 Y ny VDD VDD pm1p2_svt_lp L=6e-08 W=5.85e-07
MI4_MXPA1_3 Y ny VDD VDD pm1p2_svt_lp L=6e-08 W=5.85e-07
MI4_MXPA1_4 Y ny VDD VDD pm1p2_svt_lp L=6e-08 W=5.85e-07
.ENDS

.SUBCKT MUXT2X6H9R Y VDD VSS A B S0
MI5_MXNA1 ns0 S0 VSS VSS nm1p2_svt_lp L=6e-08 W=4.6e-07
MI5_MXNA1_2 ns0 S0 VSS VSS nm1p2_svt_lp L=6e-08 W=4.6e-07
MI0_MXNA1 na A VSS VSS nm1p2_svt_lp L=6e-08 W=4.2e-07
MI0_MXNA1_2 na A VSS VSS nm1p2_svt_lp L=6e-08 W=4.2e-07
MI0_MXNA1_3 na A VSS VSS nm1p2_svt_lp L=6e-08 W=4.2e-07
MI1_MXNOE ny ns0 na VSS nm1p2_svt_lp L=6e-08 W=4.2e-07
MI1_MXNOE_2 ny ns0 na VSS nm1p2_svt_lp L=6e-08 W=4.2e-07
MI1_MXNOE_3 ny ns0 na VSS nm1p2_svt_lp L=6e-08 W=4.2e-07
MI3_MXNOE ny S0 nb VSS nm1p2_svt_lp L=6e-08 W=4.2e-07
MI3_MXNOE_2 ny S0 nb VSS nm1p2_svt_lp L=6e-08 W=4.2e-07
MI3_MXNOE_3 ny S0 nb VSS nm1p2_svt_lp L=6e-08 W=4.2e-07
MI2_MXNA1 nb B VSS VSS nm1p2_svt_lp L=6e-08 W=4.2e-07
MI2_MXNA1_2 nb B VSS VSS nm1p2_svt_lp L=6e-08 W=4.2e-07
MI2_MXNA1_3 nb B VSS VSS nm1p2_svt_lp L=6e-08 W=4.2e-07
MI4_MXNA1 Y ny VSS VSS nm1p2_svt_lp L=6e-08 W=4.2e-07
MI4_MXNA1_2 Y ny VSS VSS nm1p2_svt_lp L=6e-08 W=4.2e-07
MI4_MXNA1_3 Y ny VSS VSS nm1p2_svt_lp L=6e-08 W=4.2e-07
MI4_MXNA1_4 Y ny VSS VSS nm1p2_svt_lp L=6e-08 W=4.2e-07
MI4_MXNA1_5 Y ny VSS VSS nm1p2_svt_lp L=6e-08 W=4.2e-07
MI4_MXNA1_6 Y ny VSS VSS nm1p2_svt_lp L=6e-08 W=4.2e-07
MI5_MXPA1 ns0 S0 VDD VDD pm1p2_svt_lp L=6e-08 W=4.1e-07
MI5_MXPA1_2 ns0 S0 VDD VDD pm1p2_svt_lp L=6e-08 W=4.1e-07
MI5_MXPA1_3 ns0 S0 VDD VDD pm1p2_svt_lp L=6e-08 W=4.1e-07
MI0_MXPA1 na A VDD VDD pm1p2_svt_lp L=6e-08 W=5.85e-07
MI0_MXPA1_2 na A VDD VDD pm1p2_svt_lp L=6e-08 W=5.85e-07
MI0_MXPA1_3 na A VDD VDD pm1p2_svt_lp L=6e-08 W=5.85e-07
MI1_MXPOEN ny S0 na VDD pm1p2_svt_lp L=6e-08 W=4.2e-07
MI1_MXPOEN_2 ny S0 na VDD pm1p2_svt_lp L=6e-08 W=4.2e-07
MI1_MXPOEN_3 ny S0 na VDD pm1p2_svt_lp L=6e-08 W=4.2e-07
MI3_MXPOEN ny ns0 nb VDD pm1p2_svt_lp L=6e-08 W=4.2e-07
MI3_MXPOEN_2 ny ns0 nb VDD pm1p2_svt_lp L=6e-08 W=4.2e-07
MI3_MXPOEN_3 ny ns0 nb VDD pm1p2_svt_lp L=6e-08 W=4.2e-07
MI2_MXPA1 nb B VDD VDD pm1p2_svt_lp L=6e-08 W=5.85e-07
MI2_MXPA1_2 nb B VDD VDD pm1p2_svt_lp L=6e-08 W=5.85e-07
MI2_MXPA1_3 nb B VDD VDD pm1p2_svt_lp L=6e-08 W=5.85e-07
MI4_MXPA1 Y ny VDD VDD pm1p2_svt_lp L=6e-08 W=5.85e-07
MI4_MXPA1_2 Y ny VDD VDD pm1p2_svt_lp L=6e-08 W=5.85e-07
MI4_MXPA1_3 Y ny VDD VDD pm1p2_svt_lp L=6e-08 W=5.85e-07
MI4_MXPA1_4 Y ny VDD VDD pm1p2_svt_lp L=6e-08 W=5.85e-07
MI4_MXPA1_5 Y ny VDD VDD pm1p2_svt_lp L=6e-08 W=5.85e-07
MI4_MXPA1_6 Y ny VDD VDD pm1p2_svt_lp L=6e-08 W=5.85e-07
.ENDS

.SUBCKT MUXIT2X0P5H9R Y VDD VSS A B S0
MI4_MXNA1 ns0 S0 VSS VSS nm1p2_svt_lp L=6e-08 W=2.8e-07
MI2_MXNA1 nb B VSS VSS nm1p2_svt_lp L=6e-08 W=2.25e-07
MI3_MXNOE Y S0 nb VSS nm1p2_svt_lp L=6e-08 W=2.25e-07
MI1_MXNOE Y ns0 na VSS nm1p2_svt_lp L=6e-08 W=2.25e-07
MI0_MXNA1 na A VSS VSS nm1p2_svt_lp L=6e-08 W=2.25e-07
MI4_MXPA1 ns0 S0 VDD VDD pm1p2_svt_lp L=6e-08 W=3.9e-07
MI2_MXPA1 nb B VDD VDD pm1p2_svt_lp L=6e-08 W=3.15e-07
MI3_MXPOEN Y ns0 nb VDD pm1p2_svt_lp L=6e-08 W=2.25e-07
MI1_MXPOEN Y S0 na VDD pm1p2_svt_lp L=6e-08 W=2.25e-07
MI0_MXPA1 na A VDD VDD pm1p2_svt_lp L=6e-08 W=3.15e-07
.ENDS

.SUBCKT MUXIT2X0P7H9R Y VDD VSS A B S0
MI4_MXNA1 ns0 S0 VSS VSS nm1p2_svt_lp L=6e-08 W=3.4e-07
MI2_MXNA1 nb B VSS VSS nm1p2_svt_lp L=6e-08 W=3.15e-07
MI3_MXNOE Y S0 nb VSS nm1p2_svt_lp L=6e-08 W=3.15e-07
MI1_MXNOE Y ns0 na VSS nm1p2_svt_lp L=6e-08 W=3.15e-07
MI0_MXNA1 na A VSS VSS nm1p2_svt_lp L=6e-08 W=3.15e-07
MI4_MXPA1 ns0 S0 VDD VDD pm1p2_svt_lp L=6e-08 W=4.75e-07
MI2_MXPA1 nb B VDD VDD pm1p2_svt_lp L=6e-08 W=4.4e-07
MI3_MXPOEN Y ns0 nb VDD pm1p2_svt_lp L=6e-08 W=3.15e-07
MI1_MXPOEN Y S0 na VDD pm1p2_svt_lp L=6e-08 W=3.15e-07
MI0_MXPA1 na A VDD VDD pm1p2_svt_lp L=6e-08 W=4.4e-07
.ENDS

.SUBCKT MUXIT2X1H9R Y VDD VSS A B S0
MI4_MXNA1 ns0 S0 VSS VSS nm1p2_svt_lp L=6e-08 W=4.15e-07
MI2_MXNA1 nb B VSS VSS nm1p2_svt_lp L=6e-08 W=4.5e-07
MI3_MXNOE Y S0 nb VSS nm1p2_svt_lp L=6e-08 W=4.5e-07
MI1_MXNOE Y ns0 na VSS nm1p2_svt_lp L=6e-08 W=4.5e-07
MI0_MXNA1 na A VSS VSS nm1p2_svt_lp L=6e-08 W=4.5e-07
MI4_MXPA1 ns0 S0 VDD VDD pm1p2_svt_lp L=6e-08 W=5.85e-07
MI2_MXPA1 nb B VDD VDD pm1p2_svt_lp L=6e-08 W=5.85e-07
MI3_MXPOEN Y ns0 nb VDD pm1p2_svt_lp L=6e-08 W=4.5e-07
MI1_MXPOEN Y S0 na VDD pm1p2_svt_lp L=6e-08 W=4.5e-07
MI0_MXPA1 na A VDD VDD pm1p2_svt_lp L=6e-08 W=5.85e-07
.ENDS

.SUBCKT MUXIT2X1P4H9R Y VDD VSS A B S0
MI4_MXNA1 ns0 S0 VSS VSS nm1p2_svt_lp L=6e-08 W=2.7e-07
MI4_MXNA1_2 ns0 S0 VSS VSS nm1p2_svt_lp L=6e-08 W=2.7e-07
MI0_MXNA1 na A VSS VSS nm1p2_svt_lp L=6e-08 W=3.15e-07
MI0_MXNA1_2 na A VSS VSS nm1p2_svt_lp L=6e-08 W=3.15e-07
MI1_MXNOE Y ns0 na VSS nm1p2_svt_lp L=6e-08 W=3.15e-07
MI1_MXNOE_2 Y ns0 na VSS nm1p2_svt_lp L=6e-08 W=3.15e-07
MI3_MXNOE Y S0 nb VSS nm1p2_svt_lp L=6e-08 W=3.15e-07
MI3_MXNOE_2 Y S0 nb VSS nm1p2_svt_lp L=6e-08 W=3.15e-07
MI2_MXNA1 nb B VSS VSS nm1p2_svt_lp L=6e-08 W=3.15e-07
MI2_MXNA1_2 nb B VSS VSS nm1p2_svt_lp L=6e-08 W=3.15e-07
MI4_MXPA1 ns0 S0 VDD VDD pm1p2_svt_lp L=6e-08 W=3.75e-07
MI4_MXPA1_2 ns0 S0 VDD VDD pm1p2_svt_lp L=6e-08 W=3.75e-07
MI0_MXPA1 na A VDD VDD pm1p2_svt_lp L=6e-08 W=4.4e-07
MI0_MXPA1_2 na A VDD VDD pm1p2_svt_lp L=6e-08 W=4.4e-07
MI1_MXPOEN Y S0 na VDD pm1p2_svt_lp L=6e-08 W=3.15e-07
MI1_MXPOEN_2 Y S0 na VDD pm1p2_svt_lp L=6e-08 W=3.15e-07
MI3_MXPOEN Y ns0 nb VDD pm1p2_svt_lp L=6e-08 W=3.15e-07
MI3_MXPOEN_2 Y ns0 nb VDD pm1p2_svt_lp L=6e-08 W=3.15e-07
MI2_MXPA1 nb B VDD VDD pm1p2_svt_lp L=6e-08 W=4.4e-07
MI2_MXPA1_2 nb B VDD VDD pm1p2_svt_lp L=6e-08 W=4.4e-07
.ENDS

.SUBCKT MUXIT2X2H9R Y VDD VSS A B S0
MI4_MXNA1 ns0 S0 VSS VSS nm1p2_svt_lp L=6e-08 W=3.2e-07
MI4_MXNA1_2 ns0 S0 VSS VSS nm1p2_svt_lp L=6e-08 W=3.2e-07
MI0_MXNA1 na A VSS VSS nm1p2_svt_lp L=6e-08 W=4.4e-07
MI0_MXNA1_2 na A VSS VSS nm1p2_svt_lp L=6e-08 W=4.4e-07
MI1_MXNOE Y ns0 na VSS nm1p2_svt_lp L=6e-08 W=4.4e-07
MI1_MXNOE_2 Y ns0 na VSS nm1p2_svt_lp L=6e-08 W=4.4e-07
MI3_MXNOE Y S0 nb VSS nm1p2_svt_lp L=6e-08 W=4.4e-07
MI3_MXNOE_2 Y S0 nb VSS nm1p2_svt_lp L=6e-08 W=4.4e-07
MI2_MXNA1 nb B VSS VSS nm1p2_svt_lp L=6e-08 W=4.4e-07
MI2_MXNA1_2 nb B VSS VSS nm1p2_svt_lp L=6e-08 W=4.4e-07
MI4_MXPA1 ns0 S0 VDD VDD pm1p2_svt_lp L=6e-08 W=4.45e-07
MI4_MXPA1_2 ns0 S0 VDD VDD pm1p2_svt_lp L=6e-08 W=4.45e-07
MI0_MXPA1 na A VDD VDD pm1p2_svt_lp L=6e-08 W=5.85e-07
MI0_MXPA1_2 na A VDD VDD pm1p2_svt_lp L=6e-08 W=5.85e-07
MI1_MXPOEN Y S0 na VDD pm1p2_svt_lp L=6e-08 W=4.4e-07
MI1_MXPOEN_2 Y S0 na VDD pm1p2_svt_lp L=6e-08 W=4.4e-07
MI3_MXPOEN Y ns0 nb VDD pm1p2_svt_lp L=6e-08 W=4.4e-07
MI3_MXPOEN_2 Y ns0 nb VDD pm1p2_svt_lp L=6e-08 W=4.4e-07
MI2_MXPA1 nb B VDD VDD pm1p2_svt_lp L=6e-08 W=5.85e-07
MI2_MXPA1_2 nb B VDD VDD pm1p2_svt_lp L=6e-08 W=5.85e-07
.ENDS

.SUBCKT MUXIT2X3H9R Y VDD VSS A B S0
MI4_MXNA1 ns0 S0 VSS VSS nm1p2_svt_lp L=6e-08 W=4.15e-07
MI4_MXNA1_2 ns0 S0 VSS VSS nm1p2_svt_lp L=6e-08 W=4.15e-07
MI0_MXNA1 na A VSS VSS nm1p2_svt_lp L=6e-08 W=4.4e-07
MI0_MXNA1_2 na A VSS VSS nm1p2_svt_lp L=6e-08 W=4.4e-07
MI0_MXNA1_3 na A VSS VSS nm1p2_svt_lp L=6e-08 W=4.4e-07
MI1_MXNOE Y ns0 na VSS nm1p2_svt_lp L=6e-08 W=4.4e-07
MI1_MXNOE_2 Y ns0 na VSS nm1p2_svt_lp L=6e-08 W=4.4e-07
MI1_MXNOE_3 Y ns0 na VSS nm1p2_svt_lp L=6e-08 W=4.4e-07
MI3_MXNOE Y S0 nb VSS nm1p2_svt_lp L=6e-08 W=4.4e-07
MI3_MXNOE_2 Y S0 nb VSS nm1p2_svt_lp L=6e-08 W=4.4e-07
MI3_MXNOE_3 Y S0 nb VSS nm1p2_svt_lp L=6e-08 W=4.4e-07
MI2_MXNA1 nb B VSS VSS nm1p2_svt_lp L=6e-08 W=4.4e-07
MI2_MXNA1_2 nb B VSS VSS nm1p2_svt_lp L=6e-08 W=4.4e-07
MI2_MXNA1_3 nb B VSS VSS nm1p2_svt_lp L=6e-08 W=4.4e-07
MI4_MXPA1 ns0 S0 VDD VDD pm1p2_svt_lp L=6e-08 W=5.8e-07
MI4_MXPA1_2 ns0 S0 VDD VDD pm1p2_svt_lp L=6e-08 W=5.8e-07
MI0_MXPA1 na A VDD VDD pm1p2_svt_lp L=6e-08 W=5.85e-07
MI0_MXPA1_2 na A VDD VDD pm1p2_svt_lp L=6e-08 W=5.85e-07
MI0_MXPA1_3 na A VDD VDD pm1p2_svt_lp L=6e-08 W=5.85e-07
MI1_MXPOEN Y S0 na VDD pm1p2_svt_lp L=6e-08 W=4.4e-07
MI1_MXPOEN_2 Y S0 na VDD pm1p2_svt_lp L=6e-08 W=4.4e-07
MI1_MXPOEN_3 Y S0 na VDD pm1p2_svt_lp L=6e-08 W=4.4e-07
MI3_MXPOEN Y ns0 nb VDD pm1p2_svt_lp L=6e-08 W=4.4e-07
MI3_MXPOEN_2 Y ns0 nb VDD pm1p2_svt_lp L=6e-08 W=4.4e-07
MI3_MXPOEN_3 Y ns0 nb VDD pm1p2_svt_lp L=6e-08 W=4.4e-07
MI2_MXPA1 nb B VDD VDD pm1p2_svt_lp L=6e-08 W=5.85e-07
MI2_MXPA1_2 nb B VDD VDD pm1p2_svt_lp L=6e-08 W=5.85e-07
MI2_MXPA1_3 nb B VDD VDD pm1p2_svt_lp L=6e-08 W=5.85e-07
.ENDS

.SUBCKT MUXIT2X4H9R Y VDD VSS A B S0
MI4_MXNA1 ns0 S0 VSS VSS nm1p2_svt_lp L=6e-08 W=4.2e-07
MI4_MXNA1_2 ns0 S0 VSS VSS nm1p2_svt_lp L=6e-08 W=4.2e-07
MI0_MXNA1 na A VSS VSS nm1p2_svt_lp L=6e-08 W=4.4e-07
MI0_MXNA1_2 na A VSS VSS nm1p2_svt_lp L=6e-08 W=4.4e-07
MI0_MXNA1_3 na A VSS VSS nm1p2_svt_lp L=6e-08 W=4.4e-07
MI0_MXNA1_4 na A VSS VSS nm1p2_svt_lp L=6e-08 W=4.4e-07
MI1_MXNOE Y ns0 na VSS nm1p2_svt_lp L=6e-08 W=4.4e-07
MI1_MXNOE_2 Y ns0 na VSS nm1p2_svt_lp L=6e-08 W=4.4e-07
MI1_MXNOE_3 Y ns0 na VSS nm1p2_svt_lp L=6e-08 W=4.4e-07
MI1_MXNOE_4 Y ns0 na VSS nm1p2_svt_lp L=6e-08 W=4.4e-07
MI3_MXNOE Y S0 nb VSS nm1p2_svt_lp L=6e-08 W=4.4e-07
MI3_MXNOE_2 Y S0 nb VSS nm1p2_svt_lp L=6e-08 W=4.4e-07
MI3_MXNOE_3 Y S0 nb VSS nm1p2_svt_lp L=6e-08 W=4.4e-07
MI3_MXNOE_4 Y S0 nb VSS nm1p2_svt_lp L=6e-08 W=4.4e-07
MI2_MXNA1 nb B VSS VSS nm1p2_svt_lp L=6e-08 W=4.4e-07
MI2_MXNA1_2 nb B VSS VSS nm1p2_svt_lp L=6e-08 W=4.4e-07
MI2_MXNA1_3 nb B VSS VSS nm1p2_svt_lp L=6e-08 W=4.4e-07
MI2_MXNA1_4 nb B VSS VSS nm1p2_svt_lp L=6e-08 W=4.4e-07
MI4_MXPA1 ns0 S0 VDD VDD pm1p2_svt_lp L=6e-08 W=5.85e-07
MI4_MXPA1_2 ns0 S0 VDD VDD pm1p2_svt_lp L=6e-08 W=5.85e-07
MI0_MXPA1 na A VDD VDD pm1p2_svt_lp L=6e-08 W=5.85e-07
MI0_MXPA1_2 na A VDD VDD pm1p2_svt_lp L=6e-08 W=5.85e-07
MI0_MXPA1_3 na A VDD VDD pm1p2_svt_lp L=6e-08 W=5.85e-07
MI0_MXPA1_4 na A VDD VDD pm1p2_svt_lp L=6e-08 W=5.85e-07
MI1_MXPOEN Y S0 na VDD pm1p2_svt_lp L=6e-08 W=4.4e-07
MI1_MXPOEN_2 Y S0 na VDD pm1p2_svt_lp L=6e-08 W=4.4e-07
MI1_MXPOEN_3 Y S0 na VDD pm1p2_svt_lp L=6e-08 W=4.4e-07
MI1_MXPOEN_4 Y S0 na VDD pm1p2_svt_lp L=6e-08 W=4.4e-07
MI3_MXPOEN Y ns0 nb VDD pm1p2_svt_lp L=6e-08 W=4.4e-07
MI3_MXPOEN_2 Y ns0 nb VDD pm1p2_svt_lp L=6e-08 W=4.4e-07
MI3_MXPOEN_3 Y ns0 nb VDD pm1p2_svt_lp L=6e-08 W=4.4e-07
MI3_MXPOEN_4 Y ns0 nb VDD pm1p2_svt_lp L=6e-08 W=4.4e-07
MI2_MXPA1 nb B VDD VDD pm1p2_svt_lp L=6e-08 W=5.85e-07
MI2_MXPA1_2 nb B VDD VDD pm1p2_svt_lp L=6e-08 W=5.85e-07
MI2_MXPA1_3 nb B VDD VDD pm1p2_svt_lp L=6e-08 W=5.85e-07
MI2_MXPA1_4 nb B VDD VDD pm1p2_svt_lp L=6e-08 W=5.85e-07
.ENDS

.SUBCKT MUXT4X0P5H9R Y VDD VSS A B C D S0 S1
MI0_MXNA1 na A VSS VSS nm1p2_svt_lp L=6e-08 W=3.3e-07
MI1_MXNOE ab ns0 na VSS nm1p2_svt_lp L=6e-08 W=3.3e-07
MI3_MXNOE ab S0 nb VSS nm1p2_svt_lp L=6e-08 W=3.3e-07
MI2_MXNA1 nb B VSS VSS nm1p2_svt_lp L=6e-08 W=3.3e-07
MI11_MXNA1 ns0 S0 VSS VSS nm1p2_svt_lp L=6e-08 W=4.2e-07
MI6_MXNA1 nd D VSS VSS nm1p2_svt_lp L=6e-08 W=3.3e-07
MI7_MXNOE cd S0 nd VSS nm1p2_svt_lp L=6e-08 W=3.3e-07
MI5_MXNOE cd ns0 nc VSS nm1p2_svt_lp L=6e-08 W=3.3e-07
MI4_MXNA1 nc C VSS VSS nm1p2_svt_lp L=6e-08 W=3.3e-07
MI12_MXNA1 ns1 S1 VSS VSS nm1p2_svt_lp L=6e-08 W=2.6e-07
MI9_MXNOE ny S1 cd VSS nm1p2_svt_lp L=6e-08 W=3.3e-07
MI8_MXNOE ny ns1 ab VSS nm1p2_svt_lp L=6e-08 W=3.3e-07
MI10_MXNA1 Y ny VSS VSS nm1p2_svt_lp L=6e-08 W=2.1e-07
MI0_MXPA1 na A VDD VDD pm1p2_svt_lp L=6e-08 W=4.7e-07
MI1_MXPOEN ab S0 na VDD pm1p2_svt_lp L=6e-08 W=3.3e-07
MI3_MXPOEN ab ns0 nb VDD pm1p2_svt_lp L=6e-08 W=3.3e-07
MI2_MXPA1 nb B VDD VDD pm1p2_svt_lp L=6e-08 W=4.7e-07
MI11_MXPA1 ns0 S0 VDD VDD pm1p2_svt_lp L=6e-08 W=5.8e-07
MI6_MXPA1 nd D VDD VDD pm1p2_svt_lp L=6e-08 W=4.7e-07
MI7_MXPOEN cd ns0 nd VDD pm1p2_svt_lp L=6e-08 W=3.3e-07
MI5_MXPOEN cd S0 nc VDD pm1p2_svt_lp L=6e-08 W=3.3e-07
MI4_MXPA1 nc C VDD VDD pm1p2_svt_lp L=6e-08 W=4.7e-07
MI12_MXPA1 ns1 S1 VDD VDD pm1p2_svt_lp L=6e-08 W=3.6e-07
MI9_MXPOEN ny ns1 cd VDD pm1p2_svt_lp L=6e-08 W=3.3e-07
MI8_MXPOEN ny S1 ab VDD pm1p2_svt_lp L=6e-08 W=3.3e-07
MI10_MXPA1 Y ny VDD VDD pm1p2_svt_lp L=6e-08 W=2.95e-07
.ENDS

.SUBCKT MUXT4X0P7H9R Y VDD VSS A B C D S0 S1
MI0_MXNA1 na A VSS VSS nm1p2_svt_lp L=6e-08 W=3.9e-07
MI1_MXNOE ab ns0 na VSS nm1p2_svt_lp L=6e-08 W=3.9e-07
MI3_MXNOE ab S0 nb VSS nm1p2_svt_lp L=6e-08 W=3.9e-07
MI2_MXNA1 nb B VSS VSS nm1p2_svt_lp L=6e-08 W=3.9e-07
MI11_MXNA1 ns0 S0 VSS VSS nm1p2_svt_lp L=6e-08 W=4.2e-07
MI6_MXNA1 nd D VSS VSS nm1p2_svt_lp L=6e-08 W=3.9e-07
MI7_MXNOE cd S0 nd VSS nm1p2_svt_lp L=6e-08 W=3.9e-07
MI5_MXNOE cd ns0 nc VSS nm1p2_svt_lp L=6e-08 W=3.9e-07
MI4_MXNA1 nc C VSS VSS nm1p2_svt_lp L=6e-08 W=3.9e-07
MI12_MXNA1 ns1 S1 VSS VSS nm1p2_svt_lp L=6e-08 W=2.8e-07
MI9_MXNOE ny S1 cd VSS nm1p2_svt_lp L=6e-08 W=3.9e-07
MI8_MXNOE ny ns1 ab VSS nm1p2_svt_lp L=6e-08 W=3.9e-07
MI10_MXNA1 Y ny VSS VSS nm1p2_svt_lp L=6e-08 W=2.95e-07
MI0_MXPA1 na A VDD VDD pm1p2_svt_lp L=6e-08 W=5.5e-07
MI1_MXPOEN ab S0 na VDD pm1p2_svt_lp L=6e-08 W=3.9e-07
MI3_MXPOEN ab ns0 nb VDD pm1p2_svt_lp L=6e-08 W=3.9e-07
MI2_MXPA1 nb B VDD VDD pm1p2_svt_lp L=6e-08 W=5.5e-07
MI11_MXPA1 ns0 S0 VDD VDD pm1p2_svt_lp L=6e-08 W=5.8e-07
MI6_MXPA1 nd D VDD VDD pm1p2_svt_lp L=6e-08 W=5.5e-07
MI7_MXPOEN cd ns0 nd VDD pm1p2_svt_lp L=6e-08 W=3.9e-07
MI5_MXPOEN cd S0 nc VDD pm1p2_svt_lp L=6e-08 W=3.9e-07
MI4_MXPA1 nc C VDD VDD pm1p2_svt_lp L=6e-08 W=5.5e-07
MI12_MXPA1 ns1 S1 VDD VDD pm1p2_svt_lp L=6e-08 W=3.9e-07
MI9_MXPOEN ny ns1 cd VDD pm1p2_svt_lp L=6e-08 W=3.9e-07
MI8_MXPOEN ny S1 ab VDD pm1p2_svt_lp L=6e-08 W=3.9e-07
MI10_MXPA1 Y ny VDD VDD pm1p2_svt_lp L=6e-08 W=4.15e-07
.ENDS

.SUBCKT MUXT4X1H9R Y VDD VSS A B C D S0 S1
MI0_MXNA1 na A VSS VSS nm1p2_svt_lp L=6e-08 W=4.2e-07
MI1_MXNOE ab ns0 na VSS nm1p2_svt_lp L=6e-08 W=4.2e-07
MI3_MXNOE ab S0 nb VSS nm1p2_svt_lp L=6e-08 W=4.2e-07
MI2_MXNA1 nb B VSS VSS nm1p2_svt_lp L=6e-08 W=4.2e-07
MI11_MXNA1 ns0 S0 VSS VSS nm1p2_svt_lp L=6e-08 W=2.1e-07
MI11_MXNA1_2 ns0 S0 VSS VSS nm1p2_svt_lp L=6e-08 W=2.1e-07
MI6_MXNA1 nd D VSS VSS nm1p2_svt_lp L=6e-08 W=4.2e-07
MI7_MXNOE cd S0 nd VSS nm1p2_svt_lp L=6e-08 W=4.2e-07
MI5_MXNOE cd ns0 nc VSS nm1p2_svt_lp L=6e-08 W=4.2e-07
MI4_MXNA1 nc C VSS VSS nm1p2_svt_lp L=6e-08 W=4.2e-07
MI12_MXNA1 ns1 S1 VSS VSS nm1p2_svt_lp L=6e-08 W=3.4e-07
MI9_MXNOE ny S1 cd VSS nm1p2_svt_lp L=6e-08 W=2.1e-07
MI9_MXNOE_2 ny S1 cd VSS nm1p2_svt_lp L=6e-08 W=2.1e-07
MI8_MXNOE ny ns1 ab VSS nm1p2_svt_lp L=6e-08 W=4.2e-07
MI10_MXNA1 Y ny VSS VSS nm1p2_svt_lp L=6e-08 W=4.2e-07
MI0_MXPA1 na A VDD VDD pm1p2_svt_lp L=6e-08 W=5.85e-07
MI1_MXPOEN ab S0 na VDD pm1p2_svt_lp L=6e-08 W=4.2e-07
MI3_MXPOEN ab ns0 nb VDD pm1p2_svt_lp L=6e-08 W=4.2e-07
MI2_MXPA1 nb B VDD VDD pm1p2_svt_lp L=6e-08 W=5.85e-07
MI11_MXPA1 ns0 S0 VDD VDD pm1p2_svt_lp L=6e-08 W=5.85e-07
MI6_MXPA1 nd D VDD VDD pm1p2_svt_lp L=6e-08 W=5.85e-07
MI7_MXPOEN cd ns0 nd VDD pm1p2_svt_lp L=6e-08 W=4.2e-07
MI5_MXPOEN cd S0 nc VDD pm1p2_svt_lp L=6e-08 W=4.2e-07
MI4_MXPA1 nc C VDD VDD pm1p2_svt_lp L=6e-08 W=5.85e-07
MI12_MXPA1 ns1 S1 VDD VDD pm1p2_svt_lp L=6e-08 W=4.8e-07
MI9_MXPOEN ny ns1 cd VDD pm1p2_svt_lp L=6e-08 W=4.2e-07
MI8_MXPOEN ny S1 ab VDD pm1p2_svt_lp L=6e-08 W=4.2e-07
MI10_MXPA1 Y ny VDD VDD pm1p2_svt_lp L=6e-08 W=5.85e-07
.ENDS

.SUBCKT MUXT4X1P4H9R Y VDD VSS A B C D S0 S1
MI0_MXNA1 na A VSS VSS nm1p2_svt_lp L=6e-08 W=4.5e-07
MI1_MXNOE ab ns0 na VSS nm1p2_svt_lp L=6e-08 W=4.5e-07
MI3_MXNOE ab S0 nb VSS nm1p2_svt_lp L=6e-08 W=4.5e-07
MI2_MXNA1 nb B VSS VSS nm1p2_svt_lp L=6e-08 W=4.5e-07
MI11_MXNA1 ns0 S0 VSS VSS nm1p2_svt_lp L=6e-08 W=4.2e-07
MI6_MXNA1 nd D VSS VSS nm1p2_svt_lp L=6e-08 W=4.5e-07
MI7_MXNOE cd S0 nd VSS nm1p2_svt_lp L=6e-08 W=4.5e-07
MI5_MXNOE cd ns0 nc VSS nm1p2_svt_lp L=6e-08 W=4.5e-07
MI4_MXNA1 nc C VSS VSS nm1p2_svt_lp L=6e-08 W=4.5e-07
MI12_MXNA1 ns1 S1 VSS VSS nm1p2_svt_lp L=6e-08 W=3.6e-07
MI9_MXNOE ny S1 cd VSS nm1p2_svt_lp L=6e-08 W=2.25e-07
MI9_MXNOE_2 ny S1 cd VSS nm1p2_svt_lp L=6e-08 W=2.25e-07
MI8_MXNOE ny ns1 ab VSS nm1p2_svt_lp L=6e-08 W=4.5e-07
MI10_MXNA1 Y ny VSS VSS nm1p2_svt_lp L=6e-08 W=2.95e-07
MI10_MXNA1_2 Y ny VSS VSS nm1p2_svt_lp L=6e-08 W=2.95e-07
MI0_MXPA1 na A VDD VDD pm1p2_svt_lp L=6e-08 W=5.85e-07
MI1_MXPOEN ab S0 na VDD pm1p2_svt_lp L=6e-08 W=4.5e-07
MI3_MXPOEN ab ns0 nb VDD pm1p2_svt_lp L=6e-08 W=4.5e-07
MI2_MXPA1 nb B VDD VDD pm1p2_svt_lp L=6e-08 W=5.85e-07
MI11_MXPA1 ns0 S0 VDD VDD pm1p2_svt_lp L=6e-08 W=5.85e-07
MI6_MXPA1 nd D VDD VDD pm1p2_svt_lp L=6e-08 W=5.85e-07
MI7_MXPOEN cd ns0 nd VDD pm1p2_svt_lp L=6e-08 W=4.5e-07
MI5_MXPOEN cd S0 nc VDD pm1p2_svt_lp L=6e-08 W=4.5e-07
MI4_MXPA1 nc C VDD VDD pm1p2_svt_lp L=6e-08 W=5.85e-07
MI12_MXPA1 ns1 S1 VDD VDD pm1p2_svt_lp L=6e-08 W=5.1e-07
MI9_MXPOEN ny ns1 cd VDD pm1p2_svt_lp L=6e-08 W=4.5e-07
MI8_MXPOEN ny S1 ab VDD pm1p2_svt_lp L=6e-08 W=4.5e-07
MI10_MXPA1 Y ny VDD VDD pm1p2_svt_lp L=6e-08 W=4.15e-07
MI10_MXPA1_2 Y ny VDD VDD pm1p2_svt_lp L=6e-08 W=4.15e-07
.ENDS

.SUBCKT MUXT4X2H9R Y VDD VSS A B C D S0 S1
MI0_MXNA1 na A VSS VSS nm1p2_svt_lp L=6e-08 W=4.2e-07
MI0_MXNA1_2 na A VSS VSS nm1p2_svt_lp L=6e-08 W=4.2e-07
MI1_MXNOE ab ns0 na VSS nm1p2_svt_lp L=6e-08 W=4.2e-07
MI1_MXNOE_2 ab ns0 na VSS nm1p2_svt_lp L=6e-08 W=4.2e-07
MI3_MXNOE ab S0 nb VSS nm1p2_svt_lp L=6e-08 W=4.2e-07
MI3_MXNOE_2 ab S0 nb VSS nm1p2_svt_lp L=6e-08 W=4.2e-07
MI2_MXNA1 nb B VSS VSS nm1p2_svt_lp L=6e-08 W=4.2e-07
MI2_MXNA1_2 nb B VSS VSS nm1p2_svt_lp L=6e-08 W=4.2e-07
MI11_MXNA1 ns0 S0 VSS VSS nm1p2_svt_lp L=6e-08 W=4.2e-07
MI11_MXNA1_2 ns0 S0 VSS VSS nm1p2_svt_lp L=6e-08 W=4.2e-07
MI4_MXNA1 nc C VSS VSS nm1p2_svt_lp L=6e-08 W=4.2e-07
MI4_MXNA1_2 nc C VSS VSS nm1p2_svt_lp L=6e-08 W=4.2e-07
MI5_MXNOE cd ns0 nc VSS nm1p2_svt_lp L=6e-08 W=4.2e-07
MI5_MXNOE_2 cd ns0 nc VSS nm1p2_svt_lp L=6e-08 W=4.2e-07
MI7_MXNOE cd S0 nd VSS nm1p2_svt_lp L=6e-08 W=4.2e-07
MI7_MXNOE_2 cd S0 nd VSS nm1p2_svt_lp L=6e-08 W=4.2e-07
MI6_MXNA1 nd D VSS VSS nm1p2_svt_lp L=6e-08 W=4.2e-07
MI6_MXNA1_2 nd D VSS VSS nm1p2_svt_lp L=6e-08 W=4.2e-07
MI12_MXNA1 ns1 S1 VSS VSS nm1p2_svt_lp L=6e-08 W=4.8e-07
MI9_MXNOE ny S1 cd VSS nm1p2_svt_lp L=6e-08 W=4.2e-07
MI9_MXNOE_2 ny S1 cd VSS nm1p2_svt_lp L=6e-08 W=4.2e-07
MI8_MXNOE ny ns1 ab VSS nm1p2_svt_lp L=6e-08 W=4.2e-07
MI8_MXNOE_2 ny ns1 ab VSS nm1p2_svt_lp L=6e-08 W=4.2e-07
MI10_MXNA1 Y ny VSS VSS nm1p2_svt_lp L=6e-08 W=4.2e-07
MI10_MXNA1_2 Y ny VSS VSS nm1p2_svt_lp L=6e-08 W=4.2e-07
MI0_MXPA1 na A VDD VDD pm1p2_svt_lp L=6e-08 W=5.85e-07
MI0_MXPA1_2 na A VDD VDD pm1p2_svt_lp L=6e-08 W=5.85e-07
MI1_MXPOEN ab S0 na VDD pm1p2_svt_lp L=6e-08 W=4.2e-07
MI1_MXPOEN_2 ab S0 na VDD pm1p2_svt_lp L=6e-08 W=4.2e-07
MI3_MXPOEN ab ns0 nb VDD pm1p2_svt_lp L=6e-08 W=4.2e-07
MI3_MXPOEN_2 ab ns0 nb VDD pm1p2_svt_lp L=6e-08 W=4.2e-07
MI2_MXPA1 nb B VDD VDD pm1p2_svt_lp L=6e-08 W=5.85e-07
MI2_MXPA1_2 nb B VDD VDD pm1p2_svt_lp L=6e-08 W=5.85e-07
MI11_MXPA1 ns0 S0 VDD VDD pm1p2_svt_lp L=6e-08 W=5.85e-07
MI11_MXPA1_2 ns0 S0 VDD VDD pm1p2_svt_lp L=6e-08 W=5.85e-07
MI4_MXPA1 nc C VDD VDD pm1p2_svt_lp L=6e-08 W=5.85e-07
MI4_MXPA1_2 nc C VDD VDD pm1p2_svt_lp L=6e-08 W=5.85e-07
MI5_MXPOEN cd S0 nc VDD pm1p2_svt_lp L=6e-08 W=4.2e-07
MI5_MXPOEN_2 cd S0 nc VDD pm1p2_svt_lp L=6e-08 W=4.2e-07
MI7_MXPOEN cd ns0 nd VDD pm1p2_svt_lp L=6e-08 W=4.2e-07
MI7_MXPOEN_2 cd ns0 nd VDD pm1p2_svt_lp L=6e-08 W=4.2e-07
MI6_MXPA1 nd D VDD VDD pm1p2_svt_lp L=6e-08 W=5.85e-07
MI6_MXPA1_2 nd D VDD VDD pm1p2_svt_lp L=6e-08 W=5.85e-07
MI12_MXPA1 ns1 S1 VDD VDD pm1p2_svt_lp L=6e-08 W=3.4e-07
MI12_MXPA1_2 ns1 S1 VDD VDD pm1p2_svt_lp L=6e-08 W=3.4e-07
MI9_MXPOEN ny ns1 cd VDD pm1p2_svt_lp L=6e-08 W=4.2e-07
MI9_MXPOEN_2 ny ns1 cd VDD pm1p2_svt_lp L=6e-08 W=4.2e-07
MI8_MXPOEN ny S1 ab VDD pm1p2_svt_lp L=6e-08 W=4.2e-07
MI8_MXPOEN_2 ny S1 ab VDD pm1p2_svt_lp L=6e-08 W=4.2e-07
MI10_MXPA1 Y ny VDD VDD pm1p2_svt_lp L=6e-08 W=5.85e-07
MI10_MXPA1_2 Y ny VDD VDD pm1p2_svt_lp L=6e-08 W=5.85e-07
.ENDS

.SUBCKT MUXT4X3H9R Y VDD VSS A B C D S0 S1
MI0_MXNA1 na A VSS VSS nm1p2_svt_lp L=6e-08 W=4.2e-07
MI0_MXNA1_2 na A VSS VSS nm1p2_svt_lp L=6e-08 W=4.2e-07
MI1_MXNOE ab ns0 na VSS nm1p2_svt_lp L=6e-08 W=4.2e-07
MI1_MXNOE_2 ab ns0 na VSS nm1p2_svt_lp L=6e-08 W=4.2e-07
MI3_MXNOE ab S0 nb VSS nm1p2_svt_lp L=6e-08 W=4.2e-07
MI3_MXNOE_2 ab S0 nb VSS nm1p2_svt_lp L=6e-08 W=4.2e-07
MI2_MXNA1 nb B VSS VSS nm1p2_svt_lp L=6e-08 W=4.2e-07
MI2_MXNA1_2 nb B VSS VSS nm1p2_svt_lp L=6e-08 W=4.2e-07
MI11_MXNA1 ns0 S0 VSS VSS nm1p2_svt_lp L=6e-08 W=4.2e-07
MI11_MXNA1_2 ns0 S0 VSS VSS nm1p2_svt_lp L=6e-08 W=4.2e-07
MI4_MXNA1 nc C VSS VSS nm1p2_svt_lp L=6e-08 W=4.2e-07
MI4_MXNA1_2 nc C VSS VSS nm1p2_svt_lp L=6e-08 W=4.2e-07
MI5_MXNOE cd ns0 nc VSS nm1p2_svt_lp L=6e-08 W=4.2e-07
MI5_MXNOE_2 cd ns0 nc VSS nm1p2_svt_lp L=6e-08 W=4.2e-07
MI7_MXNOE cd S0 nd VSS nm1p2_svt_lp L=6e-08 W=4.2e-07
MI7_MXNOE_2 cd S0 nd VSS nm1p2_svt_lp L=6e-08 W=4.2e-07
MI6_MXNA1 nd D VSS VSS nm1p2_svt_lp L=6e-08 W=4.2e-07
MI6_MXNA1_2 nd D VSS VSS nm1p2_svt_lp L=6e-08 W=4.2e-07
MI12_MXNA1 ns1 S1 VSS VSS nm1p2_svt_lp L=6e-08 W=3.55e-07
MI12_MXNA1_2 ns1 S1 VSS VSS nm1p2_svt_lp L=6e-08 W=3.55e-07
MI9_MXNOE ny S1 cd VSS nm1p2_svt_lp L=6e-08 W=4.2e-07
MI9_MXNOE_2 ny S1 cd VSS nm1p2_svt_lp L=6e-08 W=4.2e-07
MI8_MXNOE ny ns1 ab VSS nm1p2_svt_lp L=6e-08 W=4.2e-07
MI8_MXNOE_2 ny ns1 ab VSS nm1p2_svt_lp L=6e-08 W=4.2e-07
MI10_MXNA1 Y ny VSS VSS nm1p2_svt_lp L=6e-08 W=4.2e-07
MI10_MXNA1_2 Y ny VSS VSS nm1p2_svt_lp L=6e-08 W=4.2e-07
MI10_MXNA1_3 Y ny VSS VSS nm1p2_svt_lp L=6e-08 W=4.2e-07
MI0_MXPA1 na A VDD VDD pm1p2_svt_lp L=6e-08 W=5.85e-07
MI0_MXPA1_2 na A VDD VDD pm1p2_svt_lp L=6e-08 W=5.85e-07
MI1_MXPOEN ab S0 na VDD pm1p2_svt_lp L=6e-08 W=4.2e-07
MI1_MXPOEN_2 ab S0 na VDD pm1p2_svt_lp L=6e-08 W=4.2e-07
MI3_MXPOEN ab ns0 nb VDD pm1p2_svt_lp L=6e-08 W=4.2e-07
MI3_MXPOEN_2 ab ns0 nb VDD pm1p2_svt_lp L=6e-08 W=4.2e-07
MI2_MXPA1 nb B VDD VDD pm1p2_svt_lp L=6e-08 W=5.85e-07
MI2_MXPA1_2 nb B VDD VDD pm1p2_svt_lp L=6e-08 W=5.85e-07
MI11_MXPA1 ns0 S0 VDD VDD pm1p2_svt_lp L=6e-08 W=5.85e-07
MI11_MXPA1_2 ns0 S0 VDD VDD pm1p2_svt_lp L=6e-08 W=5.85e-07
MI4_MXPA1 nc C VDD VDD pm1p2_svt_lp L=6e-08 W=5.85e-07
MI4_MXPA1_2 nc C VDD VDD pm1p2_svt_lp L=6e-08 W=5.85e-07
MI5_MXPOEN cd S0 nc VDD pm1p2_svt_lp L=6e-08 W=4.2e-07
MI5_MXPOEN_2 cd S0 nc VDD pm1p2_svt_lp L=6e-08 W=4.2e-07
MI7_MXPOEN cd ns0 nd VDD pm1p2_svt_lp L=6e-08 W=4.2e-07
MI7_MXPOEN_2 cd ns0 nd VDD pm1p2_svt_lp L=6e-08 W=4.2e-07
MI6_MXPA1 nd D VDD VDD pm1p2_svt_lp L=6e-08 W=5.85e-07
MI6_MXPA1_2 nd D VDD VDD pm1p2_svt_lp L=6e-08 W=5.85e-07
MI12_MXPA1 ns1 S1 VDD VDD pm1p2_svt_lp L=6e-08 W=4.95e-07
MI12_MXPA1_2 ns1 S1 VDD VDD pm1p2_svt_lp L=6e-08 W=4.95e-07
MI9_MXPOEN ny ns1 cd VDD pm1p2_svt_lp L=6e-08 W=4.2e-07
MI9_MXPOEN_2 ny ns1 cd VDD pm1p2_svt_lp L=6e-08 W=4.2e-07
MI8_MXPOEN ny S1 ab VDD pm1p2_svt_lp L=6e-08 W=4.2e-07
MI8_MXPOEN_2 ny S1 ab VDD pm1p2_svt_lp L=6e-08 W=4.2e-07
MI10_MXPA1 Y ny VDD VDD pm1p2_svt_lp L=6e-08 W=5.85e-07
MI10_MXPA1_2 Y ny VDD VDD pm1p2_svt_lp L=6e-08 W=5.85e-07
MI10_MXPA1_3 Y ny VDD VDD pm1p2_svt_lp L=6e-08 W=5.85e-07
.ENDS

.SUBCKT MUXIT4X0P5H9R Y VDD VSS A B C D S0 S1
MI13_MXNA1 ns0 S0 VSS VSS nm1p2_svt_lp L=6e-08 W=4.2e-07
MI10_MXNA1 nd D VSS VSS nm1p2_svt_lp L=6e-08 W=1.7e-07
MI11_MXNOE ncnd S0 nd VSS nm1p2_svt_lp L=6e-08 W=1.7e-07
MI7_MXNOE ncnd ns0 nc VSS nm1p2_svt_lp L=6e-08 W=1.7e-07
MI6_MXNA1 nc C VSS VSS nm1p2_svt_lp L=6e-08 W=1.7e-07
MI2_MXNA1 nb B VSS VSS nm1p2_svt_lp L=6e-08 W=1.7e-07
MI3_MXNOE nanb S0 nb VSS nm1p2_svt_lp L=6e-08 W=1.7e-07
MI1_MXNOE nanb ns0 na VSS nm1p2_svt_lp L=6e-08 W=1.7e-07
MI0_MXNA1 na A VSS VSS nm1p2_svt_lp L=6e-08 W=1.7e-07
MI14_MXNA1 ns1 S1 VSS VSS nm1p2_svt_lp L=6e-08 W=2.5e-07
MI8_MXNA1 cd ncnd VSS VSS nm1p2_svt_lp L=6e-08 W=1.7e-07
MI9_MXNOE ny S1 cd VSS nm1p2_svt_lp L=6e-08 W=1.7e-07
MI5_MXNOE ny ns1 ab VSS nm1p2_svt_lp L=6e-08 W=1.7e-07
MI4_MXNA1 ab nanb VSS VSS nm1p2_svt_lp L=6e-08 W=1.7e-07
MI12_MXNA1 Y ny VSS VSS nm1p2_svt_lp L=6e-08 W=2.1e-07
MI13_MXPA1 ns0 S0 VDD VDD pm1p2_svt_lp L=6e-08 W=5.85e-07
MI10_MXPA1 nd D VDD VDD pm1p2_svt_lp L=6e-08 W=2.5e-07
MI11_MXPOEN ncnd ns0 nd VDD pm1p2_svt_lp L=6e-08 W=1.7e-07
MI7_MXPOEN ncnd S0 nc VDD pm1p2_svt_lp L=6e-08 W=1.7e-07
MI6_MXPA1 nc C VDD VDD pm1p2_svt_lp L=6e-08 W=2.5e-07
MI2_MXPA1 nb B VDD VDD pm1p2_svt_lp L=6e-08 W=2.5e-07
MI3_MXPOEN nanb ns0 nb VDD pm1p2_svt_lp L=6e-08 W=1.7e-07
MI1_MXPOEN nanb S0 na VDD pm1p2_svt_lp L=6e-08 W=1.7e-07
MI0_MXPA1 na A VDD VDD pm1p2_svt_lp L=6e-08 W=2.5e-07
MI14_MXPA1 ns1 S1 VDD VDD pm1p2_svt_lp L=6e-08 W=3.6e-07
MI8_MXPA1 cd ncnd VDD VDD pm1p2_svt_lp L=6e-08 W=2.5e-07
MI9_MXPOEN ny ns1 cd VDD pm1p2_svt_lp L=6e-08 W=1.7e-07
MI5_MXPOEN ny S1 ab VDD pm1p2_svt_lp L=6e-08 W=1.7e-07
MI4_MXPA1 ab nanb VDD VDD pm1p2_svt_lp L=6e-08 W=2.5e-07
MI12_MXPA1 Y ny VDD VDD pm1p2_svt_lp L=6e-08 W=2.95e-07
.ENDS

.SUBCKT MUXIT4X0P7H9R Y VDD VSS A B C D S0 S1
MI13_MXNA1 ns0 S0 VSS VSS nm1p2_svt_lp L=6e-08 W=4.2e-07
MI10_MXNA1 nd D VSS VSS nm1p2_svt_lp L=6e-08 W=2e-07
MI11_MXNOE ncnd S0 nd VSS nm1p2_svt_lp L=6e-08 W=2e-07
MI7_MXNOE ncnd ns0 nc VSS nm1p2_svt_lp L=6e-08 W=2e-07
MI6_MXNA1 nc C VSS VSS nm1p2_svt_lp L=6e-08 W=2e-07
MI2_MXNA1 nb B VSS VSS nm1p2_svt_lp L=6e-08 W=2e-07
MI3_MXNOE nanb S0 nb VSS nm1p2_svt_lp L=6e-08 W=2e-07
MI1_MXNOE nanb ns0 na VSS nm1p2_svt_lp L=6e-08 W=2e-07
MI0_MXNA1 na A VSS VSS nm1p2_svt_lp L=6e-08 W=2e-07
MI14_MXNA1 ns1 S1 VSS VSS nm1p2_svt_lp L=6e-08 W=2.7e-07
MI8_MXNA1 cd ncnd VSS VSS nm1p2_svt_lp L=6e-08 W=2e-07
MI9_MXNOE ny S1 cd VSS nm1p2_svt_lp L=6e-08 W=2e-07
MI5_MXNOE ny ns1 ab VSS nm1p2_svt_lp L=6e-08 W=2e-07
MI4_MXNA1 ab nanb VSS VSS nm1p2_svt_lp L=6e-08 W=2e-07
MI12_MXNA1 Y ny VSS VSS nm1p2_svt_lp L=6e-08 W=2.95e-07
MI13_MXPA1 ns0 S0 VDD VDD pm1p2_svt_lp L=6e-08 W=5.85e-07
MI10_MXPA1 nd D VDD VDD pm1p2_svt_lp L=6e-08 W=2.85e-07
MI11_MXPOEN ncnd ns0 nd VDD pm1p2_svt_lp L=6e-08 W=2e-07
MI7_MXPOEN ncnd S0 nc VDD pm1p2_svt_lp L=6e-08 W=2e-07
MI6_MXPA1 nc C VDD VDD pm1p2_svt_lp L=6e-08 W=2.85e-07
MI2_MXPA1 nb B VDD VDD pm1p2_svt_lp L=6e-08 W=2.85e-07
MI3_MXPOEN nanb ns0 nb VDD pm1p2_svt_lp L=6e-08 W=2e-07
MI1_MXPOEN nanb S0 na VDD pm1p2_svt_lp L=6e-08 W=2e-07
MI0_MXPA1 na A VDD VDD pm1p2_svt_lp L=6e-08 W=2.85e-07
MI14_MXPA1 ns1 S1 VDD VDD pm1p2_svt_lp L=6e-08 W=3.8e-07
MI8_MXPA1 cd ncnd VDD VDD pm1p2_svt_lp L=6e-08 W=2.85e-07
MI9_MXPOEN ny ns1 cd VDD pm1p2_svt_lp L=6e-08 W=2e-07
MI5_MXPOEN ny S1 ab VDD pm1p2_svt_lp L=6e-08 W=2e-07
MI4_MXPA1 ab nanb VDD VDD pm1p2_svt_lp L=6e-08 W=2.85e-07
MI12_MXPA1 Y ny VDD VDD pm1p2_svt_lp L=6e-08 W=4.15e-07
.ENDS

.SUBCKT MUXIT4X1H9R Y VDD VSS A B C D S0 S1
MI0_MXNA1 na A VSS VSS nm1p2_svt_lp L=6e-08 W=2.6e-07
MI1_MXNOE nanb ns0 na VSS nm1p2_svt_lp L=6e-08 W=2.6e-07
MI3_MXNOE nanb S0 nb VSS nm1p2_svt_lp L=6e-08 W=2.6e-07
MI2_MXNA1 nb B VSS VSS nm1p2_svt_lp L=6e-08 W=2.6e-07
MI13_MXNA1 ns0 S0 VSS VSS nm1p2_svt_lp L=6e-08 W=4.2e-07
MI10_MXNA1 nd D VSS VSS nm1p2_svt_lp L=6e-08 W=2.6e-07
MI11_MXNOE ncnd S0 nd VSS nm1p2_svt_lp L=6e-08 W=2.6e-07
MI7_MXNOE ncnd ns0 nc VSS nm1p2_svt_lp L=6e-08 W=2.6e-07
MI6_MXNA1 nc C VSS VSS nm1p2_svt_lp L=6e-08 W=2.6e-07
MI14_MXNA1 ns1 S1 VSS VSS nm1p2_svt_lp L=6e-08 W=3e-07
MI8_MXNA1 cd ncnd VSS VSS nm1p2_svt_lp L=6e-08 W=2.6e-07
MI9_MXNOE ny S1 cd VSS nm1p2_svt_lp L=6e-08 W=2.6e-07
MI5_MXNOE ny ns1 ab VSS nm1p2_svt_lp L=6e-08 W=2.6e-07
MI4_MXNA1 ab nanb VSS VSS nm1p2_svt_lp L=6e-08 W=2.6e-07
MI12_MXNA1 Y ny VSS VSS nm1p2_svt_lp L=6e-08 W=4.2e-07
MI0_MXPA1 na A VDD VDD pm1p2_svt_lp L=6e-08 W=4e-07
MI1_MXPOEN nanb S0 na VDD pm1p2_svt_lp L=6e-08 W=2.6e-07
MI3_MXPOEN nanb ns0 nb VDD pm1p2_svt_lp L=6e-08 W=2.6e-07
MI2_MXPA1 nb B VDD VDD pm1p2_svt_lp L=6e-08 W=4e-07
MI13_MXPA1 ns0 S0 VDD VDD pm1p2_svt_lp L=6e-08 W=5.85e-07
MI10_MXPA1 nd D VDD VDD pm1p2_svt_lp L=6e-08 W=4e-07
MI11_MXPOEN ncnd ns0 nd VDD pm1p2_svt_lp L=6e-08 W=2.6e-07
MI7_MXPOEN ncnd S0 nc VDD pm1p2_svt_lp L=6e-08 W=2.6e-07
MI6_MXPA1 nc C VDD VDD pm1p2_svt_lp L=6e-08 W=4e-07
MI14_MXPA1 ns1 S1 VDD VDD pm1p2_svt_lp L=6e-08 W=4.2e-07
MI8_MXPA1 cd ncnd VDD VDD pm1p2_svt_lp L=6e-08 W=3.65e-07
MI9_MXPOEN ny ns1 cd VDD pm1p2_svt_lp L=6e-08 W=2.6e-07
MI5_MXPOEN ny S1 ab VDD pm1p2_svt_lp L=6e-08 W=2.6e-07
MI4_MXPA1 ab nanb VDD VDD pm1p2_svt_lp L=6e-08 W=3.65e-07
MI12_MXPA1 Y ny VDD VDD pm1p2_svt_lp L=6e-08 W=5.85e-07
.ENDS

.SUBCKT MUXIT4X1P4H9R Y VDD VSS A B C D S0 S1
MI0_MXNA1 na A VSS VSS nm1p2_svt_lp L=6e-08 W=3.3e-07
MI1_MXNOE nanb ns0 na VSS nm1p2_svt_lp L=6e-08 W=3.3e-07
MI3_MXNOE nanb S0 nb VSS nm1p2_svt_lp L=6e-08 W=3.3e-07
MI2_MXNA1 nb B VSS VSS nm1p2_svt_lp L=6e-08 W=3.3e-07
MI13_MXNA1 ns0 S0 VSS VSS nm1p2_svt_lp L=6e-08 W=3.1e-07
MI13_MXNA1_2 ns0 S0 VSS VSS nm1p2_svt_lp L=6e-08 W=3.1e-07
MI10_MXNA1 nd D VSS VSS nm1p2_svt_lp L=6e-08 W=3.3e-07
MI11_MXNOE ncnd S0 nd VSS nm1p2_svt_lp L=6e-08 W=3.3e-07
MI7_MXNOE ncnd ns0 nc VSS nm1p2_svt_lp L=6e-08 W=3.3e-07
MI6_MXNA1 nc C VSS VSS nm1p2_svt_lp L=6e-08 W=3.3e-07
MI14_MXNA1 ns1 S1 VSS VSS nm1p2_svt_lp L=6e-08 W=3.35e-07
MI8_MXNA1 cd ncnd VSS VSS nm1p2_svt_lp L=6e-08 W=3.3e-07
MI9_MXNOE ny S1 cd VSS nm1p2_svt_lp L=6e-08 W=3.3e-07
MI5_MXNOE ny ns1 ab VSS nm1p2_svt_lp L=6e-08 W=3.3e-07
MI4_MXNA1 ab nanb VSS VSS nm1p2_svt_lp L=6e-08 W=3.3e-07
MI12_MXNA1 Y ny VSS VSS nm1p2_svt_lp L=6e-08 W=2.95e-07
MI12_MXNA1_2 Y ny VSS VSS nm1p2_svt_lp L=6e-08 W=2.95e-07
MI0_MXPA1 na A VDD VDD pm1p2_svt_lp L=6e-08 W=5e-07
MI1_MXPOEN nanb S0 na VDD pm1p2_svt_lp L=6e-08 W=3.3e-07
MI3_MXPOEN nanb ns0 nb VDD pm1p2_svt_lp L=6e-08 W=3.3e-07
MI2_MXPA1 nb B VDD VDD pm1p2_svt_lp L=6e-08 W=5e-07
MI13_MXPA1 ns0 S0 VDD VDD pm1p2_svt_lp L=6e-08 W=4.3e-07
MI13_MXPA1_2 ns0 S0 VDD VDD pm1p2_svt_lp L=6e-08 W=4.3e-07
MI10_MXPA1 nd D VDD VDD pm1p2_svt_lp L=6e-08 W=5e-07
MI11_MXPOEN ncnd ns0 nd VDD pm1p2_svt_lp L=6e-08 W=3.3e-07
MI7_MXPOEN ncnd S0 nc VDD pm1p2_svt_lp L=6e-08 W=3.3e-07
MI6_MXPA1 nc C VDD VDD pm1p2_svt_lp L=6e-08 W=5e-07
MI14_MXPA1 ns1 S1 VDD VDD pm1p2_svt_lp L=6e-08 W=4.7e-07
MI8_MXPA1 cd ncnd VDD VDD pm1p2_svt_lp L=6e-08 W=4.6e-07
MI9_MXPOEN ny ns1 cd VDD pm1p2_svt_lp L=6e-08 W=3.3e-07
MI5_MXPOEN ny S1 ab VDD pm1p2_svt_lp L=6e-08 W=3.3e-07
MI4_MXPA1 ab nanb VDD VDD pm1p2_svt_lp L=6e-08 W=4.6e-07
MI12_MXPA1 Y ny VDD VDD pm1p2_svt_lp L=6e-08 W=4.15e-07
MI12_MXPA1_2 Y ny VDD VDD pm1p2_svt_lp L=6e-08 W=4.15e-07
.ENDS

.SUBCKT MUXIT4X2H9R Y VDD VSS A B C D S0 S1
MI0_MXNA1 na A VSS VSS nm1p2_svt_lp L=6e-08 W=4.2e-07
MI1_MXNOE nanb ns0 na VSS nm1p2_svt_lp L=6e-08 W=4.2e-07
MI3_MXNOE nanb S0 nb VSS nm1p2_svt_lp L=6e-08 W=4.2e-07
MI2_MXNA1 nb B VSS VSS nm1p2_svt_lp L=6e-08 W=4.2e-07
MI13_MXNA1 ns0 S0 VSS VSS nm1p2_svt_lp L=6e-08 W=3.55e-07
MI13_MXNA1_2 ns0 S0 VSS VSS nm1p2_svt_lp L=6e-08 W=3.55e-07
MI10_MXNA1 nd D VSS VSS nm1p2_svt_lp L=6e-08 W=4.2e-07
MI11_MXNOE ncnd S0 nd VSS nm1p2_svt_lp L=6e-08 W=4.2e-07
MI7_MXNOE ncnd ns0 nc VSS nm1p2_svt_lp L=6e-08 W=4.2e-07
MI6_MXNA1 nc C VSS VSS nm1p2_svt_lp L=6e-08 W=4.2e-07
MI14_MXNA1 ns1 S1 VSS VSS nm1p2_svt_lp L=6e-08 W=3.8e-07
MI8_MXNA1 cd ncnd VSS VSS nm1p2_svt_lp L=6e-08 W=4.2e-07
MI9_MXNOE ny S1 cd VSS nm1p2_svt_lp L=6e-08 W=4.2e-07
MI5_MXNOE ny ns1 ab VSS nm1p2_svt_lp L=6e-08 W=4.2e-07
MI4_MXNA1 ab nanb VSS VSS nm1p2_svt_lp L=6e-08 W=4.2e-07
MI12_MXNA1 Y ny VSS VSS nm1p2_svt_lp L=6e-08 W=4.2e-07
MI12_MXNA1_2 Y ny VSS VSS nm1p2_svt_lp L=6e-08 W=4.2e-07
MI0_MXPA1 na A VDD VDD pm1p2_svt_lp L=6e-08 W=5.85e-07
MI1_MXPOEN nanb S0 na VDD pm1p2_svt_lp L=6e-08 W=4.2e-07
MI3_MXPOEN nanb ns0 nb VDD pm1p2_svt_lp L=6e-08 W=4.2e-07
MI2_MXPA1 nb B VDD VDD pm1p2_svt_lp L=6e-08 W=5.85e-07
MI13_MXPA1 ns0 S0 VDD VDD pm1p2_svt_lp L=6e-08 W=4.95e-07
MI13_MXPA1_2 ns0 S0 VDD VDD pm1p2_svt_lp L=6e-08 W=4.95e-07
MI10_MXPA1 nd D VDD VDD pm1p2_svt_lp L=6e-08 W=5.85e-07
MI11_MXPOEN ncnd ns0 nd VDD pm1p2_svt_lp L=6e-08 W=4.2e-07
MI7_MXPOEN ncnd S0 nc VDD pm1p2_svt_lp L=6e-08 W=4.2e-07
MI6_MXPA1 nc C VDD VDD pm1p2_svt_lp L=6e-08 W=5.85e-07
MI14_MXPA1 ns1 S1 VDD VDD pm1p2_svt_lp L=6e-08 W=5.35e-07
MI8_MXPA1 cd ncnd VDD VDD pm1p2_svt_lp L=6e-08 W=5.85e-07
MI9_MXPOEN ny ns1 cd VDD pm1p2_svt_lp L=6e-08 W=4.2e-07
MI5_MXPOEN ny S1 ab VDD pm1p2_svt_lp L=6e-08 W=4.2e-07
MI4_MXPA1 ab nanb VDD VDD pm1p2_svt_lp L=6e-08 W=5.85e-07
MI12_MXPA1 Y ny VDD VDD pm1p2_svt_lp L=6e-08 W=5.85e-07
MI12_MXPA1_2 Y ny VDD VDD pm1p2_svt_lp L=6e-08 W=5.85e-07
.ENDS

.SUBCKT MUXIT4X3H9R Y VDD VSS A B C D S0 S1
MI0_MXNA1 na A VSS VSS nm1p2_svt_lp L=6e-08 W=3e-07
MI0_MXNA1_2 na A VSS VSS nm1p2_svt_lp L=6e-08 W=3e-07
MI1_MXNOE nanb ns0 na VSS nm1p2_svt_lp L=6e-08 W=3e-07
MI1_MXNOE_2 nanb ns0 na VSS nm1p2_svt_lp L=6e-08 W=3e-07
MI3_MXNOE nanb S0 nb VSS nm1p2_svt_lp L=6e-08 W=3e-07
MI3_MXNOE_2 nanb S0 nb VSS nm1p2_svt_lp L=6e-08 W=3e-07
MI2_MXNA1 nb B VSS VSS nm1p2_svt_lp L=6e-08 W=3e-07
MI2_MXNA1_2 nb B VSS VSS nm1p2_svt_lp L=6e-08 W=3e-07
MI13_MXNA1 ns0 S0 VSS VSS nm1p2_svt_lp L=6e-08 W=4.15e-07
MI13_MXNA1_2 ns0 S0 VSS VSS nm1p2_svt_lp L=6e-08 W=4.15e-07
MI6_MXNA1 nc C VSS VSS nm1p2_svt_lp L=6e-08 W=3e-07
MI6_MXNA1_2 nc C VSS VSS nm1p2_svt_lp L=6e-08 W=3e-07
MI7_MXNOE ncnd ns0 nc VSS nm1p2_svt_lp L=6e-08 W=3e-07
MI7_MXNOE_2 ncnd ns0 nc VSS nm1p2_svt_lp L=6e-08 W=3e-07
MI11_MXNOE ncnd S0 nd VSS nm1p2_svt_lp L=6e-08 W=3e-07
MI11_MXNOE_2 ncnd S0 nd VSS nm1p2_svt_lp L=6e-08 W=3e-07
MI10_MXNA1 nd D VSS VSS nm1p2_svt_lp L=6e-08 W=3e-07
MI10_MXNA1_2 nd D VSS VSS nm1p2_svt_lp L=6e-08 W=3e-07
MI8_MXNA1 cd ncnd VSS VSS nm1p2_svt_lp L=6e-08 W=3e-07
MI8_MXNA1_2 cd ncnd VSS VSS nm1p2_svt_lp L=6e-08 W=3e-07
MI14_MXNA1 ns1 S1 VSS VSS nm1p2_svt_lp L=6e-08 W=4.6e-07
MI9_MXNOE ny S1 cd VSS nm1p2_svt_lp L=6e-08 W=3e-07
MI9_MXNOE_2 ny S1 cd VSS nm1p2_svt_lp L=6e-08 W=3e-07
MI5_MXNOE ny ns1 ab VSS nm1p2_svt_lp L=6e-08 W=3e-07
MI5_MXNOE_2 ny ns1 ab VSS nm1p2_svt_lp L=6e-08 W=3e-07
MI4_MXNA1 ab nanb VSS VSS nm1p2_svt_lp L=6e-08 W=3e-07
MI4_MXNA1_2 ab nanb VSS VSS nm1p2_svt_lp L=6e-08 W=3e-07
MI12_MXNA1 Y ny VSS VSS nm1p2_svt_lp L=6e-08 W=4.2e-07
MI12_MXNA1_2 Y ny VSS VSS nm1p2_svt_lp L=6e-08 W=4.2e-07
MI12_MXNA1_3 Y ny VSS VSS nm1p2_svt_lp L=6e-08 W=4.2e-07
MI0_MXPA1 na A VDD VDD pm1p2_svt_lp L=6e-08 W=4.5e-07
MI0_MXPA1_2 na A VDD VDD pm1p2_svt_lp L=6e-08 W=4.5e-07
MI1_MXPOEN nanb S0 na VDD pm1p2_svt_lp L=6e-08 W=3e-07
MI1_MXPOEN_2 nanb S0 na VDD pm1p2_svt_lp L=6e-08 W=3e-07
MI3_MXPOEN nanb ns0 nb VDD pm1p2_svt_lp L=6e-08 W=3e-07
MI3_MXPOEN_2 nanb ns0 nb VDD pm1p2_svt_lp L=6e-08 W=3e-07
MI2_MXPA1 nb B VDD VDD pm1p2_svt_lp L=6e-08 W=4.5e-07
MI2_MXPA1_2 nb B VDD VDD pm1p2_svt_lp L=6e-08 W=4.5e-07
MI13_MXPA1 ns0 S0 VDD VDD pm1p2_svt_lp L=6e-08 W=5.85e-07
MI13_MXPA1_2 ns0 S0 VDD VDD pm1p2_svt_lp L=6e-08 W=5.85e-07
MI6_MXPA1 nc C VDD VDD pm1p2_svt_lp L=6e-08 W=4.5e-07
MI6_MXPA1_2 nc C VDD VDD pm1p2_svt_lp L=6e-08 W=4.5e-07
MI7_MXPOEN ncnd S0 nc VDD pm1p2_svt_lp L=6e-08 W=3e-07
MI7_MXPOEN_2 ncnd S0 nc VDD pm1p2_svt_lp L=6e-08 W=3e-07
MI11_MXPOEN ncnd ns0 nd VDD pm1p2_svt_lp L=6e-08 W=3e-07
MI11_MXPOEN_2 ncnd ns0 nd VDD pm1p2_svt_lp L=6e-08 W=3e-07
MI10_MXPA1 nd D VDD VDD pm1p2_svt_lp L=6e-08 W=4.5e-07
MI10_MXPA1_2 nd D VDD VDD pm1p2_svt_lp L=6e-08 W=4.5e-07
MI8_MXPA1 cd ncnd VDD VDD pm1p2_svt_lp L=6e-08 W=4.2e-07
MI8_MXPA1_2 cd ncnd VDD VDD pm1p2_svt_lp L=6e-08 W=4.2e-07
MI14_MXPA1 ns1 S1 VDD VDD pm1p2_svt_lp L=6e-08 W=5.85e-07
MI9_MXPOEN ny ns1 cd VDD pm1p2_svt_lp L=6e-08 W=3e-07
MI9_MXPOEN_2 ny ns1 cd VDD pm1p2_svt_lp L=6e-08 W=3e-07
MI5_MXPOEN ny S1 ab VDD pm1p2_svt_lp L=6e-08 W=3e-07
MI5_MXPOEN_2 ny S1 ab VDD pm1p2_svt_lp L=6e-08 W=3e-07
MI4_MXPA1 ab nanb VDD VDD pm1p2_svt_lp L=6e-08 W=4.2e-07
MI4_MXPA1_2 ab nanb VDD VDD pm1p2_svt_lp L=6e-08 W=4.2e-07
MI12_MXPA1 Y ny VDD VDD pm1p2_svt_lp L=6e-08 W=5.85e-07
MI12_MXPA1_2 Y ny VDD VDD pm1p2_svt_lp L=6e-08 W=5.85e-07
MI12_MXPA1_3 Y ny VDD VDD pm1p2_svt_lp L=6e-08 W=5.85e-07
.ENDS

.SUBCKT AO21X0P5H9R Y VDD VSS A0 A1 B0
MI0_MXNB2 XI0_n1 A1 VSS VSS nm1p2_svt_lp L=6e-08 W=2.65e-07
MI0_MXNB1 ny A0 XI0_n1 VSS nm1p2_svt_lp L=6e-08 W=2.65e-07
MI0_MXNA1 ny B0 VSS VSS nm1p2_svt_lp L=6e-08 W=1.5e-07
MI1_MXNA1 Y ny VSS VSS nm1p2_svt_lp L=6e-08 W=2.1e-07
MI0_MXPB2 XI0_p1 A1 VDD VDD pm1p2_svt_lp L=6e-08 W=3.75e-07
MI0_MXPB1 XI0_p1 A0 VDD VDD pm1p2_svt_lp L=6e-08 W=3.75e-07
MI0_MXPA1 ny B0 XI0_p1 VDD pm1p2_svt_lp L=6e-08 W=3.75e-07
MI1_MXPA1 Y ny VDD VDD pm1p2_svt_lp L=6e-08 W=2.95e-07
.ENDS

.SUBCKT AO21X0P7H9R Y VDD VSS A0 A1 B0
MI0_MXNB2 XI0_n1 A1 VSS VSS nm1p2_svt_lp L=6e-08 W=2.95e-07
MI0_MXNB1 ny A0 XI0_n1 VSS nm1p2_svt_lp L=6e-08 W=2.95e-07
MI0_MXNA1 ny B0 VSS VSS nm1p2_svt_lp L=6e-08 W=1.7e-07
MI1_MXNA1 Y ny VSS VSS nm1p2_svt_lp L=6e-08 W=2.95e-07
MI0_MXPB2 XI0_p1 A1 VDD VDD pm1p2_svt_lp L=6e-08 W=4.2e-07
MI0_MXPB1 XI0_p1 A0 VDD VDD pm1p2_svt_lp L=6e-08 W=4.2e-07
MI0_MXPA1 ny B0 XI0_p1 VDD pm1p2_svt_lp L=6e-08 W=4.2e-07
MI1_MXPA1 Y ny VDD VDD pm1p2_svt_lp L=6e-08 W=4.15e-07
.ENDS

.SUBCKT AO21X1H9R Y VDD VSS A0 A1 B0
MI0_MXNB2 XI0_n1 A1 VSS VSS nm1p2_svt_lp L=6e-08 W=3.65e-07
MI0_MXNB1 ny A0 XI0_n1 VSS nm1p2_svt_lp L=6e-08 W=3.65e-07
MI0_MXNA1 ny B0 VSS VSS nm1p2_svt_lp L=6e-08 W=2.1e-07
MI1_MXNA1 Y ny VSS VSS nm1p2_svt_lp L=6e-08 W=4.2e-07
MI0_MXPB2 XI0_p1 A1 VDD VDD pm1p2_svt_lp L=6e-08 W=5.15e-07
MI0_MXPB1 XI0_p1 A0 VDD VDD pm1p2_svt_lp L=6e-08 W=5.15e-07
MI0_MXPA1 ny B0 XI0_p1 VDD pm1p2_svt_lp L=6e-08 W=5.15e-07
MI1_MXPA1 Y ny VDD VDD pm1p2_svt_lp L=6e-08 W=5.85e-07
.ENDS

.SUBCKT AO21X1P4H9R Y VDD VSS A0 A1 B0
MI0_MXNB2 XI0_n1 A1 VSS VSS nm1p2_svt_lp L=6e-08 W=2.65e-07
MI0_MXNB2_2 XI0_n1 A1 VSS VSS nm1p2_svt_lp L=6e-08 W=2.65e-07
MI0_MXNB1 ny A0 XI0_n1 VSS nm1p2_svt_lp L=6e-08 W=2.65e-07
MI0_MXNB1_2 ny A0 XI0_n1 VSS nm1p2_svt_lp L=6e-08 W=2.65e-07
MI0_MXNA1 ny B0 VSS VSS nm1p2_svt_lp L=6e-08 W=3e-07
MI1_MXNA1 Y ny VSS VSS nm1p2_svt_lp L=6e-08 W=2.95e-07
MI1_MXNA1_2 Y ny VSS VSS nm1p2_svt_lp L=6e-08 W=2.95e-07
MI0_MXPB2 XI0_p1 A1 VDD VDD pm1p2_svt_lp L=6e-08 W=3.75e-07
MI0_MXPB2_2 XI0_p1 A1 VDD VDD pm1p2_svt_lp L=6e-08 W=3.75e-07
MI0_MXPB1 XI0_p1 A0 VDD VDD pm1p2_svt_lp L=6e-08 W=3.75e-07
MI0_MXPB1_2 XI0_p1 A0 VDD VDD pm1p2_svt_lp L=6e-08 W=3.75e-07
MI0_MXPA1 ny B0 XI0_p1 VDD pm1p2_svt_lp L=6e-08 W=3.75e-07
MI0_MXPA1_2 ny B0 XI0_p1 VDD pm1p2_svt_lp L=6e-08 W=3.75e-07
MI1_MXPA1 Y ny VDD VDD pm1p2_svt_lp L=6e-08 W=4.15e-07
MI1_MXPA1_2 Y ny VDD VDD pm1p2_svt_lp L=6e-08 W=4.15e-07
.ENDS

.SUBCKT AO21X2H9R Y VDD VSS A0 A1 B0
MI0_MXNB2_2 XI0_n1__2 A1 VSS VSS nm1p2_svt_lp L=6e-08 W=3.35e-07
MI0_MXNB1_2 ny A0 XI0_n1__2 VSS nm1p2_svt_lp L=6e-08 W=3.35e-07
MI0_MXNB1 ny A0 XI0_n1 VSS nm1p2_svt_lp L=6e-08 W=3.35e-07
MI0_MXNB2 XI0_n1 A1 VSS VSS nm1p2_svt_lp L=6e-08 W=3.35e-07
MI0_MXNA1 ny B0 VSS VSS nm1p2_svt_lp L=6e-08 W=3.8e-07
MI1_MXNA1 Y ny VSS VSS nm1p2_svt_lp L=6e-08 W=4.2e-07
MI1_MXNA1_2 Y ny VSS VSS nm1p2_svt_lp L=6e-08 W=4.2e-07
MI0_MXPB2 XI0_p1 A1 VDD VDD pm1p2_svt_lp L=6e-08 W=4.7e-07
MI0_MXPB1 XI0_p1 A0 VDD VDD pm1p2_svt_lp L=6e-08 W=4.7e-07
MI0_MXPB1_2 XI0_p1 A0 VDD VDD pm1p2_svt_lp L=6e-08 W=4.7e-07
MI0_MXPB2_2 XI0_p1 A1 VDD VDD pm1p2_svt_lp L=6e-08 W=4.7e-07
MI0_MXPA1 ny B0 XI0_p1 VDD pm1p2_svt_lp L=6e-08 W=4.7e-07
MI0_MXPA1_2 ny B0 XI0_p1 VDD pm1p2_svt_lp L=6e-08 W=4.7e-07
MI1_MXPA1 Y ny VDD VDD pm1p2_svt_lp L=6e-08 W=5.85e-07
MI1_MXPA1_2 Y ny VDD VDD pm1p2_svt_lp L=6e-08 W=5.85e-07
.ENDS

.SUBCKT AO21X3H9R Y VDD VSS A0 A1 B0
MI0_MXNB2 XI0_n1 A1 VSS VSS nm1p2_svt_lp L=6e-08 W=3.35e-07
MI0_MXNB2_2 XI0_n1 A1 VSS VSS nm1p2_svt_lp L=6e-08 W=3.35e-07
MI0_MXNB2_3 XI0_n1 A1 VSS VSS nm1p2_svt_lp L=6e-08 W=3.35e-07
MI0_MXNB1 ny A0 XI0_n1 VSS nm1p2_svt_lp L=6e-08 W=3.35e-07
MI0_MXNB1_2 ny A0 XI0_n1 VSS nm1p2_svt_lp L=6e-08 W=3.35e-07
MI0_MXNB1_3 ny A0 XI0_n1 VSS nm1p2_svt_lp L=6e-08 W=3.35e-07
MI0_MXNA1 ny B0 VSS VSS nm1p2_svt_lp L=6e-08 W=2.85e-07
MI0_MXNA1_2 ny B0 VSS VSS nm1p2_svt_lp L=6e-08 W=2.85e-07
MI1_MXNA1 Y ny VSS VSS nm1p2_svt_lp L=6e-08 W=4.2e-07
MI1_MXNA1_2 Y ny VSS VSS nm1p2_svt_lp L=6e-08 W=4.2e-07
MI1_MXNA1_3 Y ny VSS VSS nm1p2_svt_lp L=6e-08 W=4.2e-07
MI0_MXPB2 XI0_p1 A1 VDD VDD pm1p2_svt_lp L=6e-08 W=4.75e-07
MI0_MXPB2_2 XI0_p1 A1 VDD VDD pm1p2_svt_lp L=6e-08 W=4.75e-07
MI0_MXPB2_3 XI0_p1 A1 VDD VDD pm1p2_svt_lp L=6e-08 W=4.75e-07
MI0_MXPB1 XI0_p1 A0 VDD VDD pm1p2_svt_lp L=6e-08 W=4.75e-07
MI0_MXPB1_2 XI0_p1 A0 VDD VDD pm1p2_svt_lp L=6e-08 W=4.75e-07
MI0_MXPB1_3 XI0_p1 A0 VDD VDD pm1p2_svt_lp L=6e-08 W=4.75e-07
MI0_MXPA1 ny B0 XI0_p1 VDD pm1p2_svt_lp L=6e-08 W=4.75e-07
MI0_MXPA1_2 ny B0 XI0_p1 VDD pm1p2_svt_lp L=6e-08 W=4.75e-07
MI0_MXPA1_3 ny B0 XI0_p1 VDD pm1p2_svt_lp L=6e-08 W=4.75e-07
MI1_MXPA1 Y ny VDD VDD pm1p2_svt_lp L=6e-08 W=5.85e-07
MI1_MXPA1_2 Y ny VDD VDD pm1p2_svt_lp L=6e-08 W=5.85e-07
MI1_MXPA1_3 Y ny VDD VDD pm1p2_svt_lp L=6e-08 W=5.85e-07
.ENDS

.SUBCKT AO21X4H9R Y VDD VSS A0 A1 B0
MI0_MXNB2 XI0_n1 A1 VSS VSS nm1p2_svt_lp L=6e-08 W=4.1e-07
MI0_MXNB2_2 XI0_n1 A1 VSS VSS nm1p2_svt_lp L=6e-08 W=4.1e-07
MI0_MXNB2_3 XI0_n1 A1 VSS VSS nm1p2_svt_lp L=6e-08 W=4.1e-07
MI0_MXNB1 ny A0 XI0_n1 VSS nm1p2_svt_lp L=6e-08 W=4.1e-07
MI0_MXNB1_2 ny A0 XI0_n1 VSS nm1p2_svt_lp L=6e-08 W=4.1e-07
MI0_MXNB1_3 ny A0 XI0_n1 VSS nm1p2_svt_lp L=6e-08 W=4.1e-07
MI0_MXNA1 ny B0 VSS VSS nm1p2_svt_lp L=6e-08 W=3.55e-07
MI0_MXNA1_2 ny B0 VSS VSS nm1p2_svt_lp L=6e-08 W=3.55e-07
MI1_MXNA1 Y ny VSS VSS nm1p2_svt_lp L=6e-08 W=4.2e-07
MI1_MXNA1_2 Y ny VSS VSS nm1p2_svt_lp L=6e-08 W=4.2e-07
MI1_MXNA1_3 Y ny VSS VSS nm1p2_svt_lp L=6e-08 W=4.2e-07
MI1_MXNA1_4 Y ny VSS VSS nm1p2_svt_lp L=6e-08 W=4.2e-07
MI0_MXPB2 XI0_p1 A1 VDD VDD pm1p2_svt_lp L=6e-08 W=5.85e-07
MI0_MXPB2_2 XI0_p1 A1 VDD VDD pm1p2_svt_lp L=6e-08 W=5.85e-07
MI0_MXPB2_3 XI0_p1 A1 VDD VDD pm1p2_svt_lp L=6e-08 W=5.85e-07
MI0_MXPB1 XI0_p1 A0 VDD VDD pm1p2_svt_lp L=6e-08 W=5.85e-07
MI0_MXPB1_2 XI0_p1 A0 VDD VDD pm1p2_svt_lp L=6e-08 W=5.85e-07
MI0_MXPB1_3 XI0_p1 A0 VDD VDD pm1p2_svt_lp L=6e-08 W=5.85e-07
MI0_MXPA1 ny B0 XI0_p1 VDD pm1p2_svt_lp L=6e-08 W=5.85e-07
MI0_MXPA1_2 ny B0 XI0_p1 VDD pm1p2_svt_lp L=6e-08 W=5.85e-07
MI0_MXPA1_3 ny B0 XI0_p1 VDD pm1p2_svt_lp L=6e-08 W=5.85e-07
MI1_MXPA1 Y ny VDD VDD pm1p2_svt_lp L=6e-08 W=5.85e-07
MI1_MXPA1_2 Y ny VDD VDD pm1p2_svt_lp L=6e-08 W=5.85e-07
MI1_MXPA1_3 Y ny VDD VDD pm1p2_svt_lp L=6e-08 W=5.85e-07
MI1_MXPA1_4 Y ny VDD VDD pm1p2_svt_lp L=6e-08 W=5.85e-07
.ENDS

.SUBCKT AO21X6H9R Y VDD VSS A0 A1 B0
MI0_MXNB2 XI0_n1 A1 VSS VSS nm1p2_svt_lp L=6e-08 W=4.7e-07
MI0_MXNB2_2 XI0_n1 A1 VSS VSS nm1p2_svt_lp L=6e-08 W=4.7e-07
MI0_MXNB2_3 XI0_n1 A1 VSS VSS nm1p2_svt_lp L=6e-08 W=4.7e-07
MI0_MXNB2_4 XI0_n1 A1 VSS VSS nm1p2_svt_lp L=6e-08 W=4.7e-07
MI0_MXNB1 ny A0 XI0_n1 VSS nm1p2_svt_lp L=6e-08 W=4.7e-07
MI0_MXNB1_2 ny A0 XI0_n1 VSS nm1p2_svt_lp L=6e-08 W=4.7e-07
MI0_MXNB1_3 ny A0 XI0_n1 VSS nm1p2_svt_lp L=6e-08 W=4.7e-07
MI0_MXNB1_4 ny A0 XI0_n1 VSS nm1p2_svt_lp L=6e-08 W=4.7e-07
MI0_MXNA1 ny B0 VSS VSS nm1p2_svt_lp L=6e-08 W=3.6e-07
MI0_MXNA1_2 ny B0 VSS VSS nm1p2_svt_lp L=6e-08 W=3.6e-07
MI0_MXNA1_3 ny B0 VSS VSS nm1p2_svt_lp L=6e-08 W=3.6e-07
MI1_MXNA1 Y ny VSS VSS nm1p2_svt_lp L=6e-08 W=4.2e-07
MI1_MXNA1_2 Y ny VSS VSS nm1p2_svt_lp L=6e-08 W=4.2e-07
MI1_MXNA1_3 Y ny VSS VSS nm1p2_svt_lp L=6e-08 W=4.2e-07
MI1_MXNA1_4 Y ny VSS VSS nm1p2_svt_lp L=6e-08 W=4.2e-07
MI1_MXNA1_5 Y ny VSS VSS nm1p2_svt_lp L=6e-08 W=4.2e-07
MI1_MXNA1_6 Y ny VSS VSS nm1p2_svt_lp L=6e-08 W=4.2e-07
MI0_MXPB2 XI0_p1 A1 VDD VDD pm1p2_svt_lp L=6e-08 W=5.35e-07
MI0_MXPB2_2 XI0_p1 A1 VDD VDD pm1p2_svt_lp L=6e-08 W=5.35e-07
MI0_MXPB2_3 XI0_p1 A1 VDD VDD pm1p2_svt_lp L=6e-08 W=5.35e-07
MI0_MXPB2_4 XI0_p1 A1 VDD VDD pm1p2_svt_lp L=6e-08 W=5.35e-07
MI0_MXPB2_5 XI0_p1 A1 VDD VDD pm1p2_svt_lp L=6e-08 W=5.35e-07
MI0_MXPB1 XI0_p1 A0 VDD VDD pm1p2_svt_lp L=6e-08 W=5.35e-07
MI0_MXPB1_2 XI0_p1 A0 VDD VDD pm1p2_svt_lp L=6e-08 W=5.35e-07
MI0_MXPB1_3 XI0_p1 A0 VDD VDD pm1p2_svt_lp L=6e-08 W=5.35e-07
MI0_MXPB1_4 XI0_p1 A0 VDD VDD pm1p2_svt_lp L=6e-08 W=5.35e-07
MI0_MXPB1_5 XI0_p1 A0 VDD VDD pm1p2_svt_lp L=6e-08 W=5.35e-07
MI0_MXPA1 ny B0 XI0_p1 VDD pm1p2_svt_lp L=6e-08 W=5.35e-07
MI0_MXPA1_2 ny B0 XI0_p1 VDD pm1p2_svt_lp L=6e-08 W=5.35e-07
MI0_MXPA1_3 ny B0 XI0_p1 VDD pm1p2_svt_lp L=6e-08 W=5.35e-07
MI0_MXPA1_4 ny B0 XI0_p1 VDD pm1p2_svt_lp L=6e-08 W=5.35e-07
MI0_MXPA1_5 ny B0 XI0_p1 VDD pm1p2_svt_lp L=6e-08 W=5.35e-07
MI1_MXPA1 Y ny VDD VDD pm1p2_svt_lp L=6e-08 W=5.85e-07
MI1_MXPA1_2 Y ny VDD VDD pm1p2_svt_lp L=6e-08 W=5.85e-07
MI1_MXPA1_3 Y ny VDD VDD pm1p2_svt_lp L=6e-08 W=5.85e-07
MI1_MXPA1_4 Y ny VDD VDD pm1p2_svt_lp L=6e-08 W=5.85e-07
MI1_MXPA1_5 Y ny VDD VDD pm1p2_svt_lp L=6e-08 W=5.85e-07
MI1_MXPA1_6 Y ny VDD VDD pm1p2_svt_lp L=6e-08 W=5.85e-07
.ENDS

.SUBCKT AOI21X0P5H9R Y VDD VSS A0 A1 B0
MI0_MXNB2 XI0_n1 A1 VSS VSS nm1p2_svt_lp L=6e-08 W=2.65e-07
MI0_MXNB1 Y A0 XI0_n1 VSS nm1p2_svt_lp L=6e-08 W=2.65e-07
MI0_MXNA1 Y B0 VSS VSS nm1p2_svt_lp L=6e-08 W=1.5e-07
MI0_MXPB2 XI0_p1 A1 VDD VDD pm1p2_svt_lp L=6e-08 W=3.75e-07
MI0_MXPB1 XI0_p1 A0 VDD VDD pm1p2_svt_lp L=6e-08 W=3.75e-07
MI0_MXPA1 Y B0 XI0_p1 VDD pm1p2_svt_lp L=6e-08 W=3.75e-07
.ENDS

.SUBCKT AOI21X0P7H9R Y VDD VSS A0 A1 B0
MI0_MXNB2 XI0_n1 A1 VSS VSS nm1p2_svt_lp L=6e-08 W=2.9e-07
MI0_MXNB1 Y A0 XI0_n1 VSS nm1p2_svt_lp L=6e-08 W=2.9e-07
MI0_MXNA1 Y B0 VSS VSS nm1p2_svt_lp L=6e-08 W=1.65e-07
MI0_MXPB2 XI0_p1 A1 VDD VDD pm1p2_svt_lp L=6e-08 W=4.15e-07
MI0_MXPB1 XI0_p1 A0 VDD VDD pm1p2_svt_lp L=6e-08 W=4.15e-07
MI0_MXPA1 Y B0 XI0_p1 VDD pm1p2_svt_lp L=6e-08 W=4.15e-07
.ENDS

.SUBCKT AOI21X1H9R Y VDD VSS A0 A1 B0
MI0_MXNB2 XI0_n1 A1 VSS VSS nm1p2_svt_lp L=6e-08 W=4.1e-07
MI0_MXNB1 Y A0 XI0_n1 VSS nm1p2_svt_lp L=6e-08 W=4.1e-07
MI0_MXNA1 Y B0 VSS VSS nm1p2_svt_lp L=6e-08 W=2.35e-07
MI0_MXPB2 XI0_p1 A1 VDD VDD pm1p2_svt_lp L=6e-08 W=5.85e-07
MI0_MXPB1 XI0_p1 A0 VDD VDD pm1p2_svt_lp L=6e-08 W=5.85e-07
MI0_MXPA1 Y B0 XI0_p1 VDD pm1p2_svt_lp L=6e-08 W=5.85e-07
.ENDS

.SUBCKT AOI21X1P4H9R Y VDD VSS A0 A1 B0
MI0_MXNB2_2 XI0_n1__2 A1 VSS VSS nm1p2_svt_lp L=6e-08 W=2.9e-07
MI0_MXNB1_2 Y A0 XI0_n1__2 VSS nm1p2_svt_lp L=6e-08 W=2.9e-07
MI0_MXNB1 Y A0 XI0_n1 VSS nm1p2_svt_lp L=6e-08 W=2.9e-07
MI0_MXNB2 XI0_n1 A1 VSS VSS nm1p2_svt_lp L=6e-08 W=2.9e-07
MI0_MXNA1 Y B0 VSS VSS nm1p2_svt_lp L=6e-08 W=3.3e-07
MI0_MXPB2 XI0_p1 A1 VDD VDD pm1p2_svt_lp L=6e-08 W=4.15e-07
MI0_MXPB1 XI0_p1 A0 VDD VDD pm1p2_svt_lp L=6e-08 W=4.15e-07
MI0_MXPB1_2 XI0_p1 A0 VDD VDD pm1p2_svt_lp L=6e-08 W=4.15e-07
MI0_MXPB2_2 XI0_p1 A1 VDD VDD pm1p2_svt_lp L=6e-08 W=4.15e-07
MI0_MXPA1 Y B0 XI0_p1 VDD pm1p2_svt_lp L=6e-08 W=4.15e-07
MI0_MXPA1_2 Y B0 XI0_p1 VDD pm1p2_svt_lp L=6e-08 W=4.15e-07
.ENDS

.SUBCKT AOI21X2H9R Y VDD VSS A0 A1 B0
MI0_MXNB2_2 XI0_n1__2 A1 VSS VSS nm1p2_svt_lp L=6e-08 W=4.1e-07
MI0_MXNB1_2 Y A0 XI0_n1__2 VSS nm1p2_svt_lp L=6e-08 W=4.1e-07
MI0_MXNB1 Y A0 XI0_n1 VSS nm1p2_svt_lp L=6e-08 W=4.1e-07
MI0_MXNB2 XI0_n1 A1 VSS VSS nm1p2_svt_lp L=6e-08 W=4.1e-07
MI0_MXNA1 Y B0 VSS VSS nm1p2_svt_lp L=6e-08 W=4.7e-07
MI0_MXPB2 XI0_p1 A1 VDD VDD pm1p2_svt_lp L=6e-08 W=5.85e-07
MI0_MXPB1 XI0_p1 A0 VDD VDD pm1p2_svt_lp L=6e-08 W=5.85e-07
MI0_MXPB1_2 XI0_p1 A0 VDD VDD pm1p2_svt_lp L=6e-08 W=5.85e-07
MI0_MXPB2_2 XI0_p1 A1 VDD VDD pm1p2_svt_lp L=6e-08 W=5.85e-07
MI0_MXPA1 Y B0 XI0_p1 VDD pm1p2_svt_lp L=6e-08 W=5.85e-07
MI0_MXPA1_2 Y B0 XI0_p1 VDD pm1p2_svt_lp L=6e-08 W=5.85e-07
.ENDS

.SUBCKT AOI21X3H9R Y VDD VSS A0 A1 B0
MI0_MXNB2 XI0_n1 A1 VSS VSS nm1p2_svt_lp L=6e-08 W=4.1e-07
MI0_MXNB2_2 XI0_n1 A1 VSS VSS nm1p2_svt_lp L=6e-08 W=4.1e-07
MI0_MXNB2_3 XI0_n1 A1 VSS VSS nm1p2_svt_lp L=6e-08 W=4.1e-07
MI0_MXNB1 Y A0 XI0_n1 VSS nm1p2_svt_lp L=6e-08 W=4.1e-07
MI0_MXNB1_2 Y A0 XI0_n1 VSS nm1p2_svt_lp L=6e-08 W=4.1e-07
MI0_MXNB1_3 Y A0 XI0_n1 VSS nm1p2_svt_lp L=6e-08 W=4.1e-07
MI0_MXNA1 Y B0 VSS VSS nm1p2_svt_lp L=6e-08 W=3.55e-07
MI0_MXNA1_2 Y B0 VSS VSS nm1p2_svt_lp L=6e-08 W=3.55e-07
MI0_MXPB2 XI0_p1 A1 VDD VDD pm1p2_svt_lp L=6e-08 W=5.85e-07
MI0_MXPB2_2 XI0_p1 A1 VDD VDD pm1p2_svt_lp L=6e-08 W=5.85e-07
MI0_MXPB2_3 XI0_p1 A1 VDD VDD pm1p2_svt_lp L=6e-08 W=5.85e-07
MI0_MXPB1 XI0_p1 A0 VDD VDD pm1p2_svt_lp L=6e-08 W=5.85e-07
MI0_MXPB1_2 XI0_p1 A0 VDD VDD pm1p2_svt_lp L=6e-08 W=5.85e-07
MI0_MXPB1_3 XI0_p1 A0 VDD VDD pm1p2_svt_lp L=6e-08 W=5.85e-07
MI0_MXPA1 Y B0 XI0_p1 VDD pm1p2_svt_lp L=6e-08 W=5.85e-07
MI0_MXPA1_2 Y B0 XI0_p1 VDD pm1p2_svt_lp L=6e-08 W=5.85e-07
MI0_MXPA1_3 Y B0 XI0_p1 VDD pm1p2_svt_lp L=6e-08 W=5.85e-07
.ENDS

.SUBCKT AOI21X4H9R Y VDD VSS A0 A1 B0
MI0_MXNB2 XI0_n1 A1 VSS VSS nm1p2_svt_lp L=6e-08 W=4.1e-07
MI0_MXNB2_2 XI0_n1 A1 VSS VSS nm1p2_svt_lp L=6e-08 W=4.1e-07
MI0_MXNB2_3 XI0_n1 A1 VSS VSS nm1p2_svt_lp L=6e-08 W=4.1e-07
MI0_MXNB2_4 XI0_n1 A1 VSS VSS nm1p2_svt_lp L=6e-08 W=4.1e-07
MI0_MXNB1 Y A0 XI0_n1 VSS nm1p2_svt_lp L=6e-08 W=4.1e-07
MI0_MXNB1_2 Y A0 XI0_n1 VSS nm1p2_svt_lp L=6e-08 W=4.1e-07
MI0_MXNB1_3 Y A0 XI0_n1 VSS nm1p2_svt_lp L=6e-08 W=4.1e-07
MI0_MXNB1_4 Y A0 XI0_n1 VSS nm1p2_svt_lp L=6e-08 W=4.1e-07
MI0_MXNA1 Y B0 VSS VSS nm1p2_svt_lp L=6e-08 W=4.7e-07
MI0_MXNA1_2 Y B0 VSS VSS nm1p2_svt_lp L=6e-08 W=4.7e-07
MI0_MXPB2 XI0_p1 A1 VDD VDD pm1p2_svt_lp L=6e-08 W=5.85e-07
MI0_MXPB2_2 XI0_p1 A1 VDD VDD pm1p2_svt_lp L=6e-08 W=5.85e-07
MI0_MXPB2_3 XI0_p1 A1 VDD VDD pm1p2_svt_lp L=6e-08 W=5.85e-07
MI0_MXPB2_4 XI0_p1 A1 VDD VDD pm1p2_svt_lp L=6e-08 W=5.85e-07
MI0_MXPB1 XI0_p1 A0 VDD VDD pm1p2_svt_lp L=6e-08 W=5.85e-07
MI0_MXPB1_2 XI0_p1 A0 VDD VDD pm1p2_svt_lp L=6e-08 W=5.85e-07
MI0_MXPB1_3 XI0_p1 A0 VDD VDD pm1p2_svt_lp L=6e-08 W=5.85e-07
MI0_MXPB1_4 XI0_p1 A0 VDD VDD pm1p2_svt_lp L=6e-08 W=5.85e-07
MI0_MXPA1 Y B0 XI0_p1 VDD pm1p2_svt_lp L=6e-08 W=5.85e-07
MI0_MXPA1_2 Y B0 XI0_p1 VDD pm1p2_svt_lp L=6e-08 W=5.85e-07
MI0_MXPA1_3 Y B0 XI0_p1 VDD pm1p2_svt_lp L=6e-08 W=5.85e-07
MI0_MXPA1_4 Y B0 XI0_p1 VDD pm1p2_svt_lp L=6e-08 W=5.85e-07
.ENDS

.SUBCKT AOI21X6H9R Y VDD VSS A0 A1 B0
MI0_MXNB2 XI0_n1 A1 VSS VSS nm1p2_svt_lp L=6e-08 W=4.95e-07
MI0_MXNB2_2 XI0_n1 A1 VSS VSS nm1p2_svt_lp L=6e-08 W=4.95e-07
MI0_MXNB2_3 XI0_n1 A1 VSS VSS nm1p2_svt_lp L=6e-08 W=4.95e-07
MI0_MXNB2_4 XI0_n1 A1 VSS VSS nm1p2_svt_lp L=6e-08 W=4.95e-07
MI0_MXNB2_5 XI0_n1 A1 VSS VSS nm1p2_svt_lp L=6e-08 W=4.95e-07
MI0_MXNB1 Y A0 XI0_n1 VSS nm1p2_svt_lp L=6e-08 W=4.95e-07
MI0_MXNB1_2 Y A0 XI0_n1 VSS nm1p2_svt_lp L=6e-08 W=4.95e-07
MI0_MXNB1_3 Y A0 XI0_n1 VSS nm1p2_svt_lp L=6e-08 W=4.95e-07
MI0_MXNB1_4 Y A0 XI0_n1 VSS nm1p2_svt_lp L=6e-08 W=4.95e-07
MI0_MXNB1_5 Y A0 XI0_n1 VSS nm1p2_svt_lp L=6e-08 W=4.95e-07
MI0_MXNA1 Y B0 VSS VSS nm1p2_svt_lp L=6e-08 W=4.7e-07
MI0_MXNA1_2 Y B0 VSS VSS nm1p2_svt_lp L=6e-08 W=4.7e-07
MI0_MXNA1_3 Y B0 VSS VSS nm1p2_svt_lp L=6e-08 W=4.7e-07
MI0_MXPB2 XI0_p1 A1 VDD VDD pm1p2_svt_lp L=6e-08 W=5.85e-07
MI0_MXPB2_2 XI0_p1 A1 VDD VDD pm1p2_svt_lp L=6e-08 W=5.85e-07
MI0_MXPB2_3 XI0_p1 A1 VDD VDD pm1p2_svt_lp L=6e-08 W=5.85e-07
MI0_MXPB2_4 XI0_p1 A1 VDD VDD pm1p2_svt_lp L=6e-08 W=5.85e-07
MI0_MXPB2_5 XI0_p1 A1 VDD VDD pm1p2_svt_lp L=6e-08 W=5.85e-07
MI0_MXPB2_6 XI0_p1 A1 VDD VDD pm1p2_svt_lp L=6e-08 W=5.85e-07
MI0_MXPB1 XI0_p1 A0 VDD VDD pm1p2_svt_lp L=6e-08 W=5.85e-07
MI0_MXPB1_2 XI0_p1 A0 VDD VDD pm1p2_svt_lp L=6e-08 W=5.85e-07
MI0_MXPB1_3 XI0_p1 A0 VDD VDD pm1p2_svt_lp L=6e-08 W=5.85e-07
MI0_MXPB1_4 XI0_p1 A0 VDD VDD pm1p2_svt_lp L=6e-08 W=5.85e-07
MI0_MXPB1_5 XI0_p1 A0 VDD VDD pm1p2_svt_lp L=6e-08 W=5.85e-07
MI0_MXPB1_6 XI0_p1 A0 VDD VDD pm1p2_svt_lp L=6e-08 W=5.85e-07
MI0_MXPA1 Y B0 XI0_p1 VDD pm1p2_svt_lp L=6e-08 W=5.85e-07
MI0_MXPA1_2 Y B0 XI0_p1 VDD pm1p2_svt_lp L=6e-08 W=5.85e-07
MI0_MXPA1_3 Y B0 XI0_p1 VDD pm1p2_svt_lp L=6e-08 W=5.85e-07
MI0_MXPA1_4 Y B0 XI0_p1 VDD pm1p2_svt_lp L=6e-08 W=5.85e-07
MI0_MXPA1_5 Y B0 XI0_p1 VDD pm1p2_svt_lp L=6e-08 W=5.85e-07
MI0_MXPA1_6 Y B0 XI0_p1 VDD pm1p2_svt_lp L=6e-08 W=5.85e-07
.ENDS

.SUBCKT AOI21X8H9R Y VDD VSS A0 A1 B0
MI0_MXNB2 XI0_n1 A1 VSS VSS nm1p2_svt_lp L=6e-08 W=4.7e-07
MI0_MXNB2_2 XI0_n1 A1 VSS VSS nm1p2_svt_lp L=6e-08 W=4.7e-07
MI0_MXNB2_3 XI0_n1 A1 VSS VSS nm1p2_svt_lp L=6e-08 W=4.7e-07
MI0_MXNB2_4 XI0_n1 A1 VSS VSS nm1p2_svt_lp L=6e-08 W=4.7e-07
MI0_MXNB2_5 XI0_n1 A1 VSS VSS nm1p2_svt_lp L=6e-08 W=4.7e-07
MI0_MXNB2_6 XI0_n1 A1 VSS VSS nm1p2_svt_lp L=6e-08 W=4.7e-07
MI0_MXNB2_7 XI0_n1 A1 VSS VSS nm1p2_svt_lp L=6e-08 W=4.7e-07
MI0_MXNB1 Y A0 XI0_n1 VSS nm1p2_svt_lp L=6e-08 W=4.7e-07
MI0_MXNB1_2 Y A0 XI0_n1 VSS nm1p2_svt_lp L=6e-08 W=4.7e-07
MI0_MXNB1_3 Y A0 XI0_n1 VSS nm1p2_svt_lp L=6e-08 W=4.7e-07
MI0_MXNB1_4 Y A0 XI0_n1 VSS nm1p2_svt_lp L=6e-08 W=4.7e-07
MI0_MXNB1_5 Y A0 XI0_n1 VSS nm1p2_svt_lp L=6e-08 W=4.7e-07
MI0_MXNB1_6 Y A0 XI0_n1 VSS nm1p2_svt_lp L=6e-08 W=4.7e-07
MI0_MXNB1_7 Y A0 XI0_n1 VSS nm1p2_svt_lp L=6e-08 W=4.7e-07
MI0_MXNA1 Y B0 VSS VSS nm1p2_svt_lp L=6e-08 W=4.7e-07
MI0_MXNA1_2 Y B0 VSS VSS nm1p2_svt_lp L=6e-08 W=4.7e-07
MI0_MXNA1_3 Y B0 VSS VSS nm1p2_svt_lp L=6e-08 W=4.7e-07
MI0_MXNA1_4 Y B0 VSS VSS nm1p2_svt_lp L=6e-08 W=4.7e-07
MI0_MXPB2 XI0_p1 A1 VDD VDD pm1p2_svt_lp L=6e-08 W=5.85e-07
MI0_MXPB2_2 XI0_p1 A1 VDD VDD pm1p2_svt_lp L=6e-08 W=5.85e-07
MI0_MXPB2_3 XI0_p1 A1 VDD VDD pm1p2_svt_lp L=6e-08 W=5.85e-07
MI0_MXPB2_4 XI0_p1 A1 VDD VDD pm1p2_svt_lp L=6e-08 W=5.85e-07
MI0_MXPB2_5 XI0_p1 A1 VDD VDD pm1p2_svt_lp L=6e-08 W=5.85e-07
MI0_MXPB2_6 XI0_p1 A1 VDD VDD pm1p2_svt_lp L=6e-08 W=5.85e-07
MI0_MXPB2_7 XI0_p1 A1 VDD VDD pm1p2_svt_lp L=6e-08 W=5.85e-07
MI0_MXPB2_8 XI0_p1 A1 VDD VDD pm1p2_svt_lp L=6e-08 W=5.85e-07
MI0_MXPB1 XI0_p1 A0 VDD VDD pm1p2_svt_lp L=6e-08 W=5.85e-07
MI0_MXPB1_2 XI0_p1 A0 VDD VDD pm1p2_svt_lp L=6e-08 W=5.85e-07
MI0_MXPB1_3 XI0_p1 A0 VDD VDD pm1p2_svt_lp L=6e-08 W=5.85e-07
MI0_MXPB1_4 XI0_p1 A0 VDD VDD pm1p2_svt_lp L=6e-08 W=5.85e-07
MI0_MXPB1_5 XI0_p1 A0 VDD VDD pm1p2_svt_lp L=6e-08 W=5.85e-07
MI0_MXPB1_6 XI0_p1 A0 VDD VDD pm1p2_svt_lp L=6e-08 W=5.85e-07
MI0_MXPB1_7 XI0_p1 A0 VDD VDD pm1p2_svt_lp L=6e-08 W=5.85e-07
MI0_MXPB1_8 XI0_p1 A0 VDD VDD pm1p2_svt_lp L=6e-08 W=5.85e-07
MI0_MXPA1 Y B0 XI0_p1 VDD pm1p2_svt_lp L=6e-08 W=5.85e-07
MI0_MXPA1_2 Y B0 XI0_p1 VDD pm1p2_svt_lp L=6e-08 W=5.85e-07
MI0_MXPA1_3 Y B0 XI0_p1 VDD pm1p2_svt_lp L=6e-08 W=5.85e-07
MI0_MXPA1_4 Y B0 XI0_p1 VDD pm1p2_svt_lp L=6e-08 W=5.85e-07
MI0_MXPA1_5 Y B0 XI0_p1 VDD pm1p2_svt_lp L=6e-08 W=5.85e-07
MI0_MXPA1_6 Y B0 XI0_p1 VDD pm1p2_svt_lp L=6e-08 W=5.85e-07
MI0_MXPA1_7 Y B0 XI0_p1 VDD pm1p2_svt_lp L=6e-08 W=5.85e-07
MI0_MXPA1_8 Y B0 XI0_p1 VDD pm1p2_svt_lp L=6e-08 W=5.85e-07
.ENDS

.SUBCKT AOI2XB1X0P5H9R Y VDD VSS A0 A1N B0
MI0_MXNA1 a1 A1N VSS VSS nm1p2_svt_lp L=6e-08 W=1.5e-07
MI1_MXNB2 XI1_n1 a1 VSS VSS nm1p2_svt_lp L=6e-08 W=2.65e-07
MI1_MXNB1 Y A0 XI1_n1 VSS nm1p2_svt_lp L=6e-08 W=2.65e-07
MI1_MXNA1 Y B0 VSS VSS nm1p2_svt_lp L=6e-08 W=1.5e-07
MI0_MXPA1 a1 A1N VDD VDD pm1p2_svt_lp L=6e-08 W=2.1e-07
MI1_MXPB2 XI1_p1 a1 VDD VDD pm1p2_svt_lp L=6e-08 W=3.75e-07
MI1_MXPB1 XI1_p1 A0 VDD VDD pm1p2_svt_lp L=6e-08 W=3.75e-07
MI1_MXPA1 Y B0 XI1_p1 VDD pm1p2_svt_lp L=6e-08 W=3.75e-07
.ENDS

.SUBCKT AOI2XB1X0P7H9R Y VDD VSS A0 A1N B0
MI0_MXNA1 a1 A1N VSS VSS nm1p2_svt_lp L=6e-08 W=1.5e-07
MI1_MXNB2 XI1_n1 a1 VSS VSS nm1p2_svt_lp L=6e-08 W=2.9e-07
MI1_MXNB1 Y A0 XI1_n1 VSS nm1p2_svt_lp L=6e-08 W=2.9e-07
MI1_MXNA1 Y B0 VSS VSS nm1p2_svt_lp L=6e-08 W=1.65e-07
MI0_MXPA1 a1 A1N VDD VDD pm1p2_svt_lp L=6e-08 W=2.1e-07
MI1_MXPB2 XI1_p1 a1 VDD VDD pm1p2_svt_lp L=6e-08 W=4.15e-07
MI1_MXPB1 XI1_p1 A0 VDD VDD pm1p2_svt_lp L=6e-08 W=4.15e-07
MI1_MXPA1 Y B0 XI1_p1 VDD pm1p2_svt_lp L=6e-08 W=4.15e-07
.ENDS

.SUBCKT AOI2XB1X1H9R Y VDD VSS A0 A1N B0
MI0_MXNA1 a1 A1N VSS VSS nm1p2_svt_lp L=6e-08 W=1.5e-07
MI1_MXNB2 XI1_n1 a1 VSS VSS nm1p2_svt_lp L=6e-08 W=4.1e-07
MI1_MXNB1 Y A0 XI1_n1 VSS nm1p2_svt_lp L=6e-08 W=4.1e-07
MI1_MXNA1 Y B0 VSS VSS nm1p2_svt_lp L=6e-08 W=2.35e-07
MI0_MXPA1 a1 A1N VDD VDD pm1p2_svt_lp L=6e-08 W=2.1e-07
MI1_MXPB2 XI1_p1 a1 VDD VDD pm1p2_svt_lp L=6e-08 W=5.85e-07
MI1_MXPB1 XI1_p1 A0 VDD VDD pm1p2_svt_lp L=6e-08 W=5.85e-07
MI1_MXPA1 Y B0 XI1_p1 VDD pm1p2_svt_lp L=6e-08 W=5.85e-07
.ENDS

.SUBCKT AOI2XB1X1P4H9R Y VDD VSS A0 A1N B0
MI0_MXNA1 a1 A1N VSS VSS nm1p2_svt_lp L=6e-08 W=2e-07
MI1_MXNB2_2 XI1_n1__2 a1 VSS VSS nm1p2_svt_lp L=6e-08 W=2.9e-07
MI1_MXNB1_2 Y A0 XI1_n1__2 VSS nm1p2_svt_lp L=6e-08 W=2.9e-07
MI1_MXNB1 Y A0 XI1_n1 VSS nm1p2_svt_lp L=6e-08 W=2.9e-07
MI1_MXNB2 XI1_n1 a1 VSS VSS nm1p2_svt_lp L=6e-08 W=2.9e-07
MI1_MXNA1 Y B0 VSS VSS nm1p2_svt_lp L=6e-08 W=3.3e-07
MI0_MXPA1 a1 A1N VDD VDD pm1p2_svt_lp L=6e-08 W=2.8e-07
MI1_MXPB2 XI1_p1 a1 VDD VDD pm1p2_svt_lp L=6e-08 W=4.15e-07
MI1_MXPB1 XI1_p1 A0 VDD VDD pm1p2_svt_lp L=6e-08 W=4.15e-07
MI1_MXPB1_2 XI1_p1 A0 VDD VDD pm1p2_svt_lp L=6e-08 W=4.15e-07
MI1_MXPB2_2 XI1_p1 a1 VDD VDD pm1p2_svt_lp L=6e-08 W=4.15e-07
MI1_MXPA1 Y B0 XI1_p1 VDD pm1p2_svt_lp L=6e-08 W=4.15e-07
MI1_MXPA1_2 Y B0 XI1_p1 VDD pm1p2_svt_lp L=6e-08 W=4.15e-07
.ENDS

.SUBCKT AOI2XB1X2H9R Y VDD VSS A0 A1N B0
MI0_MXNA1 a1 A1N VSS VSS nm1p2_svt_lp L=6e-08 W=2.6e-07
MI1_MXNB2_2 XI1_n1__2 a1 VSS VSS nm1p2_svt_lp L=6e-08 W=4.1e-07
MI1_MXNB1_2 Y A0 XI1_n1__2 VSS nm1p2_svt_lp L=6e-08 W=4.1e-07
MI1_MXNB1 Y A0 XI1_n1 VSS nm1p2_svt_lp L=6e-08 W=4.1e-07
MI1_MXNB2 XI1_n1 a1 VSS VSS nm1p2_svt_lp L=6e-08 W=4.1e-07
MI1_MXNA1 Y B0 VSS VSS nm1p2_svt_lp L=6e-08 W=2.35e-07
MI1_MXNA1_2 Y B0 VSS VSS nm1p2_svt_lp L=6e-08 W=2.35e-07
MI0_MXPA1 a1 A1N VDD VDD pm1p2_svt_lp L=6e-08 W=3.65e-07
MI1_MXPB2 XI1_p1 a1 VDD VDD pm1p2_svt_lp L=6e-08 W=5.85e-07
MI1_MXPB1 XI1_p1 A0 VDD VDD pm1p2_svt_lp L=6e-08 W=5.85e-07
MI1_MXPB1_2 XI1_p1 A0 VDD VDD pm1p2_svt_lp L=6e-08 W=5.85e-07
MI1_MXPB2_2 XI1_p1 a1 VDD VDD pm1p2_svt_lp L=6e-08 W=5.85e-07
MI1_MXPA1 Y B0 XI1_p1 VDD pm1p2_svt_lp L=6e-08 W=5.85e-07
MI1_MXPA1_2 Y B0 XI1_p1 VDD pm1p2_svt_lp L=6e-08 W=5.85e-07
.ENDS

.SUBCKT AOI2XB1X3H9R Y VDD VSS A0 A1N B0
MI0_MXNA1 a1 A1N VSS VSS nm1p2_svt_lp L=6e-08 W=3.75e-07
MI1_MXNB2 XI1_n1 a1 VSS VSS nm1p2_svt_lp L=6e-08 W=4.1e-07
MI1_MXNB2_2 XI1_n1 a1 VSS VSS nm1p2_svt_lp L=6e-08 W=4.1e-07
MI1_MXNB2_3 XI1_n1 a1 VSS VSS nm1p2_svt_lp L=6e-08 W=4.1e-07
MI1_MXNB1 Y A0 XI1_n1 VSS nm1p2_svt_lp L=6e-08 W=4.1e-07
MI1_MXNB1_2 Y A0 XI1_n1 VSS nm1p2_svt_lp L=6e-08 W=4.1e-07
MI1_MXNB1_3 Y A0 XI1_n1 VSS nm1p2_svt_lp L=6e-08 W=4.1e-07
MI1_MXNA1 Y B0 VSS VSS nm1p2_svt_lp L=6e-08 W=2.35e-07
MI1_MXNA1_2 Y B0 VSS VSS nm1p2_svt_lp L=6e-08 W=2.35e-07
MI1_MXNA1_3 Y B0 VSS VSS nm1p2_svt_lp L=6e-08 W=2.35e-07
MI0_MXPA1 a1 A1N VDD VDD pm1p2_svt_lp L=6e-08 W=5.25e-07
MI1_MXPB2 XI1_p1 a1 VDD VDD pm1p2_svt_lp L=6e-08 W=5.85e-07
MI1_MXPB2_2 XI1_p1 a1 VDD VDD pm1p2_svt_lp L=6e-08 W=5.85e-07
MI1_MXPB2_3 XI1_p1 a1 VDD VDD pm1p2_svt_lp L=6e-08 W=5.85e-07
MI1_MXPB1 XI1_p1 A0 VDD VDD pm1p2_svt_lp L=6e-08 W=5.85e-07
MI1_MXPB1_2 XI1_p1 A0 VDD VDD pm1p2_svt_lp L=6e-08 W=5.85e-07
MI1_MXPB1_3 XI1_p1 A0 VDD VDD pm1p2_svt_lp L=6e-08 W=5.85e-07
MI1_MXPA1 Y B0 XI1_p1 VDD pm1p2_svt_lp L=6e-08 W=5.85e-07
MI1_MXPA1_2 Y B0 XI1_p1 VDD pm1p2_svt_lp L=6e-08 W=5.85e-07
MI1_MXPA1_3 Y B0 XI1_p1 VDD pm1p2_svt_lp L=6e-08 W=5.85e-07
.ENDS

.SUBCKT AOI2XB1X4H9R Y VDD VSS A0 A1N B0
MI0_MXNA1 a1 A1N VSS VSS nm1p2_svt_lp L=6e-08 W=2.55e-07
MI0_MXNA1_2 a1 A1N VSS VSS nm1p2_svt_lp L=6e-08 W=2.55e-07
MI1_MXNB2_2 XI1_n1__2 a1 VSS VSS nm1p2_svt_lp L=6e-08 W=4.1e-07
MI1_MXNB1_2 Y A0 XI1_n1__2 VSS nm1p2_svt_lp L=6e-08 W=4.1e-07
MI1_MXNB1_3 Y A0 XI1_n1__3 VSS nm1p2_svt_lp L=6e-08 W=4.1e-07
MI1_MXNB2_3 XI1_n1__3 a1 VSS VSS nm1p2_svt_lp L=6e-08 W=4.1e-07
MI1_MXNB2_4 XI1_n1__4 a1 VSS VSS nm1p2_svt_lp L=6e-08 W=4.1e-07
MI1_MXNB1_4 Y A0 XI1_n1__4 VSS nm1p2_svt_lp L=6e-08 W=4.1e-07
MI1_MXNB1 Y A0 XI1_n1 VSS nm1p2_svt_lp L=6e-08 W=4.1e-07
MI1_MXNB2 XI1_n1 a1 VSS VSS nm1p2_svt_lp L=6e-08 W=4.1e-07
MI1_MXNA1 Y B0 VSS VSS nm1p2_svt_lp L=6e-08 W=2.35e-07
MI1_MXNA1_2 Y B0 VSS VSS nm1p2_svt_lp L=6e-08 W=2.35e-07
MI1_MXNA1_3 Y B0 VSS VSS nm1p2_svt_lp L=6e-08 W=2.35e-07
MI1_MXNA1_4 Y B0 VSS VSS nm1p2_svt_lp L=6e-08 W=2.35e-07
MI0_MXPA1 a1 A1N VDD VDD pm1p2_svt_lp L=6e-08 W=3.55e-07
MI0_MXPA1_2 a1 A1N VDD VDD pm1p2_svt_lp L=6e-08 W=3.55e-07
MI1_MXPB2 XI1_p1 a1 VDD VDD pm1p2_svt_lp L=6e-08 W=5.85e-07
MI1_MXPB1 XI1_p1 A0 VDD VDD pm1p2_svt_lp L=6e-08 W=5.85e-07
MI1_MXPB1_2 XI1_p1 A0 VDD VDD pm1p2_svt_lp L=6e-08 W=5.85e-07
MI1_MXPB2_2 XI1_p1 a1 VDD VDD pm1p2_svt_lp L=6e-08 W=5.85e-07
MI1_MXPB2_3 XI1_p1 a1 VDD VDD pm1p2_svt_lp L=6e-08 W=5.85e-07
MI1_MXPB1_3 XI1_p1 A0 VDD VDD pm1p2_svt_lp L=6e-08 W=5.85e-07
MI1_MXPB1_4 XI1_p1 A0 VDD VDD pm1p2_svt_lp L=6e-08 W=5.85e-07
MI1_MXPB2_4 XI1_p1 a1 VDD VDD pm1p2_svt_lp L=6e-08 W=5.85e-07
MI1_MXPA1 Y B0 XI1_p1 VDD pm1p2_svt_lp L=6e-08 W=5.85e-07
MI1_MXPA1_2 Y B0 XI1_p1 VDD pm1p2_svt_lp L=6e-08 W=5.85e-07
MI1_MXPA1_3 Y B0 XI1_p1 VDD pm1p2_svt_lp L=6e-08 W=5.85e-07
MI1_MXPA1_4 Y B0 XI1_p1 VDD pm1p2_svt_lp L=6e-08 W=5.85e-07
.ENDS

.SUBCKT AOI2XB1X6H9R Y VDD VSS A0 A1N B0
MI0_MXNA1 a1 A1N VSS VSS nm1p2_svt_lp L=6e-08 W=3.75e-07
MI0_MXNA1_2 a1 A1N VSS VSS nm1p2_svt_lp L=6e-08 W=3.75e-07
MI1_MXNB2 XI1_n1 a1 VSS VSS nm1p2_svt_lp L=6e-08 W=4.95e-07
MI1_MXNB2_2 XI1_n1 a1 VSS VSS nm1p2_svt_lp L=6e-08 W=4.95e-07
MI1_MXNB2_3 XI1_n1 a1 VSS VSS nm1p2_svt_lp L=6e-08 W=4.95e-07
MI1_MXNB2_4 XI1_n1 a1 VSS VSS nm1p2_svt_lp L=6e-08 W=4.95e-07
MI1_MXNB2_5 XI1_n1 a1 VSS VSS nm1p2_svt_lp L=6e-08 W=4.95e-07
MI1_MXNB1 Y A0 XI1_n1 VSS nm1p2_svt_lp L=6e-08 W=4.95e-07
MI1_MXNB1_2 Y A0 XI1_n1 VSS nm1p2_svt_lp L=6e-08 W=4.95e-07
MI1_MXNB1_3 Y A0 XI1_n1 VSS nm1p2_svt_lp L=6e-08 W=4.95e-07
MI1_MXNB1_4 Y A0 XI1_n1 VSS nm1p2_svt_lp L=6e-08 W=4.95e-07
MI1_MXNB1_5 Y A0 XI1_n1 VSS nm1p2_svt_lp L=6e-08 W=4.95e-07
MI1_MXNA1 Y B0 VSS VSS nm1p2_svt_lp L=6e-08 W=2.35e-07
MI1_MXNA1_2 Y B0 VSS VSS nm1p2_svt_lp L=6e-08 W=2.35e-07
MI1_MXNA1_3 Y B0 VSS VSS nm1p2_svt_lp L=6e-08 W=2.35e-07
MI1_MXNA1_4 Y B0 VSS VSS nm1p2_svt_lp L=6e-08 W=2.35e-07
MI1_MXNA1_5 Y B0 VSS VSS nm1p2_svt_lp L=6e-08 W=2.35e-07
MI1_MXNA1_6 Y B0 VSS VSS nm1p2_svt_lp L=6e-08 W=2.35e-07
MI0_MXPA1 a1 A1N VDD VDD pm1p2_svt_lp L=6e-08 W=5.2e-07
MI0_MXPA1_2 a1 A1N VDD VDD pm1p2_svt_lp L=6e-08 W=5.2e-07
MI1_MXPB2 XI1_p1 a1 VDD VDD pm1p2_svt_lp L=6e-08 W=5.85e-07
MI1_MXPB2_2 XI1_p1 a1 VDD VDD pm1p2_svt_lp L=6e-08 W=5.85e-07
MI1_MXPB2_3 XI1_p1 a1 VDD VDD pm1p2_svt_lp L=6e-08 W=5.85e-07
MI1_MXPB2_4 XI1_p1 a1 VDD VDD pm1p2_svt_lp L=6e-08 W=5.85e-07
MI1_MXPB2_5 XI1_p1 a1 VDD VDD pm1p2_svt_lp L=6e-08 W=5.85e-07
MI1_MXPB2_6 XI1_p1 a1 VDD VDD pm1p2_svt_lp L=6e-08 W=5.85e-07
MI1_MXPB1 XI1_p1 A0 VDD VDD pm1p2_svt_lp L=6e-08 W=5.85e-07
MI1_MXPB1_2 XI1_p1 A0 VDD VDD pm1p2_svt_lp L=6e-08 W=5.85e-07
MI1_MXPB1_3 XI1_p1 A0 VDD VDD pm1p2_svt_lp L=6e-08 W=5.85e-07
MI1_MXPB1_4 XI1_p1 A0 VDD VDD pm1p2_svt_lp L=6e-08 W=5.85e-07
MI1_MXPB1_5 XI1_p1 A0 VDD VDD pm1p2_svt_lp L=6e-08 W=5.85e-07
MI1_MXPB1_6 XI1_p1 A0 VDD VDD pm1p2_svt_lp L=6e-08 W=5.85e-07
MI1_MXPA1 Y B0 XI1_p1 VDD pm1p2_svt_lp L=6e-08 W=5.85e-07
MI1_MXPA1_2 Y B0 XI1_p1 VDD pm1p2_svt_lp L=6e-08 W=5.85e-07
MI1_MXPA1_3 Y B0 XI1_p1 VDD pm1p2_svt_lp L=6e-08 W=5.85e-07
MI1_MXPA1_4 Y B0 XI1_p1 VDD pm1p2_svt_lp L=6e-08 W=5.85e-07
MI1_MXPA1_5 Y B0 XI1_p1 VDD pm1p2_svt_lp L=6e-08 W=5.85e-07
MI1_MXPA1_6 Y B0 XI1_p1 VDD pm1p2_svt_lp L=6e-08 W=5.85e-07
.ENDS

.SUBCKT AOI2XB1X8H9R Y VDD VSS A0 A1N B0
MI0_MXNA1 a1 A1N VSS VSS nm1p2_svt_lp L=6e-08 W=3.4e-07
MI0_MXNA1_2 a1 A1N VSS VSS nm1p2_svt_lp L=6e-08 W=3.4e-07
MI0_MXNA1_3 a1 A1N VSS VSS nm1p2_svt_lp L=6e-08 W=3.4e-07
MI1_MXNB2 XI1_n1 a1 VSS VSS nm1p2_svt_lp L=6e-08 W=4.7e-07
MI1_MXNB2_2 XI1_n1 a1 VSS VSS nm1p2_svt_lp L=6e-08 W=4.7e-07
MI1_MXNB2_3 XI1_n1 a1 VSS VSS nm1p2_svt_lp L=6e-08 W=4.7e-07
MI1_MXNB2_4 XI1_n1 a1 VSS VSS nm1p2_svt_lp L=6e-08 W=4.7e-07
MI1_MXNB2_5 XI1_n1 a1 VSS VSS nm1p2_svt_lp L=6e-08 W=4.7e-07
MI1_MXNB2_6 XI1_n1 a1 VSS VSS nm1p2_svt_lp L=6e-08 W=4.7e-07
MI1_MXNB2_7 XI1_n1 a1 VSS VSS nm1p2_svt_lp L=6e-08 W=4.7e-07
MI1_MXNB1 Y A0 XI1_n1 VSS nm1p2_svt_lp L=6e-08 W=4.7e-07
MI1_MXNB1_2 Y A0 XI1_n1 VSS nm1p2_svt_lp L=6e-08 W=4.7e-07
MI1_MXNB1_3 Y A0 XI1_n1 VSS nm1p2_svt_lp L=6e-08 W=4.7e-07
MI1_MXNB1_4 Y A0 XI1_n1 VSS nm1p2_svt_lp L=6e-08 W=4.7e-07
MI1_MXNB1_5 Y A0 XI1_n1 VSS nm1p2_svt_lp L=6e-08 W=4.7e-07
MI1_MXNB1_6 Y A0 XI1_n1 VSS nm1p2_svt_lp L=6e-08 W=4.7e-07
MI1_MXNB1_7 Y A0 XI1_n1 VSS nm1p2_svt_lp L=6e-08 W=4.7e-07
MI1_MXNA1 Y B0 VSS VSS nm1p2_svt_lp L=6e-08 W=2.35e-07
MI1_MXNA1_2 Y B0 VSS VSS nm1p2_svt_lp L=6e-08 W=2.35e-07
MI1_MXNA1_3 Y B0 VSS VSS nm1p2_svt_lp L=6e-08 W=2.35e-07
MI1_MXNA1_4 Y B0 VSS VSS nm1p2_svt_lp L=6e-08 W=2.35e-07
MI1_MXNA1_5 Y B0 VSS VSS nm1p2_svt_lp L=6e-08 W=2.35e-07
MI1_MXNA1_6 Y B0 VSS VSS nm1p2_svt_lp L=6e-08 W=2.35e-07
MI1_MXNA1_7 Y B0 VSS VSS nm1p2_svt_lp L=6e-08 W=2.35e-07
MI1_MXNA1_8 Y B0 VSS VSS nm1p2_svt_lp L=6e-08 W=2.35e-07
MI0_MXPA1 a1 A1N VDD VDD pm1p2_svt_lp L=6e-08 W=4.75e-07
MI0_MXPA1_2 a1 A1N VDD VDD pm1p2_svt_lp L=6e-08 W=4.75e-07
MI0_MXPA1_3 a1 A1N VDD VDD pm1p2_svt_lp L=6e-08 W=4.75e-07
MI1_MXPB2 XI1_p1 a1 VDD VDD pm1p2_svt_lp L=6e-08 W=5.85e-07
MI1_MXPB2_2 XI1_p1 a1 VDD VDD pm1p2_svt_lp L=6e-08 W=5.85e-07
MI1_MXPB2_3 XI1_p1 a1 VDD VDD pm1p2_svt_lp L=6e-08 W=5.85e-07
MI1_MXPB2_4 XI1_p1 a1 VDD VDD pm1p2_svt_lp L=6e-08 W=5.85e-07
MI1_MXPB2_5 XI1_p1 a1 VDD VDD pm1p2_svt_lp L=6e-08 W=5.85e-07
MI1_MXPB2_6 XI1_p1 a1 VDD VDD pm1p2_svt_lp L=6e-08 W=5.85e-07
MI1_MXPB2_7 XI1_p1 a1 VDD VDD pm1p2_svt_lp L=6e-08 W=5.85e-07
MI1_MXPB2_8 XI1_p1 a1 VDD VDD pm1p2_svt_lp L=6e-08 W=5.85e-07
MI1_MXPB1 XI1_p1 A0 VDD VDD pm1p2_svt_lp L=6e-08 W=5.85e-07
MI1_MXPB1_2 XI1_p1 A0 VDD VDD pm1p2_svt_lp L=6e-08 W=5.85e-07
MI1_MXPB1_3 XI1_p1 A0 VDD VDD pm1p2_svt_lp L=6e-08 W=5.85e-07
MI1_MXPB1_4 XI1_p1 A0 VDD VDD pm1p2_svt_lp L=6e-08 W=5.85e-07
MI1_MXPB1_5 XI1_p1 A0 VDD VDD pm1p2_svt_lp L=6e-08 W=5.85e-07
MI1_MXPB1_6 XI1_p1 A0 VDD VDD pm1p2_svt_lp L=6e-08 W=5.85e-07
MI1_MXPB1_7 XI1_p1 A0 VDD VDD pm1p2_svt_lp L=6e-08 W=5.85e-07
MI1_MXPB1_8 XI1_p1 A0 VDD VDD pm1p2_svt_lp L=6e-08 W=5.85e-07
MI1_MXPA1 Y B0 XI1_p1 VDD pm1p2_svt_lp L=6e-08 W=5.85e-07
MI1_MXPA1_2 Y B0 XI1_p1 VDD pm1p2_svt_lp L=6e-08 W=5.85e-07
MI1_MXPA1_3 Y B0 XI1_p1 VDD pm1p2_svt_lp L=6e-08 W=5.85e-07
MI1_MXPA1_4 Y B0 XI1_p1 VDD pm1p2_svt_lp L=6e-08 W=5.85e-07
MI1_MXPA1_5 Y B0 XI1_p1 VDD pm1p2_svt_lp L=6e-08 W=5.85e-07
MI1_MXPA1_6 Y B0 XI1_p1 VDD pm1p2_svt_lp L=6e-08 W=5.85e-07
MI1_MXPA1_7 Y B0 XI1_p1 VDD pm1p2_svt_lp L=6e-08 W=5.85e-07
MI1_MXPA1_8 Y B0 XI1_p1 VDD pm1p2_svt_lp L=6e-08 W=5.85e-07
.ENDS

.SUBCKT AOI21BX0P5H9R Y VDD VSS A0 A1 B0N
MI1_MXNB2 XI1_n1 A1 VSS VSS nm1p2_svt_lp L=6e-08 W=2.65e-07
MI1_MXNB1 Y A0 XI1_n1 VSS nm1p2_svt_lp L=6e-08 W=2.65e-07
MI1_MXNA1 Y b0 VSS VSS nm1p2_svt_lp L=6e-08 W=1.5e-07
MI0_MXNA1 b0 B0N VSS VSS nm1p2_svt_lp L=6e-08 W=1.5e-07
MI1_MXPB2 XI1_p1 A1 VDD VDD pm1p2_svt_lp L=6e-08 W=3.75e-07
MI1_MXPB1 XI1_p1 A0 VDD VDD pm1p2_svt_lp L=6e-08 W=3.75e-07
MI1_MXPA1 Y b0 XI1_p1 VDD pm1p2_svt_lp L=6e-08 W=3.75e-07
MI0_MXPA1 b0 B0N VDD VDD pm1p2_svt_lp L=6e-08 W=2.1e-07
.ENDS

.SUBCKT AOI21BX0P7H9R Y VDD VSS A0 A1 B0N
MI1_MXNB2 XI1_n1 A1 VSS VSS nm1p2_svt_lp L=6e-08 W=2.9e-07
MI1_MXNB1 Y A0 XI1_n1 VSS nm1p2_svt_lp L=6e-08 W=2.9e-07
MI1_MXNA1 Y b0 VSS VSS nm1p2_svt_lp L=6e-08 W=1.65e-07
MI0_MXNA1 b0 B0N VSS VSS nm1p2_svt_lp L=6e-08 W=1.5e-07
MI1_MXPB2 XI1_p1 A1 VDD VDD pm1p2_svt_lp L=6e-08 W=4.15e-07
MI1_MXPB1 XI1_p1 A0 VDD VDD pm1p2_svt_lp L=6e-08 W=4.15e-07
MI1_MXPA1 Y b0 XI1_p1 VDD pm1p2_svt_lp L=6e-08 W=4.15e-07
MI0_MXPA1 b0 B0N VDD VDD pm1p2_svt_lp L=6e-08 W=2.1e-07
.ENDS

.SUBCKT AOI21BX1H9R Y VDD VSS A0 A1 B0N
MI1_MXNB2 XI1_n1 A1 VSS VSS nm1p2_svt_lp L=6e-08 W=4.1e-07
MI1_MXNB1 Y A0 XI1_n1 VSS nm1p2_svt_lp L=6e-08 W=4.1e-07
MI1_MXNA1 Y b0 VSS VSS nm1p2_svt_lp L=6e-08 W=2.35e-07
MI0_MXNA1 b0 B0N VSS VSS nm1p2_svt_lp L=6e-08 W=1.5e-07
MI1_MXPB2 XI1_p1 A1 VDD VDD pm1p2_svt_lp L=6e-08 W=5.85e-07
MI1_MXPB1 XI1_p1 A0 VDD VDD pm1p2_svt_lp L=6e-08 W=5.85e-07
MI1_MXPA1 Y b0 XI1_p1 VDD pm1p2_svt_lp L=6e-08 W=5.85e-07
MI0_MXPA1 b0 B0N VDD VDD pm1p2_svt_lp L=6e-08 W=2.1e-07
.ENDS

.SUBCKT AOI21BX1P4H9R Y VDD VSS A0 A1 B0N
MI1_MXNB2 XI1_n1 A1 VSS VSS nm1p2_svt_lp L=6e-08 W=2.9e-07
MI1_MXNB2_2 XI1_n1 A1 VSS VSS nm1p2_svt_lp L=6e-08 W=2.9e-07
MI1_MXNB1 Y A0 XI1_n1 VSS nm1p2_svt_lp L=6e-08 W=2.9e-07
MI1_MXNB1_2 Y A0 XI1_n1 VSS nm1p2_svt_lp L=6e-08 W=2.9e-07
MI1_MXNA1 Y b0 VSS VSS nm1p2_svt_lp L=6e-08 W=3.3e-07
MI0_MXNA1 b0 B0N VSS VSS nm1p2_svt_lp L=6e-08 W=1.75e-07
MI1_MXPB2 XI1_p1 A1 VDD VDD pm1p2_svt_lp L=6e-08 W=4.15e-07
MI1_MXPB2_2 XI1_p1 A1 VDD VDD pm1p2_svt_lp L=6e-08 W=4.15e-07
MI1_MXPB1 XI1_p1 A0 VDD VDD pm1p2_svt_lp L=6e-08 W=4.15e-07
MI1_MXPB1_2 XI1_p1 A0 VDD VDD pm1p2_svt_lp L=6e-08 W=4.15e-07
MI1_MXPA1 Y b0 XI1_p1 VDD pm1p2_svt_lp L=6e-08 W=4.15e-07
MI1_MXPA1_2 Y b0 XI1_p1 VDD pm1p2_svt_lp L=6e-08 W=4.15e-07
MI0_MXPA1 b0 B0N VDD VDD pm1p2_svt_lp L=6e-08 W=2.45e-07
.ENDS

.SUBCKT AOI21BX2H9R Y VDD VSS A0 A1 B0N
MI1_MXNB2 XI1_n1 A1 VSS VSS nm1p2_svt_lp L=6e-08 W=4.1e-07
MI1_MXNB2_2 XI1_n1 A1 VSS VSS nm1p2_svt_lp L=6e-08 W=4.1e-07
MI1_MXNB1 Y A0 XI1_n1 VSS nm1p2_svt_lp L=6e-08 W=4.1e-07
MI1_MXNB1_2 Y A0 XI1_n1 VSS nm1p2_svt_lp L=6e-08 W=4.1e-07
MI1_MXNA1 Y b0 VSS VSS nm1p2_svt_lp L=6e-08 W=4.7e-07
MI0_MXNA1 b0 B0N VSS VSS nm1p2_svt_lp L=6e-08 W=2.25e-07
MI1_MXPB2 XI1_p1 A1 VDD VDD pm1p2_svt_lp L=6e-08 W=5.85e-07
MI1_MXPB2_2 XI1_p1 A1 VDD VDD pm1p2_svt_lp L=6e-08 W=5.85e-07
MI1_MXPB1 XI1_p1 A0 VDD VDD pm1p2_svt_lp L=6e-08 W=5.85e-07
MI1_MXPB1_2 XI1_p1 A0 VDD VDD pm1p2_svt_lp L=6e-08 W=5.85e-07
MI1_MXPA1 Y b0 XI1_p1 VDD pm1p2_svt_lp L=6e-08 W=5.85e-07
MI1_MXPA1_2 Y b0 XI1_p1 VDD pm1p2_svt_lp L=6e-08 W=5.85e-07
MI0_MXPA1 b0 B0N VDD VDD pm1p2_svt_lp L=6e-08 W=3.15e-07
.ENDS

.SUBCKT AOI21BX3H9R Y VDD VSS A0 A1 B0N
MI1_MXNB2 XI1_n1 A1 VSS VSS nm1p2_svt_lp L=6e-08 W=4.1e-07
MI1_MXNB2_2 XI1_n1 A1 VSS VSS nm1p2_svt_lp L=6e-08 W=4.1e-07
MI1_MXNB2_3 XI1_n1 A1 VSS VSS nm1p2_svt_lp L=6e-08 W=4.1e-07
MI1_MXNB1 Y A0 XI1_n1 VSS nm1p2_svt_lp L=6e-08 W=4.1e-07
MI1_MXNB1_2 Y A0 XI1_n1 VSS nm1p2_svt_lp L=6e-08 W=4.1e-07
MI1_MXNB1_3 Y A0 XI1_n1 VSS nm1p2_svt_lp L=6e-08 W=4.1e-07
MI1_MXNA1 Y b0 VSS VSS nm1p2_svt_lp L=6e-08 W=3.55e-07
MI1_MXNA1_2 Y b0 VSS VSS nm1p2_svt_lp L=6e-08 W=3.55e-07
MI0_MXNA1 b0 B0N VSS VSS nm1p2_svt_lp L=6e-08 W=3.2e-07
MI1_MXPB2 XI1_p1 A1 VDD VDD pm1p2_svt_lp L=6e-08 W=5.85e-07
MI1_MXPB2_2 XI1_p1 A1 VDD VDD pm1p2_svt_lp L=6e-08 W=5.85e-07
MI1_MXPB2_3 XI1_p1 A1 VDD VDD pm1p2_svt_lp L=6e-08 W=5.85e-07
MI1_MXPB1 XI1_p1 A0 VDD VDD pm1p2_svt_lp L=6e-08 W=5.85e-07
MI1_MXPB1_2 XI1_p1 A0 VDD VDD pm1p2_svt_lp L=6e-08 W=5.85e-07
MI1_MXPB1_3 XI1_p1 A0 VDD VDD pm1p2_svt_lp L=6e-08 W=5.85e-07
MI1_MXPA1 Y b0 XI1_p1 VDD pm1p2_svt_lp L=6e-08 W=5.85e-07
MI1_MXPA1_2 Y b0 XI1_p1 VDD pm1p2_svt_lp L=6e-08 W=5.85e-07
MI1_MXPA1_3 Y b0 XI1_p1 VDD pm1p2_svt_lp L=6e-08 W=5.85e-07
MI0_MXPA1 b0 B0N VDD VDD pm1p2_svt_lp L=6e-08 W=4.5e-07
.ENDS

.SUBCKT AOI21BX4H9R Y VDD VSS A0 A1 B0N
MI1_MXNB2 XI1_n1 A1 VSS VSS nm1p2_svt_lp L=6e-08 W=4.1e-07
MI1_MXNB2_2 XI1_n1 A1 VSS VSS nm1p2_svt_lp L=6e-08 W=4.1e-07
MI1_MXNB2_3 XI1_n1 A1 VSS VSS nm1p2_svt_lp L=6e-08 W=4.1e-07
MI1_MXNB2_4 XI1_n1 A1 VSS VSS nm1p2_svt_lp L=6e-08 W=4.1e-07
MI1_MXNB1 Y A0 XI1_n1 VSS nm1p2_svt_lp L=6e-08 W=4.1e-07
MI1_MXNB1_2 Y A0 XI1_n1 VSS nm1p2_svt_lp L=6e-08 W=4.1e-07
MI1_MXNB1_3 Y A0 XI1_n1 VSS nm1p2_svt_lp L=6e-08 W=4.1e-07
MI1_MXNB1_4 Y A0 XI1_n1 VSS nm1p2_svt_lp L=6e-08 W=4.1e-07
MI1_MXNA1 Y b0 VSS VSS nm1p2_svt_lp L=6e-08 W=4.7e-07
MI1_MXNA1_2 Y b0 VSS VSS nm1p2_svt_lp L=6e-08 W=4.7e-07
MI0_MXNA1 b0 B0N VSS VSS nm1p2_svt_lp L=6e-08 W=4.2e-07
MI1_MXPB2 XI1_p1 A1 VDD VDD pm1p2_svt_lp L=6e-08 W=5.85e-07
MI1_MXPB2_2 XI1_p1 A1 VDD VDD pm1p2_svt_lp L=6e-08 W=5.85e-07
MI1_MXPB2_3 XI1_p1 A1 VDD VDD pm1p2_svt_lp L=6e-08 W=5.85e-07
MI1_MXPB2_4 XI1_p1 A1 VDD VDD pm1p2_svt_lp L=6e-08 W=5.85e-07
MI1_MXPB1 XI1_p1 A0 VDD VDD pm1p2_svt_lp L=6e-08 W=5.85e-07
MI1_MXPB1_2 XI1_p1 A0 VDD VDD pm1p2_svt_lp L=6e-08 W=5.85e-07
MI1_MXPB1_3 XI1_p1 A0 VDD VDD pm1p2_svt_lp L=6e-08 W=5.85e-07
MI1_MXPB1_4 XI1_p1 A0 VDD VDD pm1p2_svt_lp L=6e-08 W=5.85e-07
MI1_MXPA1 Y b0 XI1_p1 VDD pm1p2_svt_lp L=6e-08 W=5.85e-07
MI1_MXPA1_2 Y b0 XI1_p1 VDD pm1p2_svt_lp L=6e-08 W=5.85e-07
MI1_MXPA1_3 Y b0 XI1_p1 VDD pm1p2_svt_lp L=6e-08 W=5.85e-07
MI1_MXPA1_4 Y b0 XI1_p1 VDD pm1p2_svt_lp L=6e-08 W=5.85e-07
MI0_MXPA1 b0 B0N VDD VDD pm1p2_svt_lp L=6e-08 W=5.85e-07
.ENDS

.SUBCKT AOI21BX6H9R Y VDD VSS A0 A1 B0N
MI1_MXNB2 XI1_n1 A1 VSS VSS nm1p2_svt_lp L=6e-08 W=4.1e-07
MI1_MXNB2_2 XI1_n1 A1 VSS VSS nm1p2_svt_lp L=6e-08 W=4.1e-07
MI1_MXNB2_3 XI1_n1 A1 VSS VSS nm1p2_svt_lp L=6e-08 W=4.1e-07
MI1_MXNB2_4 XI1_n1 A1 VSS VSS nm1p2_svt_lp L=6e-08 W=4.1e-07
MI1_MXNB2_5 XI1_n1 A1 VSS VSS nm1p2_svt_lp L=6e-08 W=4.1e-07
MI1_MXNB2_6 XI1_n1 A1 VSS VSS nm1p2_svt_lp L=6e-08 W=4.1e-07
MI1_MXNB1 Y A0 XI1_n1 VSS nm1p2_svt_lp L=6e-08 W=4.1e-07
MI1_MXNB1_2 Y A0 XI1_n1 VSS nm1p2_svt_lp L=6e-08 W=4.1e-07
MI1_MXNB1_3 Y A0 XI1_n1 VSS nm1p2_svt_lp L=6e-08 W=4.1e-07
MI1_MXNB1_4 Y A0 XI1_n1 VSS nm1p2_svt_lp L=6e-08 W=4.1e-07
MI1_MXNB1_5 Y A0 XI1_n1 VSS nm1p2_svt_lp L=6e-08 W=4.1e-07
MI1_MXNB1_6 Y A0 XI1_n1 VSS nm1p2_svt_lp L=6e-08 W=4.1e-07
MI1_MXNA1 Y b0 VSS VSS nm1p2_svt_lp L=6e-08 W=4.7e-07
MI1_MXNA1_2 Y b0 VSS VSS nm1p2_svt_lp L=6e-08 W=4.7e-07
MI1_MXNA1_3 Y b0 VSS VSS nm1p2_svt_lp L=6e-08 W=4.7e-07
MI0_MXNA1 b0 B0N VSS VSS nm1p2_svt_lp L=6e-08 W=3.2e-07
MI0_MXNA1_2 b0 B0N VSS VSS nm1p2_svt_lp L=6e-08 W=3.2e-07
MI1_MXPB2 XI1_p1 A1 VDD VDD pm1p2_svt_lp L=6e-08 W=5.85e-07
MI1_MXPB2_2 XI1_p1 A1 VDD VDD pm1p2_svt_lp L=6e-08 W=5.85e-07
MI1_MXPB2_3 XI1_p1 A1 VDD VDD pm1p2_svt_lp L=6e-08 W=5.85e-07
MI1_MXPB2_4 XI1_p1 A1 VDD VDD pm1p2_svt_lp L=6e-08 W=5.85e-07
MI1_MXPB2_5 XI1_p1 A1 VDD VDD pm1p2_svt_lp L=6e-08 W=5.85e-07
MI1_MXPB2_6 XI1_p1 A1 VDD VDD pm1p2_svt_lp L=6e-08 W=5.85e-07
MI1_MXPB1 XI1_p1 A0 VDD VDD pm1p2_svt_lp L=6e-08 W=5.85e-07
MI1_MXPB1_2 XI1_p1 A0 VDD VDD pm1p2_svt_lp L=6e-08 W=5.85e-07
MI1_MXPB1_3 XI1_p1 A0 VDD VDD pm1p2_svt_lp L=6e-08 W=5.85e-07
MI1_MXPB1_4 XI1_p1 A0 VDD VDD pm1p2_svt_lp L=6e-08 W=5.85e-07
MI1_MXPB1_5 XI1_p1 A0 VDD VDD pm1p2_svt_lp L=6e-08 W=5.85e-07
MI1_MXPB1_6 XI1_p1 A0 VDD VDD pm1p2_svt_lp L=6e-08 W=5.85e-07
MI1_MXPA1 Y b0 XI1_p1 VDD pm1p2_svt_lp L=6e-08 W=5.85e-07
MI1_MXPA1_2 Y b0 XI1_p1 VDD pm1p2_svt_lp L=6e-08 W=5.85e-07
MI1_MXPA1_3 Y b0 XI1_p1 VDD pm1p2_svt_lp L=6e-08 W=5.85e-07
MI1_MXPA1_4 Y b0 XI1_p1 VDD pm1p2_svt_lp L=6e-08 W=5.85e-07
MI1_MXPA1_5 Y b0 XI1_p1 VDD pm1p2_svt_lp L=6e-08 W=5.85e-07
MI1_MXPA1_6 Y b0 XI1_p1 VDD pm1p2_svt_lp L=6e-08 W=5.85e-07
MI0_MXPA1 b0 B0N VDD VDD pm1p2_svt_lp L=6e-08 W=4.45e-07
MI0_MXPA1_2 b0 B0N VDD VDD pm1p2_svt_lp L=6e-08 W=4.45e-07
.ENDS

.SUBCKT AOI21BX8H9R Y VDD VSS A0 A1 B0N
MI1_MXNB2 XI1_n1 A1 VSS VSS nm1p2_svt_lp L=6e-08 W=4.1e-07
MI1_MXNB2_2 XI1_n1 A1 VSS VSS nm1p2_svt_lp L=6e-08 W=4.1e-07
MI1_MXNB2_3 XI1_n1 A1 VSS VSS nm1p2_svt_lp L=6e-08 W=4.1e-07
MI1_MXNB2_4 XI1_n1 A1 VSS VSS nm1p2_svt_lp L=6e-08 W=4.1e-07
MI1_MXNB2_5 XI1_n1 A1 VSS VSS nm1p2_svt_lp L=6e-08 W=4.1e-07
MI1_MXNB2_6 XI1_n1 A1 VSS VSS nm1p2_svt_lp L=6e-08 W=4.1e-07
MI1_MXNB2_7 XI1_n1 A1 VSS VSS nm1p2_svt_lp L=6e-08 W=4.1e-07
MI1_MXNB2_8 XI1_n1 A1 VSS VSS nm1p2_svt_lp L=6e-08 W=4.1e-07
MI1_MXNB1 Y A0 XI1_n1 VSS nm1p2_svt_lp L=6e-08 W=4.1e-07
MI1_MXNB1_2 Y A0 XI1_n1 VSS nm1p2_svt_lp L=6e-08 W=4.1e-07
MI1_MXNB1_3 Y A0 XI1_n1 VSS nm1p2_svt_lp L=6e-08 W=4.1e-07
MI1_MXNB1_4 Y A0 XI1_n1 VSS nm1p2_svt_lp L=6e-08 W=4.1e-07
MI1_MXNB1_5 Y A0 XI1_n1 VSS nm1p2_svt_lp L=6e-08 W=4.1e-07
MI1_MXNB1_6 Y A0 XI1_n1 VSS nm1p2_svt_lp L=6e-08 W=4.1e-07
MI1_MXNB1_7 Y A0 XI1_n1 VSS nm1p2_svt_lp L=6e-08 W=4.1e-07
MI1_MXNB1_8 Y A0 XI1_n1 VSS nm1p2_svt_lp L=6e-08 W=4.1e-07
MI1_MXNA1 Y b0 VSS VSS nm1p2_svt_lp L=6e-08 W=4.7e-07
MI1_MXNA1_2 Y b0 VSS VSS nm1p2_svt_lp L=6e-08 W=4.7e-07
MI1_MXNA1_3 Y b0 VSS VSS nm1p2_svt_lp L=6e-08 W=4.7e-07
MI1_MXNA1_4 Y b0 VSS VSS nm1p2_svt_lp L=6e-08 W=4.7e-07
MI0_MXNA1 b0 B0N VSS VSS nm1p2_svt_lp L=6e-08 W=4.2e-07
MI0_MXNA1_2 b0 B0N VSS VSS nm1p2_svt_lp L=6e-08 W=4.2e-07
MI1_MXPB2 XI1_p1 A1 VDD VDD pm1p2_svt_lp L=6e-08 W=5.85e-07
MI1_MXPB2_2 XI1_p1 A1 VDD VDD pm1p2_svt_lp L=6e-08 W=5.85e-07
MI1_MXPB2_3 XI1_p1 A1 VDD VDD pm1p2_svt_lp L=6e-08 W=5.85e-07
MI1_MXPB2_4 XI1_p1 A1 VDD VDD pm1p2_svt_lp L=6e-08 W=5.85e-07
MI1_MXPB2_5 XI1_p1 A1 VDD VDD pm1p2_svt_lp L=6e-08 W=5.85e-07
MI1_MXPB2_6 XI1_p1 A1 VDD VDD pm1p2_svt_lp L=6e-08 W=5.85e-07
MI1_MXPB2_7 XI1_p1 A1 VDD VDD pm1p2_svt_lp L=6e-08 W=5.85e-07
MI1_MXPB2_8 XI1_p1 A1 VDD VDD pm1p2_svt_lp L=6e-08 W=5.85e-07
MI1_MXPB1 XI1_p1 A0 VDD VDD pm1p2_svt_lp L=6e-08 W=5.85e-07
MI1_MXPB1_2 XI1_p1 A0 VDD VDD pm1p2_svt_lp L=6e-08 W=5.85e-07
MI1_MXPB1_3 XI1_p1 A0 VDD VDD pm1p2_svt_lp L=6e-08 W=5.85e-07
MI1_MXPB1_4 XI1_p1 A0 VDD VDD pm1p2_svt_lp L=6e-08 W=5.85e-07
MI1_MXPB1_5 XI1_p1 A0 VDD VDD pm1p2_svt_lp L=6e-08 W=5.85e-07
MI1_MXPB1_6 XI1_p1 A0 VDD VDD pm1p2_svt_lp L=6e-08 W=5.85e-07
MI1_MXPB1_7 XI1_p1 A0 VDD VDD pm1p2_svt_lp L=6e-08 W=5.85e-07
MI1_MXPB1_8 XI1_p1 A0 VDD VDD pm1p2_svt_lp L=6e-08 W=5.85e-07
MI1_MXPA1 Y b0 XI1_p1 VDD pm1p2_svt_lp L=6e-08 W=5.85e-07
MI1_MXPA1_2 Y b0 XI1_p1 VDD pm1p2_svt_lp L=6e-08 W=5.85e-07
MI1_MXPA1_3 Y b0 XI1_p1 VDD pm1p2_svt_lp L=6e-08 W=5.85e-07
MI1_MXPA1_4 Y b0 XI1_p1 VDD pm1p2_svt_lp L=6e-08 W=5.85e-07
MI1_MXPA1_5 Y b0 XI1_p1 VDD pm1p2_svt_lp L=6e-08 W=5.85e-07
MI1_MXPA1_6 Y b0 XI1_p1 VDD pm1p2_svt_lp L=6e-08 W=5.85e-07
MI1_MXPA1_7 Y b0 XI1_p1 VDD pm1p2_svt_lp L=6e-08 W=5.85e-07
MI1_MXPA1_8 Y b0 XI1_p1 VDD pm1p2_svt_lp L=6e-08 W=5.85e-07
MI0_MXPA1 b0 B0N VDD VDD pm1p2_svt_lp L=6e-08 W=5.85e-07
MI0_MXPA1_2 b0 B0N VDD VDD pm1p2_svt_lp L=6e-08 W=5.85e-07
.ENDS

.SUBCKT AO22X0P5H9R Y VDD VSS A0 A1 B0 B1
MI0_MXNB2 XI0_n1B A1 VSS VSS nm1p2_svt_lp L=6e-08 W=2.65e-07
MI0_MXNB1 ny A0 XI0_n1B VSS nm1p2_svt_lp L=6e-08 W=2.65e-07
MI0_MXNA1 ny B0 XI0_n1A VSS nm1p2_svt_lp L=6e-08 W=2.65e-07
MI0_MXNA2 XI0_n1A B1 VSS VSS nm1p2_svt_lp L=6e-08 W=2.65e-07
MI1_MXNA1 Y ny VSS VSS nm1p2_svt_lp L=6e-08 W=2.1e-07
MI0_MXPB2 XI0_p1 A1 VDD VDD pm1p2_svt_lp L=6e-08 W=3.75e-07
MI0_MXPB1 XI0_p1 A0 VDD VDD pm1p2_svt_lp L=6e-08 W=3.75e-07
MI0_MXPA1 ny B0 XI0_p1 VDD pm1p2_svt_lp L=6e-08 W=3.75e-07
MI0_MXPA2 ny B1 XI0_p1 VDD pm1p2_svt_lp L=6e-08 W=3.75e-07
MI1_MXPA1 Y ny VDD VDD pm1p2_svt_lp L=6e-08 W=2.95e-07
.ENDS

.SUBCKT AO22X0P7H9R Y VDD VSS A0 A1 B0 B1
MI0_MXNB2 XI0_n1B A1 VSS VSS nm1p2_svt_lp L=6e-08 W=3.1e-07
MI0_MXNB1 ny A0 XI0_n1B VSS nm1p2_svt_lp L=6e-08 W=3.1e-07
MI0_MXNA1 ny B0 XI0_n1A VSS nm1p2_svt_lp L=6e-08 W=3.1e-07
MI0_MXNA2 XI0_n1A B1 VSS VSS nm1p2_svt_lp L=6e-08 W=3.1e-07
MI1_MXNA1 Y ny VSS VSS nm1p2_svt_lp L=6e-08 W=2.95e-07
MI0_MXPB2 XI0_p1 A1 VDD VDD pm1p2_svt_lp L=6e-08 W=4.4e-07
MI0_MXPB1 XI0_p1 A0 VDD VDD pm1p2_svt_lp L=6e-08 W=4.4e-07
MI0_MXPA1 ny B0 XI0_p1 VDD pm1p2_svt_lp L=6e-08 W=4.4e-07
MI0_MXPA2 ny B1 XI0_p1 VDD pm1p2_svt_lp L=6e-08 W=4.4e-07
MI1_MXPA1 Y ny VDD VDD pm1p2_svt_lp L=6e-08 W=4.15e-07
.ENDS

.SUBCKT AO22X1H9R Y VDD VSS A0 A1 B0 B1
MI0_MXNB2 XI0_n1B A1 VSS VSS nm1p2_svt_lp L=6e-08 W=3.8e-07
MI0_MXNB1 ny A0 XI0_n1B VSS nm1p2_svt_lp L=6e-08 W=3.8e-07
MI0_MXNA1 ny B0 XI0_n1A VSS nm1p2_svt_lp L=6e-08 W=3.8e-07
MI0_MXNA2 XI0_n1A B1 VSS VSS nm1p2_svt_lp L=6e-08 W=3.8e-07
MI1_MXNA1 Y ny VSS VSS nm1p2_svt_lp L=6e-08 W=4.2e-07
MI0_MXPB2 XI0_p1 A1 VDD VDD pm1p2_svt_lp L=6e-08 W=5.35e-07
MI0_MXPB1 XI0_p1 A0 VDD VDD pm1p2_svt_lp L=6e-08 W=5.35e-07
MI0_MXPA1 ny B0 XI0_p1 VDD pm1p2_svt_lp L=6e-08 W=5.35e-07
MI0_MXPA2 ny B1 XI0_p1 VDD pm1p2_svt_lp L=6e-08 W=5.35e-07
MI1_MXPA1 Y ny VDD VDD pm1p2_svt_lp L=6e-08 W=5.85e-07
.ENDS

.SUBCKT AO22X1P4H9R Y VDD VSS A0 A1 B0 B1
MI0_MXNB2_2 XI0_n1B__2 A1 VSS VSS nm1p2_svt_lp L=6e-08 W=3.15e-07
MI0_MXNB1_2 ny A0 XI0_n1B__2 VSS nm1p2_svt_lp L=6e-08 W=3.15e-07
MI0_MXNB1 ny A0 XI0_n1B VSS nm1p2_svt_lp L=6e-08 W=3.15e-07
MI0_MXNB2 XI0_n1B A1 VSS VSS nm1p2_svt_lp L=6e-08 W=3.15e-07
MI0_MXNA2_2 XI0_n1A__2 B1 VSS VSS nm1p2_svt_lp L=6e-08 W=3.15e-07
MI0_MXNA1_2 ny B0 XI0_n1A__2 VSS nm1p2_svt_lp L=6e-08 W=3.15e-07
MI0_MXNA1 ny B0 XI0_n1A VSS nm1p2_svt_lp L=6e-08 W=3.15e-07
MI0_MXNA2 XI0_n1A B1 VSS VSS nm1p2_svt_lp L=6e-08 W=3.15e-07
MI1_MXNA1 Y ny VSS VSS nm1p2_svt_lp L=6e-08 W=2.95e-07
MI1_MXNA1_2 Y ny VSS VSS nm1p2_svt_lp L=6e-08 W=2.95e-07
MI0_MXPB2 XI0_p1 A1 VDD VDD pm1p2_svt_lp L=6e-08 W=4.45e-07
MI0_MXPB1 XI0_p1 A0 VDD VDD pm1p2_svt_lp L=6e-08 W=4.45e-07
MI0_MXPB1_2 XI0_p1 A0 VDD VDD pm1p2_svt_lp L=6e-08 W=4.45e-07
MI0_MXPB2_2 XI0_p1 A1 VDD VDD pm1p2_svt_lp L=6e-08 W=4.45e-07
MI0_MXPA2 ny B1 XI0_p1 VDD pm1p2_svt_lp L=6e-08 W=4.45e-07
MI0_MXPA1 ny B0 XI0_p1 VDD pm1p2_svt_lp L=6e-08 W=4.45e-07
MI0_MXPA1_2 ny B0 XI0_p1 VDD pm1p2_svt_lp L=6e-08 W=4.45e-07
MI0_MXPA2_2 ny B1 XI0_p1 VDD pm1p2_svt_lp L=6e-08 W=4.45e-07
MI1_MXPA1 Y ny VDD VDD pm1p2_svt_lp L=6e-08 W=4.15e-07
MI1_MXPA1_2 Y ny VDD VDD pm1p2_svt_lp L=6e-08 W=4.15e-07
.ENDS

.SUBCKT AO22X2H9R Y VDD VSS A0 A1 B0 B1
MI0_MXNB2_2 XI0_n1B__2 A1 VSS VSS nm1p2_svt_lp L=6e-08 W=3.8e-07
MI0_MXNB1_2 ny A0 XI0_n1B__2 VSS nm1p2_svt_lp L=6e-08 W=3.8e-07
MI0_MXNB1 ny A0 XI0_n1B VSS nm1p2_svt_lp L=6e-08 W=3.8e-07
MI0_MXNB2 XI0_n1B A1 VSS VSS nm1p2_svt_lp L=6e-08 W=3.8e-07
MI0_MXNA2_2 XI0_n1A__2 B1 VSS VSS nm1p2_svt_lp L=6e-08 W=3.8e-07
MI0_MXNA1_2 ny B0 XI0_n1A__2 VSS nm1p2_svt_lp L=6e-08 W=3.8e-07
MI0_MXNA1 ny B0 XI0_n1A VSS nm1p2_svt_lp L=6e-08 W=3.8e-07
MI0_MXNA2 XI0_n1A B1 VSS VSS nm1p2_svt_lp L=6e-08 W=3.8e-07
MI1_MXNA1 Y ny VSS VSS nm1p2_svt_lp L=6e-08 W=4.2e-07
MI1_MXNA1_2 Y ny VSS VSS nm1p2_svt_lp L=6e-08 W=4.2e-07
MI0_MXPB2 XI0_p1 A1 VDD VDD pm1p2_svt_lp L=6e-08 W=5.4e-07
MI0_MXPB1 XI0_p1 A0 VDD VDD pm1p2_svt_lp L=6e-08 W=5.4e-07
MI0_MXPB1_2 XI0_p1 A0 VDD VDD pm1p2_svt_lp L=6e-08 W=5.4e-07
MI0_MXPB2_2 XI0_p1 A1 VDD VDD pm1p2_svt_lp L=6e-08 W=5.4e-07
MI0_MXPA2 ny B1 XI0_p1 VDD pm1p2_svt_lp L=6e-08 W=5.4e-07
MI0_MXPA1 ny B0 XI0_p1 VDD pm1p2_svt_lp L=6e-08 W=5.4e-07
MI0_MXPA1_2 ny B0 XI0_p1 VDD pm1p2_svt_lp L=6e-08 W=5.4e-07
MI0_MXPA2_2 ny B1 XI0_p1 VDD pm1p2_svt_lp L=6e-08 W=5.4e-07
MI1_MXPA1 Y ny VDD VDD pm1p2_svt_lp L=6e-08 W=5.85e-07
MI1_MXPA1_2 Y ny VDD VDD pm1p2_svt_lp L=6e-08 W=5.85e-07
.ENDS

.SUBCKT AO22X3H9R Y VDD VSS A0 A1 B0 B1
MI0_MXNB2 XI0_n1B A1 VSS VSS nm1p2_svt_lp L=6e-08 W=4e-07
MI0_MXNB2_2 XI0_n1B A1 VSS VSS nm1p2_svt_lp L=6e-08 W=4e-07
MI0_MXNB2_3 XI0_n1B A1 VSS VSS nm1p2_svt_lp L=6e-08 W=4e-07
MI0_MXNB1 ny A0 XI0_n1B VSS nm1p2_svt_lp L=6e-08 W=4e-07
MI0_MXNB1_2 ny A0 XI0_n1B VSS nm1p2_svt_lp L=6e-08 W=4e-07
MI0_MXNB1_3 ny A0 XI0_n1B VSS nm1p2_svt_lp L=6e-08 W=4e-07
MI0_MXNA1 ny B0 XI0_n1A VSS nm1p2_svt_lp L=6e-08 W=4e-07
MI0_MXNA1_2 ny B0 XI0_n1A VSS nm1p2_svt_lp L=6e-08 W=4e-07
MI0_MXNA1_3 ny B0 XI0_n1A VSS nm1p2_svt_lp L=6e-08 W=4e-07
MI0_MXNA2 XI0_n1A B1 VSS VSS nm1p2_svt_lp L=6e-08 W=4e-07
MI0_MXNA2_2 XI0_n1A B1 VSS VSS nm1p2_svt_lp L=6e-08 W=4e-07
MI0_MXNA2_3 XI0_n1A B1 VSS VSS nm1p2_svt_lp L=6e-08 W=4e-07
MI1_MXNA1 Y ny VSS VSS nm1p2_svt_lp L=6e-08 W=4.2e-07
MI1_MXNA1_2 Y ny VSS VSS nm1p2_svt_lp L=6e-08 W=4.2e-07
MI1_MXNA1_3 Y ny VSS VSS nm1p2_svt_lp L=6e-08 W=4.2e-07
MI0_MXPB2 XI0_p1 A1 VDD VDD pm1p2_svt_lp L=6e-08 W=5.65e-07
MI0_MXPB2_2 XI0_p1 A1 VDD VDD pm1p2_svt_lp L=6e-08 W=5.65e-07
MI0_MXPB2_3 XI0_p1 A1 VDD VDD pm1p2_svt_lp L=6e-08 W=5.65e-07
MI0_MXPB1 XI0_p1 A0 VDD VDD pm1p2_svt_lp L=6e-08 W=5.65e-07
MI0_MXPB1_2 XI0_p1 A0 VDD VDD pm1p2_svt_lp L=6e-08 W=5.65e-07
MI0_MXPB1_3 XI0_p1 A0 VDD VDD pm1p2_svt_lp L=6e-08 W=5.65e-07
MI0_MXPA1 ny B0 XI0_p1 VDD pm1p2_svt_lp L=6e-08 W=5.65e-07
MI0_MXPA1_2 ny B0 XI0_p1 VDD pm1p2_svt_lp L=6e-08 W=5.65e-07
MI0_MXPA1_3 ny B0 XI0_p1 VDD pm1p2_svt_lp L=6e-08 W=5.65e-07
MI0_MXPA2 ny B1 XI0_p1 VDD pm1p2_svt_lp L=6e-08 W=5.65e-07
MI0_MXPA2_2 ny B1 XI0_p1 VDD pm1p2_svt_lp L=6e-08 W=5.65e-07
MI0_MXPA2_3 ny B1 XI0_p1 VDD pm1p2_svt_lp L=6e-08 W=5.65e-07
MI1_MXPA1 Y ny VDD VDD pm1p2_svt_lp L=6e-08 W=5.85e-07
MI1_MXPA1_2 Y ny VDD VDD pm1p2_svt_lp L=6e-08 W=5.85e-07
MI1_MXPA1_3 Y ny VDD VDD pm1p2_svt_lp L=6e-08 W=5.85e-07
.ENDS

.SUBCKT AO22X4H9R Y VDD VSS A0 A1 B0 B1
MI0_MXNB2_2 XI0_n1B__2 A1 VSS VSS nm1p2_svt_lp L=6e-08 W=3.8e-07
MI0_MXNB1_2 ny A0 XI0_n1B__2 VSS nm1p2_svt_lp L=6e-08 W=3.8e-07
MI0_MXNB1_3 ny A0 XI0_n1B__3 VSS nm1p2_svt_lp L=6e-08 W=3.8e-07
MI0_MXNB2_3 XI0_n1B__3 A1 VSS VSS nm1p2_svt_lp L=6e-08 W=3.8e-07
MI0_MXNB2_4 XI0_n1B__4 A1 VSS VSS nm1p2_svt_lp L=6e-08 W=3.8e-07
MI0_MXNB1_4 ny A0 XI0_n1B__4 VSS nm1p2_svt_lp L=6e-08 W=3.8e-07
MI0_MXNB1 ny A0 XI0_n1B VSS nm1p2_svt_lp L=6e-08 W=3.8e-07
MI0_MXNB2 XI0_n1B A1 VSS VSS nm1p2_svt_lp L=6e-08 W=3.8e-07
MI0_MXNA2_2 XI0_n1A__2 B1 VSS VSS nm1p2_svt_lp L=6e-08 W=3.8e-07
MI0_MXNA1_2 ny B0 XI0_n1A__2 VSS nm1p2_svt_lp L=6e-08 W=3.8e-07
MI0_MXNA1_3 ny B0 XI0_n1A__3 VSS nm1p2_svt_lp L=6e-08 W=3.8e-07
MI0_MXNA2_3 XI0_n1A__3 B1 VSS VSS nm1p2_svt_lp L=6e-08 W=3.8e-07
MI0_MXNA2_4 XI0_n1A__4 B1 VSS VSS nm1p2_svt_lp L=6e-08 W=3.8e-07
MI0_MXNA1_4 ny B0 XI0_n1A__4 VSS nm1p2_svt_lp L=6e-08 W=3.8e-07
MI0_MXNA1 ny B0 XI0_n1A VSS nm1p2_svt_lp L=6e-08 W=3.8e-07
MI0_MXNA2 XI0_n1A B1 VSS VSS nm1p2_svt_lp L=6e-08 W=3.8e-07
MI1_MXNA1 Y ny VSS VSS nm1p2_svt_lp L=6e-08 W=4.2e-07
MI1_MXNA1_2 Y ny VSS VSS nm1p2_svt_lp L=6e-08 W=4.2e-07
MI1_MXNA1_3 Y ny VSS VSS nm1p2_svt_lp L=6e-08 W=4.2e-07
MI1_MXNA1_4 Y ny VSS VSS nm1p2_svt_lp L=6e-08 W=4.2e-07
MI0_MXPB2 XI0_p1 A1 VDD VDD pm1p2_svt_lp L=6e-08 W=5.4e-07
MI0_MXPB1 XI0_p1 A0 VDD VDD pm1p2_svt_lp L=6e-08 W=5.4e-07
MI0_MXPB1_2 XI0_p1 A0 VDD VDD pm1p2_svt_lp L=6e-08 W=5.4e-07
MI0_MXPB2_2 XI0_p1 A1 VDD VDD pm1p2_svt_lp L=6e-08 W=5.4e-07
MI0_MXPB2_3 XI0_p1 A1 VDD VDD pm1p2_svt_lp L=6e-08 W=5.4e-07
MI0_MXPB1_3 XI0_p1 A0 VDD VDD pm1p2_svt_lp L=6e-08 W=5.4e-07
MI0_MXPB1_4 XI0_p1 A0 VDD VDD pm1p2_svt_lp L=6e-08 W=5.4e-07
MI0_MXPB2_4 XI0_p1 A1 VDD VDD pm1p2_svt_lp L=6e-08 W=5.4e-07
MI0_MXPA2 ny B1 XI0_p1 VDD pm1p2_svt_lp L=6e-08 W=5.4e-07
MI0_MXPA1 ny B0 XI0_p1 VDD pm1p2_svt_lp L=6e-08 W=5.4e-07
MI0_MXPA1_2 ny B0 XI0_p1 VDD pm1p2_svt_lp L=6e-08 W=5.4e-07
MI0_MXPA2_2 ny B1 XI0_p1 VDD pm1p2_svt_lp L=6e-08 W=5.4e-07
MI0_MXPA2_3 ny B1 XI0_p1 VDD pm1p2_svt_lp L=6e-08 W=5.4e-07
MI0_MXPA1_3 ny B0 XI0_p1 VDD pm1p2_svt_lp L=6e-08 W=5.4e-07
MI0_MXPA1_4 ny B0 XI0_p1 VDD pm1p2_svt_lp L=6e-08 W=5.4e-07
MI0_MXPA2_4 ny B1 XI0_p1 VDD pm1p2_svt_lp L=6e-08 W=5.4e-07
MI1_MXPA1 Y ny VDD VDD pm1p2_svt_lp L=6e-08 W=5.85e-07
MI1_MXPA1_2 Y ny VDD VDD pm1p2_svt_lp L=6e-08 W=5.85e-07
MI1_MXPA1_3 Y ny VDD VDD pm1p2_svt_lp L=6e-08 W=5.85e-07
MI1_MXPA1_4 Y ny VDD VDD pm1p2_svt_lp L=6e-08 W=5.85e-07
.ENDS

.SUBCKT AO22X6H9R Y VDD VSS A0 A1 B0 B1
MI0_MXNB2 XI0_n1B A1 VSS VSS nm1p2_svt_lp L=6e-08 W=4.45e-07
MI0_MXNB2_2 XI0_n1B A1 VSS VSS nm1p2_svt_lp L=6e-08 W=4.45e-07
MI0_MXNB2_3 XI0_n1B A1 VSS VSS nm1p2_svt_lp L=6e-08 W=4.45e-07
MI0_MXNB2_4 XI0_n1B A1 VSS VSS nm1p2_svt_lp L=6e-08 W=4.45e-07
MI0_MXNB2_5 XI0_n1B A1 VSS VSS nm1p2_svt_lp L=6e-08 W=4.45e-07
MI0_MXNB1 ny A0 XI0_n1B VSS nm1p2_svt_lp L=6e-08 W=4.45e-07
MI0_MXNB1_2 ny A0 XI0_n1B VSS nm1p2_svt_lp L=6e-08 W=4.45e-07
MI0_MXNB1_3 ny A0 XI0_n1B VSS nm1p2_svt_lp L=6e-08 W=4.45e-07
MI0_MXNB1_4 ny A0 XI0_n1B VSS nm1p2_svt_lp L=6e-08 W=4.45e-07
MI0_MXNB1_5 ny A0 XI0_n1B VSS nm1p2_svt_lp L=6e-08 W=4.45e-07
MI0_MXNA1 ny B0 XI0_n1A VSS nm1p2_svt_lp L=6e-08 W=4.45e-07
MI0_MXNA1_2 ny B0 XI0_n1A VSS nm1p2_svt_lp L=6e-08 W=4.45e-07
MI0_MXNA1_3 ny B0 XI0_n1A VSS nm1p2_svt_lp L=6e-08 W=4.45e-07
MI0_MXNA1_4 ny B0 XI0_n1A VSS nm1p2_svt_lp L=6e-08 W=4.45e-07
MI0_MXNA1_5 ny B0 XI0_n1A VSS nm1p2_svt_lp L=6e-08 W=4.45e-07
MI0_MXNA2 XI0_n1A B1 VSS VSS nm1p2_svt_lp L=6e-08 W=4.45e-07
MI0_MXNA2_2 XI0_n1A B1 VSS VSS nm1p2_svt_lp L=6e-08 W=4.45e-07
MI0_MXNA2_3 XI0_n1A B1 VSS VSS nm1p2_svt_lp L=6e-08 W=4.45e-07
MI0_MXNA2_4 XI0_n1A B1 VSS VSS nm1p2_svt_lp L=6e-08 W=4.45e-07
MI0_MXNA2_5 XI0_n1A B1 VSS VSS nm1p2_svt_lp L=6e-08 W=4.45e-07
MI1_MXNA1 Y ny VSS VSS nm1p2_svt_lp L=6e-08 W=4.2e-07
MI1_MXNA1_2 Y ny VSS VSS nm1p2_svt_lp L=6e-08 W=4.2e-07
MI1_MXNA1_3 Y ny VSS VSS nm1p2_svt_lp L=6e-08 W=4.2e-07
MI1_MXNA1_4 Y ny VSS VSS nm1p2_svt_lp L=6e-08 W=4.2e-07
MI1_MXNA1_5 Y ny VSS VSS nm1p2_svt_lp L=6e-08 W=4.2e-07
MI1_MXNA1_6 Y ny VSS VSS nm1p2_svt_lp L=6e-08 W=4.2e-07
MI0_MXPB2 XI0_p1 A1 VDD VDD pm1p2_svt_lp L=6e-08 W=5.3e-07
MI0_MXPB2_2 XI0_p1 A1 VDD VDD pm1p2_svt_lp L=6e-08 W=5.3e-07
MI0_MXPB2_3 XI0_p1 A1 VDD VDD pm1p2_svt_lp L=6e-08 W=5.3e-07
MI0_MXPB2_4 XI0_p1 A1 VDD VDD pm1p2_svt_lp L=6e-08 W=5.3e-07
MI0_MXPB2_5 XI0_p1 A1 VDD VDD pm1p2_svt_lp L=6e-08 W=5.3e-07
MI0_MXPB2_6 XI0_p1 A1 VDD VDD pm1p2_svt_lp L=6e-08 W=5.3e-07
MI0_MXPB1 XI0_p1 A0 VDD VDD pm1p2_svt_lp L=6e-08 W=5.3e-07
MI0_MXPB1_2 XI0_p1 A0 VDD VDD pm1p2_svt_lp L=6e-08 W=5.3e-07
MI0_MXPB1_3 XI0_p1 A0 VDD VDD pm1p2_svt_lp L=6e-08 W=5.3e-07
MI0_MXPB1_4 XI0_p1 A0 VDD VDD pm1p2_svt_lp L=6e-08 W=5.3e-07
MI0_MXPB1_5 XI0_p1 A0 VDD VDD pm1p2_svt_lp L=6e-08 W=5.3e-07
MI0_MXPB1_6 XI0_p1 A0 VDD VDD pm1p2_svt_lp L=6e-08 W=5.3e-07
MI0_MXPA1 ny B0 XI0_p1 VDD pm1p2_svt_lp L=6e-08 W=5.3e-07
MI0_MXPA1_2 ny B0 XI0_p1 VDD pm1p2_svt_lp L=6e-08 W=5.3e-07
MI0_MXPA1_3 ny B0 XI0_p1 VDD pm1p2_svt_lp L=6e-08 W=5.3e-07
MI0_MXPA1_4 ny B0 XI0_p1 VDD pm1p2_svt_lp L=6e-08 W=5.3e-07
MI0_MXPA1_5 ny B0 XI0_p1 VDD pm1p2_svt_lp L=6e-08 W=5.3e-07
MI0_MXPA1_6 ny B0 XI0_p1 VDD pm1p2_svt_lp L=6e-08 W=5.3e-07
MI0_MXPA2 ny B1 XI0_p1 VDD pm1p2_svt_lp L=6e-08 W=5.3e-07
MI0_MXPA2_2 ny B1 XI0_p1 VDD pm1p2_svt_lp L=6e-08 W=5.3e-07
MI0_MXPA2_3 ny B1 XI0_p1 VDD pm1p2_svt_lp L=6e-08 W=5.3e-07
MI0_MXPA2_4 ny B1 XI0_p1 VDD pm1p2_svt_lp L=6e-08 W=5.3e-07
MI0_MXPA2_5 ny B1 XI0_p1 VDD pm1p2_svt_lp L=6e-08 W=5.3e-07
MI0_MXPA2_6 ny B1 XI0_p1 VDD pm1p2_svt_lp L=6e-08 W=5.3e-07
MI1_MXPA1 Y ny VDD VDD pm1p2_svt_lp L=6e-08 W=5.85e-07
MI1_MXPA1_2 Y ny VDD VDD pm1p2_svt_lp L=6e-08 W=5.85e-07
MI1_MXPA1_3 Y ny VDD VDD pm1p2_svt_lp L=6e-08 W=5.85e-07
MI1_MXPA1_4 Y ny VDD VDD pm1p2_svt_lp L=6e-08 W=5.85e-07
MI1_MXPA1_5 Y ny VDD VDD pm1p2_svt_lp L=6e-08 W=5.85e-07
MI1_MXPA1_6 Y ny VDD VDD pm1p2_svt_lp L=6e-08 W=5.85e-07
.ENDS

.SUBCKT AOI22X0P5H9R Y VDD VSS A0 A1 B0 B1
MI0_MXNB2 XI0_n1B A1 VSS VSS nm1p2_svt_lp L=6e-08 W=2.1e-07
MI0_MXNB1 Y A0 XI0_n1B VSS nm1p2_svt_lp L=6e-08 W=2.1e-07
MI0_MXNA1 Y B0 XI0_n1A VSS nm1p2_svt_lp L=6e-08 W=2.1e-07
MI0_MXNA2 XI0_n1A B1 VSS VSS nm1p2_svt_lp L=6e-08 W=2.1e-07
MI0_MXPB2 XI0_p1 A1 VDD VDD pm1p2_svt_lp L=6e-08 W=2.95e-07
MI0_MXPB1 XI0_p1 A0 VDD VDD pm1p2_svt_lp L=6e-08 W=2.95e-07
MI0_MXPA1 Y B0 XI0_p1 VDD pm1p2_svt_lp L=6e-08 W=2.95e-07
MI0_MXPA2 Y B1 XI0_p1 VDD pm1p2_svt_lp L=6e-08 W=2.95e-07
.ENDS

.SUBCKT AOI22X0P7H9R Y VDD VSS A0 A1 B0 B1
MI0_MXNB2 XI0_n1B A1 VSS VSS nm1p2_svt_lp L=6e-08 W=2.9e-07
MI0_MXNB1 Y A0 XI0_n1B VSS nm1p2_svt_lp L=6e-08 W=2.9e-07
MI0_MXNA1 Y B0 XI0_n1A VSS nm1p2_svt_lp L=6e-08 W=2.9e-07
MI0_MXNA2 XI0_n1A B1 VSS VSS nm1p2_svt_lp L=6e-08 W=2.9e-07
MI0_MXPB2 XI0_p1 A1 VDD VDD pm1p2_svt_lp L=6e-08 W=4.15e-07
MI0_MXPB1 XI0_p1 A0 VDD VDD pm1p2_svt_lp L=6e-08 W=4.15e-07
MI0_MXPA1 Y B0 XI0_p1 VDD pm1p2_svt_lp L=6e-08 W=4.15e-07
MI0_MXPA2 Y B1 XI0_p1 VDD pm1p2_svt_lp L=6e-08 W=4.15e-07
.ENDS

.SUBCKT AOI22X1H9R Y VDD VSS A0 A1 B0 B1
MI0_MXNB2 XI0_n1B A1 VSS VSS nm1p2_svt_lp L=6e-08 W=4.1e-07
MI0_MXNB1 Y A0 XI0_n1B VSS nm1p2_svt_lp L=6e-08 W=4.1e-07
MI0_MXNA1 Y B0 XI0_n1A VSS nm1p2_svt_lp L=6e-08 W=4.1e-07
MI0_MXNA2 XI0_n1A B1 VSS VSS nm1p2_svt_lp L=6e-08 W=4.1e-07
MI0_MXPB2 XI0_p1 A1 VDD VDD pm1p2_svt_lp L=6e-08 W=5.85e-07
MI0_MXPB1 XI0_p1 A0 VDD VDD pm1p2_svt_lp L=6e-08 W=5.85e-07
MI0_MXPA1 Y B0 XI0_p1 VDD pm1p2_svt_lp L=6e-08 W=5.85e-07
MI0_MXPA2 Y B1 XI0_p1 VDD pm1p2_svt_lp L=6e-08 W=5.85e-07
.ENDS

.SUBCKT AOI22X1P4H9R Y VDD VSS A0 A1 B0 B1
MI0_MXNB2_2 XI0_n1B__2 A1 VSS VSS nm1p2_svt_lp L=6e-08 W=2.9e-07
MI0_MXNB1_2 Y A0 XI0_n1B__2 VSS nm1p2_svt_lp L=6e-08 W=2.9e-07
MI0_MXNB1 Y A0 XI0_n1B VSS nm1p2_svt_lp L=6e-08 W=2.9e-07
MI0_MXNB2 XI0_n1B A1 VSS VSS nm1p2_svt_lp L=6e-08 W=2.9e-07
MI0_MXNA2_2 XI0_n1A__2 B1 VSS VSS nm1p2_svt_lp L=6e-08 W=2.9e-07
MI0_MXNA1_2 Y B0 XI0_n1A__2 VSS nm1p2_svt_lp L=6e-08 W=2.9e-07
MI0_MXNA1 Y B0 XI0_n1A VSS nm1p2_svt_lp L=6e-08 W=2.9e-07
MI0_MXNA2 XI0_n1A B1 VSS VSS nm1p2_svt_lp L=6e-08 W=2.9e-07
MI0_MXPB2 XI0_p1 A1 VDD VDD pm1p2_svt_lp L=6e-08 W=4.15e-07
MI0_MXPB1 XI0_p1 A0 VDD VDD pm1p2_svt_lp L=6e-08 W=4.15e-07
MI0_MXPB1_2 XI0_p1 A0 VDD VDD pm1p2_svt_lp L=6e-08 W=4.15e-07
MI0_MXPB2_2 XI0_p1 A1 VDD VDD pm1p2_svt_lp L=6e-08 W=4.15e-07
MI0_MXPA2 Y B1 XI0_p1 VDD pm1p2_svt_lp L=6e-08 W=4.15e-07
MI0_MXPA1 Y B0 XI0_p1 VDD pm1p2_svt_lp L=6e-08 W=4.15e-07
MI0_MXPA1_2 Y B0 XI0_p1 VDD pm1p2_svt_lp L=6e-08 W=4.15e-07
MI0_MXPA2_2 Y B1 XI0_p1 VDD pm1p2_svt_lp L=6e-08 W=4.15e-07
.ENDS

.SUBCKT AOI22X2H9R Y VDD VSS A0 A1 B0 B1
MI0_MXNB2_2 XI0_n1B__2 A1 VSS VSS nm1p2_svt_lp L=6e-08 W=4.1e-07
MI0_MXNB1_2 Y A0 XI0_n1B__2 VSS nm1p2_svt_lp L=6e-08 W=4.1e-07
MI0_MXNB1 Y A0 XI0_n1B VSS nm1p2_svt_lp L=6e-08 W=4.1e-07
MI0_MXNB2 XI0_n1B A1 VSS VSS nm1p2_svt_lp L=6e-08 W=4.1e-07
MI0_MXNA2_2 XI0_n1A__2 B1 VSS VSS nm1p2_svt_lp L=6e-08 W=4.1e-07
MI0_MXNA1_2 Y B0 XI0_n1A__2 VSS nm1p2_svt_lp L=6e-08 W=4.1e-07
MI0_MXNA1 Y B0 XI0_n1A VSS nm1p2_svt_lp L=6e-08 W=4.1e-07
MI0_MXNA2 XI0_n1A B1 VSS VSS nm1p2_svt_lp L=6e-08 W=4.1e-07
MI0_MXPB2 XI0_p1 A1 VDD VDD pm1p2_svt_lp L=6e-08 W=5.85e-07
MI0_MXPB1 XI0_p1 A0 VDD VDD pm1p2_svt_lp L=6e-08 W=5.85e-07
MI0_MXPB1_2 XI0_p1 A0 VDD VDD pm1p2_svt_lp L=6e-08 W=5.85e-07
MI0_MXPB2_2 XI0_p1 A1 VDD VDD pm1p2_svt_lp L=6e-08 W=5.85e-07
MI0_MXPA2 Y B1 XI0_p1 VDD pm1p2_svt_lp L=6e-08 W=5.85e-07
MI0_MXPA1 Y B0 XI0_p1 VDD pm1p2_svt_lp L=6e-08 W=5.85e-07
MI0_MXPA1_2 Y B0 XI0_p1 VDD pm1p2_svt_lp L=6e-08 W=5.85e-07
MI0_MXPA2_2 Y B1 XI0_p1 VDD pm1p2_svt_lp L=6e-08 W=5.85e-07
.ENDS

.SUBCKT AOI22X3H9R Y VDD VSS A0 A1 B0 B1
MI0_MXNB2_2 XI0_n1B__2 A1 VSS VSS nm1p2_svt_lp L=6e-08 W=4.1e-07
MI0_MXNB1_2 Y A0 XI0_n1B__2 VSS nm1p2_svt_lp L=6e-08 W=4.1e-07
MI0_MXNB1_3 Y A0 XI0_n1B__3 VSS nm1p2_svt_lp L=6e-08 W=4.1e-07
MI0_MXNB2_3 XI0_n1B__3 A1 VSS VSS nm1p2_svt_lp L=6e-08 W=4.1e-07
MI0_MXNB2 XI0_n1B A1 VSS VSS nm1p2_svt_lp L=6e-08 W=4.1e-07
MI0_MXNB1 Y A0 XI0_n1B VSS nm1p2_svt_lp L=6e-08 W=4.1e-07
MI0_MXNA1_2 Y B0 XI0_n1A__2 VSS nm1p2_svt_lp L=6e-08 W=4.1e-07
MI0_MXNA2_2 XI0_n1A__2 B1 VSS VSS nm1p2_svt_lp L=6e-08 W=4.1e-07
MI0_MXNA2_3 XI0_n1A__3 B1 VSS VSS nm1p2_svt_lp L=6e-08 W=4.1e-07
MI0_MXNA1_3 Y B0 XI0_n1A__3 VSS nm1p2_svt_lp L=6e-08 W=4.1e-07
MI0_MXNA1 Y B0 XI0_n1A VSS nm1p2_svt_lp L=6e-08 W=4.1e-07
MI0_MXNA2 XI0_n1A B1 VSS VSS nm1p2_svt_lp L=6e-08 W=4.1e-07
MI0_MXPB2 XI0_p1 A1 VDD VDD pm1p2_svt_lp L=6e-08 W=5.85e-07
MI0_MXPB1 XI0_p1 A0 VDD VDD pm1p2_svt_lp L=6e-08 W=5.85e-07
MI0_MXPB1_2 XI0_p1 A0 VDD VDD pm1p2_svt_lp L=6e-08 W=5.85e-07
MI0_MXPB2_2 XI0_p1 A1 VDD VDD pm1p2_svt_lp L=6e-08 W=5.85e-07
MI0_MXPB2_3 XI0_p1 A1 VDD VDD pm1p2_svt_lp L=6e-08 W=5.85e-07
MI0_MXPB1_3 XI0_p1 A0 VDD VDD pm1p2_svt_lp L=6e-08 W=5.85e-07
MI0_MXPA1 Y B0 XI0_p1 VDD pm1p2_svt_lp L=6e-08 W=5.85e-07
MI0_MXPA2 Y B1 XI0_p1 VDD pm1p2_svt_lp L=6e-08 W=5.85e-07
MI0_MXPA2_2 Y B1 XI0_p1 VDD pm1p2_svt_lp L=6e-08 W=5.85e-07
MI0_MXPA1_2 Y B0 XI0_p1 VDD pm1p2_svt_lp L=6e-08 W=5.85e-07
MI0_MXPA1_3 Y B0 XI0_p1 VDD pm1p2_svt_lp L=6e-08 W=5.85e-07
MI0_MXPA2_3 Y B1 XI0_p1 VDD pm1p2_svt_lp L=6e-08 W=5.85e-07
.ENDS

.SUBCKT AOI22X4H9R Y VDD VSS A0 A1 B0 B1
MI0_MXNB2_2 XI0_n1B__2 A1 VSS VSS nm1p2_svt_lp L=6e-08 W=4.1e-07
MI0_MXNB1_2 Y A0 XI0_n1B__2 VSS nm1p2_svt_lp L=6e-08 W=4.1e-07
MI0_MXNB1_3 Y A0 XI0_n1B__3 VSS nm1p2_svt_lp L=6e-08 W=4.1e-07
MI0_MXNB2_3 XI0_n1B__3 A1 VSS VSS nm1p2_svt_lp L=6e-08 W=4.1e-07
MI0_MXNB2_4 XI0_n1B__4 A1 VSS VSS nm1p2_svt_lp L=6e-08 W=4.1e-07
MI0_MXNB1_4 Y A0 XI0_n1B__4 VSS nm1p2_svt_lp L=6e-08 W=4.1e-07
MI0_MXNB1 Y A0 XI0_n1B VSS nm1p2_svt_lp L=6e-08 W=4.1e-07
MI0_MXNB2 XI0_n1B A1 VSS VSS nm1p2_svt_lp L=6e-08 W=4.1e-07
MI0_MXNA2_2 XI0_n1A__2 B1 VSS VSS nm1p2_svt_lp L=6e-08 W=4.1e-07
MI0_MXNA1_2 Y B0 XI0_n1A__2 VSS nm1p2_svt_lp L=6e-08 W=4.1e-07
MI0_MXNA1_3 Y B0 XI0_n1A__3 VSS nm1p2_svt_lp L=6e-08 W=4.1e-07
MI0_MXNA2_3 XI0_n1A__3 B1 VSS VSS nm1p2_svt_lp L=6e-08 W=4.1e-07
MI0_MXNA2_4 XI0_n1A__4 B1 VSS VSS nm1p2_svt_lp L=6e-08 W=4.1e-07
MI0_MXNA1_4 Y B0 XI0_n1A__4 VSS nm1p2_svt_lp L=6e-08 W=4.1e-07
MI0_MXNA1 Y B0 XI0_n1A VSS nm1p2_svt_lp L=6e-08 W=4.1e-07
MI0_MXNA2 XI0_n1A B1 VSS VSS nm1p2_svt_lp L=6e-08 W=4.1e-07
MI0_MXPB2 XI0_p1 A1 VDD VDD pm1p2_svt_lp L=6e-08 W=5.85e-07
MI0_MXPB1 XI0_p1 A0 VDD VDD pm1p2_svt_lp L=6e-08 W=5.85e-07
MI0_MXPB1_2 XI0_p1 A0 VDD VDD pm1p2_svt_lp L=6e-08 W=5.85e-07
MI0_MXPB2_2 XI0_p1 A1 VDD VDD pm1p2_svt_lp L=6e-08 W=5.85e-07
MI0_MXPB2_3 XI0_p1 A1 VDD VDD pm1p2_svt_lp L=6e-08 W=5.85e-07
MI0_MXPB1_3 XI0_p1 A0 VDD VDD pm1p2_svt_lp L=6e-08 W=5.85e-07
MI0_MXPB1_4 XI0_p1 A0 VDD VDD pm1p2_svt_lp L=6e-08 W=5.85e-07
MI0_MXPB2_4 XI0_p1 A1 VDD VDD pm1p2_svt_lp L=6e-08 W=5.85e-07
MI0_MXPA2 Y B1 XI0_p1 VDD pm1p2_svt_lp L=6e-08 W=5.85e-07
MI0_MXPA1 Y B0 XI0_p1 VDD pm1p2_svt_lp L=6e-08 W=5.85e-07
MI0_MXPA1_2 Y B0 XI0_p1 VDD pm1p2_svt_lp L=6e-08 W=5.85e-07
MI0_MXPA2_2 Y B1 XI0_p1 VDD pm1p2_svt_lp L=6e-08 W=5.85e-07
MI0_MXPA2_3 Y B1 XI0_p1 VDD pm1p2_svt_lp L=6e-08 W=5.85e-07
MI0_MXPA1_3 Y B0 XI0_p1 VDD pm1p2_svt_lp L=6e-08 W=5.85e-07
MI0_MXPA1_4 Y B0 XI0_p1 VDD pm1p2_svt_lp L=6e-08 W=5.85e-07
MI0_MXPA2_4 Y B1 XI0_p1 VDD pm1p2_svt_lp L=6e-08 W=5.85e-07
.ENDS

.SUBCKT AOI22X6H9R Y VDD VSS A0 A1 B0 B1
MI0_MXNB2 XI0_n1B A1 VSS VSS nm1p2_svt_lp L=6e-08 W=4.95e-07
MI0_MXNB2_2 XI0_n1B A1 VSS VSS nm1p2_svt_lp L=6e-08 W=4.95e-07
MI0_MXNB2_3 XI0_n1B A1 VSS VSS nm1p2_svt_lp L=6e-08 W=4.95e-07
MI0_MXNB2_4 XI0_n1B A1 VSS VSS nm1p2_svt_lp L=6e-08 W=4.95e-07
MI0_MXNB2_5 XI0_n1B A1 VSS VSS nm1p2_svt_lp L=6e-08 W=4.95e-07
MI0_MXNB1 Y A0 XI0_n1B VSS nm1p2_svt_lp L=6e-08 W=4.95e-07
MI0_MXNB1_2 Y A0 XI0_n1B VSS nm1p2_svt_lp L=6e-08 W=4.95e-07
MI0_MXNB1_3 Y A0 XI0_n1B VSS nm1p2_svt_lp L=6e-08 W=4.95e-07
MI0_MXNB1_4 Y A0 XI0_n1B VSS nm1p2_svt_lp L=6e-08 W=4.95e-07
MI0_MXNB1_5 Y A0 XI0_n1B VSS nm1p2_svt_lp L=6e-08 W=4.95e-07
MI0_MXNA1 Y B0 XI0_n1A VSS nm1p2_svt_lp L=6e-08 W=4.95e-07
MI0_MXNA1_2 Y B0 XI0_n1A VSS nm1p2_svt_lp L=6e-08 W=4.95e-07
MI0_MXNA1_3 Y B0 XI0_n1A VSS nm1p2_svt_lp L=6e-08 W=4.95e-07
MI0_MXNA1_4 Y B0 XI0_n1A VSS nm1p2_svt_lp L=6e-08 W=4.95e-07
MI0_MXNA1_5 Y B0 XI0_n1A VSS nm1p2_svt_lp L=6e-08 W=4.95e-07
MI0_MXNA2 XI0_n1A B1 VSS VSS nm1p2_svt_lp L=6e-08 W=4.95e-07
MI0_MXNA2_2 XI0_n1A B1 VSS VSS nm1p2_svt_lp L=6e-08 W=4.95e-07
MI0_MXNA2_3 XI0_n1A B1 VSS VSS nm1p2_svt_lp L=6e-08 W=4.95e-07
MI0_MXNA2_4 XI0_n1A B1 VSS VSS nm1p2_svt_lp L=6e-08 W=4.95e-07
MI0_MXNA2_5 XI0_n1A B1 VSS VSS nm1p2_svt_lp L=6e-08 W=4.95e-07
MI0_MXPB2 XI0_p1 A1 VDD VDD pm1p2_svt_lp L=6e-08 W=5.85e-07
MI0_MXPB2_2 XI0_p1 A1 VDD VDD pm1p2_svt_lp L=6e-08 W=5.85e-07
MI0_MXPB2_3 XI0_p1 A1 VDD VDD pm1p2_svt_lp L=6e-08 W=5.85e-07
MI0_MXPB2_4 XI0_p1 A1 VDD VDD pm1p2_svt_lp L=6e-08 W=5.85e-07
MI0_MXPB2_5 XI0_p1 A1 VDD VDD pm1p2_svt_lp L=6e-08 W=5.85e-07
MI0_MXPB2_6 XI0_p1 A1 VDD VDD pm1p2_svt_lp L=6e-08 W=5.85e-07
MI0_MXPB1 XI0_p1 A0 VDD VDD pm1p2_svt_lp L=6e-08 W=5.85e-07
MI0_MXPB1_2 XI0_p1 A0 VDD VDD pm1p2_svt_lp L=6e-08 W=5.85e-07
MI0_MXPB1_3 XI0_p1 A0 VDD VDD pm1p2_svt_lp L=6e-08 W=5.85e-07
MI0_MXPB1_4 XI0_p1 A0 VDD VDD pm1p2_svt_lp L=6e-08 W=5.85e-07
MI0_MXPB1_5 XI0_p1 A0 VDD VDD pm1p2_svt_lp L=6e-08 W=5.85e-07
MI0_MXPB1_6 XI0_p1 A0 VDD VDD pm1p2_svt_lp L=6e-08 W=5.85e-07
MI0_MXPA1 Y B0 XI0_p1 VDD pm1p2_svt_lp L=6e-08 W=5.85e-07
MI0_MXPA1_2 Y B0 XI0_p1 VDD pm1p2_svt_lp L=6e-08 W=5.85e-07
MI0_MXPA1_3 Y B0 XI0_p1 VDD pm1p2_svt_lp L=6e-08 W=5.85e-07
MI0_MXPA1_4 Y B0 XI0_p1 VDD pm1p2_svt_lp L=6e-08 W=5.85e-07
MI0_MXPA1_5 Y B0 XI0_p1 VDD pm1p2_svt_lp L=6e-08 W=5.85e-07
MI0_MXPA1_6 Y B0 XI0_p1 VDD pm1p2_svt_lp L=6e-08 W=5.85e-07
MI0_MXPA2 Y B1 XI0_p1 VDD pm1p2_svt_lp L=6e-08 W=5.85e-07
MI0_MXPA2_2 Y B1 XI0_p1 VDD pm1p2_svt_lp L=6e-08 W=5.85e-07
MI0_MXPA2_3 Y B1 XI0_p1 VDD pm1p2_svt_lp L=6e-08 W=5.85e-07
MI0_MXPA2_4 Y B1 XI0_p1 VDD pm1p2_svt_lp L=6e-08 W=5.85e-07
MI0_MXPA2_5 Y B1 XI0_p1 VDD pm1p2_svt_lp L=6e-08 W=5.85e-07
MI0_MXPA2_6 Y B1 XI0_p1 VDD pm1p2_svt_lp L=6e-08 W=5.85e-07
.ENDS

.SUBCKT AOI22X8H9R Y VDD VSS A0 A1 B0 B1
MI0_MXNB2 XI0_n1B A1 VSS VSS nm1p2_svt_lp L=6e-08 W=4.7e-07
MI0_MXNB2_2 XI0_n1B A1 VSS VSS nm1p2_svt_lp L=6e-08 W=4.7e-07
MI0_MXNB2_3 XI0_n1B A1 VSS VSS nm1p2_svt_lp L=6e-08 W=4.7e-07
MI0_MXNB2_4 XI0_n1B A1 VSS VSS nm1p2_svt_lp L=6e-08 W=4.7e-07
MI0_MXNB2_5 XI0_n1B A1 VSS VSS nm1p2_svt_lp L=6e-08 W=4.7e-07
MI0_MXNB2_6 XI0_n1B A1 VSS VSS nm1p2_svt_lp L=6e-08 W=4.7e-07
MI0_MXNB2_7 XI0_n1B A1 VSS VSS nm1p2_svt_lp L=6e-08 W=4.7e-07
MI0_MXNB1 Y A0 XI0_n1B VSS nm1p2_svt_lp L=6e-08 W=4.7e-07
MI0_MXNB1_2 Y A0 XI0_n1B VSS nm1p2_svt_lp L=6e-08 W=4.7e-07
MI0_MXNB1_3 Y A0 XI0_n1B VSS nm1p2_svt_lp L=6e-08 W=4.7e-07
MI0_MXNB1_4 Y A0 XI0_n1B VSS nm1p2_svt_lp L=6e-08 W=4.7e-07
MI0_MXNB1_5 Y A0 XI0_n1B VSS nm1p2_svt_lp L=6e-08 W=4.7e-07
MI0_MXNB1_6 Y A0 XI0_n1B VSS nm1p2_svt_lp L=6e-08 W=4.7e-07
MI0_MXNB1_7 Y A0 XI0_n1B VSS nm1p2_svt_lp L=6e-08 W=4.7e-07
MI0_MXNA1 Y B0 XI0_n1A VSS nm1p2_svt_lp L=6e-08 W=4.7e-07
MI0_MXNA1_2 Y B0 XI0_n1A VSS nm1p2_svt_lp L=6e-08 W=4.7e-07
MI0_MXNA1_3 Y B0 XI0_n1A VSS nm1p2_svt_lp L=6e-08 W=4.7e-07
MI0_MXNA1_4 Y B0 XI0_n1A VSS nm1p2_svt_lp L=6e-08 W=4.7e-07
MI0_MXNA1_5 Y B0 XI0_n1A VSS nm1p2_svt_lp L=6e-08 W=4.7e-07
MI0_MXNA1_6 Y B0 XI0_n1A VSS nm1p2_svt_lp L=6e-08 W=4.7e-07
MI0_MXNA1_7 Y B0 XI0_n1A VSS nm1p2_svt_lp L=6e-08 W=4.7e-07
MI0_MXNA2 XI0_n1A B1 VSS VSS nm1p2_svt_lp L=6e-08 W=4.7e-07
MI0_MXNA2_2 XI0_n1A B1 VSS VSS nm1p2_svt_lp L=6e-08 W=4.7e-07
MI0_MXNA2_3 XI0_n1A B1 VSS VSS nm1p2_svt_lp L=6e-08 W=4.7e-07
MI0_MXNA2_4 XI0_n1A B1 VSS VSS nm1p2_svt_lp L=6e-08 W=4.7e-07
MI0_MXNA2_5 XI0_n1A B1 VSS VSS nm1p2_svt_lp L=6e-08 W=4.7e-07
MI0_MXNA2_6 XI0_n1A B1 VSS VSS nm1p2_svt_lp L=6e-08 W=4.7e-07
MI0_MXNA2_7 XI0_n1A B1 VSS VSS nm1p2_svt_lp L=6e-08 W=4.7e-07
MI0_MXPB2 XI0_p1 A1 VDD VDD pm1p2_svt_lp L=6e-08 W=5.85e-07
MI0_MXPB2_2 XI0_p1 A1 VDD VDD pm1p2_svt_lp L=6e-08 W=5.85e-07
MI0_MXPB2_3 XI0_p1 A1 VDD VDD pm1p2_svt_lp L=6e-08 W=5.85e-07
MI0_MXPB2_4 XI0_p1 A1 VDD VDD pm1p2_svt_lp L=6e-08 W=5.85e-07
MI0_MXPB2_5 XI0_p1 A1 VDD VDD pm1p2_svt_lp L=6e-08 W=5.85e-07
MI0_MXPB2_6 XI0_p1 A1 VDD VDD pm1p2_svt_lp L=6e-08 W=5.85e-07
MI0_MXPB2_7 XI0_p1 A1 VDD VDD pm1p2_svt_lp L=6e-08 W=5.85e-07
MI0_MXPB2_8 XI0_p1 A1 VDD VDD pm1p2_svt_lp L=6e-08 W=5.85e-07
MI0_MXPB1 XI0_p1 A0 VDD VDD pm1p2_svt_lp L=6e-08 W=5.85e-07
MI0_MXPB1_2 XI0_p1 A0 VDD VDD pm1p2_svt_lp L=6e-08 W=5.85e-07
MI0_MXPB1_3 XI0_p1 A0 VDD VDD pm1p2_svt_lp L=6e-08 W=5.85e-07
MI0_MXPB1_4 XI0_p1 A0 VDD VDD pm1p2_svt_lp L=6e-08 W=5.85e-07
MI0_MXPB1_5 XI0_p1 A0 VDD VDD pm1p2_svt_lp L=6e-08 W=5.85e-07
MI0_MXPB1_6 XI0_p1 A0 VDD VDD pm1p2_svt_lp L=6e-08 W=5.85e-07
MI0_MXPB1_7 XI0_p1 A0 VDD VDD pm1p2_svt_lp L=6e-08 W=5.85e-07
MI0_MXPB1_8 XI0_p1 A0 VDD VDD pm1p2_svt_lp L=6e-08 W=5.85e-07
MI0_MXPA1 Y B0 XI0_p1 VDD pm1p2_svt_lp L=6e-08 W=5.85e-07
MI0_MXPA1_2 Y B0 XI0_p1 VDD pm1p2_svt_lp L=6e-08 W=5.85e-07
MI0_MXPA1_3 Y B0 XI0_p1 VDD pm1p2_svt_lp L=6e-08 W=5.85e-07
MI0_MXPA1_4 Y B0 XI0_p1 VDD pm1p2_svt_lp L=6e-08 W=5.85e-07
MI0_MXPA1_5 Y B0 XI0_p1 VDD pm1p2_svt_lp L=6e-08 W=5.85e-07
MI0_MXPA1_6 Y B0 XI0_p1 VDD pm1p2_svt_lp L=6e-08 W=5.85e-07
MI0_MXPA1_7 Y B0 XI0_p1 VDD pm1p2_svt_lp L=6e-08 W=5.85e-07
MI0_MXPA1_8 Y B0 XI0_p1 VDD pm1p2_svt_lp L=6e-08 W=5.85e-07
MI0_MXPA2 Y B1 XI0_p1 VDD pm1p2_svt_lp L=6e-08 W=5.85e-07
MI0_MXPA2_2 Y B1 XI0_p1 VDD pm1p2_svt_lp L=6e-08 W=5.85e-07
MI0_MXPA2_3 Y B1 XI0_p1 VDD pm1p2_svt_lp L=6e-08 W=5.85e-07
MI0_MXPA2_4 Y B1 XI0_p1 VDD pm1p2_svt_lp L=6e-08 W=5.85e-07
MI0_MXPA2_5 Y B1 XI0_p1 VDD pm1p2_svt_lp L=6e-08 W=5.85e-07
MI0_MXPA2_6 Y B1 XI0_p1 VDD pm1p2_svt_lp L=6e-08 W=5.85e-07
MI0_MXPA2_7 Y B1 XI0_p1 VDD pm1p2_svt_lp L=6e-08 W=5.85e-07
MI0_MXPA2_8 Y B1 XI0_p1 VDD pm1p2_svt_lp L=6e-08 W=5.85e-07
.ENDS

.SUBCKT AOI211X0P5H9R Y VDD VSS A0 A1 B0 C0
MXNA1 net17 A1 VSS VSS nm1p2_svt_lp L=6e-08 W=1.5e-07
MXNA0 Y A0 net17 VSS nm1p2_svt_lp L=6e-08 W=1.5e-07
MXNB0 Y B0 VSS VSS nm1p2_svt_lp L=6e-08 W=1.5e-07
MXNC0 Y C0 VSS VSS nm1p2_svt_lp L=6e-08 W=1.5e-07
MXPA1 p1 A1 VDD VDD pm1p2_svt_lp L=6e-08 W=2.95e-07
MXPA0 p1 A0 VDD VDD pm1p2_svt_lp L=6e-08 W=2.95e-07
MXPB0 net045 B0 p1 VDD pm1p2_svt_lp L=6e-08 W=2.95e-07
MXPC0 Y C0 net045 VDD pm1p2_svt_lp L=6e-08 W=2.95e-07
.ENDS

.SUBCKT AOI211X0P7H9R Y VDD VSS A0 A1 B0 C0
MXNA1 net17 A1 VSS VSS nm1p2_svt_lp L=6e-08 W=2.65e-07
MXNA0 Y A0 net17 VSS nm1p2_svt_lp L=6e-08 W=2.65e-07
MXNB0 Y B0 VSS VSS nm1p2_svt_lp L=6e-08 W=1.5e-07
MXNC0 Y C0 VSS VSS nm1p2_svt_lp L=6e-08 W=1.5e-07
MXPA1 p1 A1 VDD VDD pm1p2_svt_lp L=6e-08 W=5.3e-07
MXPA0 p1 A0 VDD VDD pm1p2_svt_lp L=6e-08 W=5.3e-07
MXPB0 net045 B0 p1 VDD pm1p2_svt_lp L=6e-08 W=5.3e-07
MXPC0 Y C0 net045 VDD pm1p2_svt_lp L=6e-08 W=5.3e-07
.ENDS

.SUBCKT AOI211X1H9R Y VDD VSS A0 A1 B0 C0
MXNA1 net17 A1 VSS VSS nm1p2_svt_lp L=6e-08 W=2.95e-07
MXNA0 Y A0 net17 VSS nm1p2_svt_lp L=6e-08 W=2.95e-07
MXNB0 Y B0 VSS VSS nm1p2_svt_lp L=6e-08 W=1.7e-07
MXNC0 Y C0 VSS VSS nm1p2_svt_lp L=6e-08 W=1.7e-07
MXPA1 p1 A1 VDD VDD pm1p2_svt_lp L=6e-08 W=5.85e-07
MXPA0 p1 A0 VDD VDD pm1p2_svt_lp L=6e-08 W=5.85e-07
MXPB0 net045 B0 p1 VDD pm1p2_svt_lp L=6e-08 W=5.85e-07
MXPC0 Y C0 net045 VDD pm1p2_svt_lp L=6e-08 W=5.85e-07
.ENDS

.SUBCKT AOI211X1P4H9R Y VDD VSS A0 A1 B0 C0
MXNA1 net17 A1 VSS VSS nm1p2_svt_lp L=6e-08 W=4.2e-07
MXNA0 Y A0 net17 VSS nm1p2_svt_lp L=6e-08 W=4.2e-07
MXNB0 Y B0 VSS VSS nm1p2_svt_lp L=6e-08 W=2.4e-07
MXNC0 Y C0 VSS VSS nm1p2_svt_lp L=6e-08 W=2.4e-07
MXPA1 p1 A1 VDD VDD pm1p2_svt_lp L=6e-08 W=4.15e-07
MXPA0 p1 A0 VDD VDD pm1p2_svt_lp L=6e-08 W=4.15e-07
MXPA0_2 p1 A0 VDD VDD pm1p2_svt_lp L=6e-08 W=4.15e-07
MXPA1_2 p1 A1 VDD VDD pm1p2_svt_lp L=6e-08 W=4.15e-07
MXPB0_2 net045__2 B0 p1 VDD pm1p2_svt_lp L=6e-08 W=4.15e-07
MXPC0_2 Y C0 net045__2 VDD pm1p2_svt_lp L=6e-08 W=4.15e-07
MXPC0 Y C0 net045 VDD pm1p2_svt_lp L=6e-08 W=4.15e-07
MXPB0 net045 B0 p1 VDD pm1p2_svt_lp L=6e-08 W=4.15e-07
.ENDS

.SUBCKT AOI211X2H9R Y VDD VSS A0 A1 B0 C0
MXNC0 Y C0 VSS VSS nm1p2_svt_lp L=6e-08 W=3.4e-07
MXNB0 Y B0 VSS VSS nm1p2_svt_lp L=6e-08 W=3.4e-07
MXNA0_2 Y A0 net17__2 VSS nm1p2_svt_lp L=6e-08 W=2.95e-07
MXNA1_2 net17__2 A1 VSS VSS nm1p2_svt_lp L=6e-08 W=2.95e-07
MXNA1 net17 A1 VSS VSS nm1p2_svt_lp L=6e-08 W=2.95e-07
MXNA0 Y A0 net17 VSS nm1p2_svt_lp L=6e-08 W=2.95e-07
MXPB0_2 net045__2 B0 p1 VDD pm1p2_svt_lp L=6e-08 W=5.85e-07
MXPC0_2 Y C0 net045__2 VDD pm1p2_svt_lp L=6e-08 W=5.85e-07
MXPC0 Y C0 net045 VDD pm1p2_svt_lp L=6e-08 W=5.85e-07
MXPB0 net045 B0 p1 VDD pm1p2_svt_lp L=6e-08 W=5.85e-07
MXPA0 p1 A0 VDD VDD pm1p2_svt_lp L=6e-08 W=5.85e-07
MXPA1 p1 A1 VDD VDD pm1p2_svt_lp L=6e-08 W=5.85e-07
MXPA1_2 p1 A1 VDD VDD pm1p2_svt_lp L=6e-08 W=5.85e-07
MXPA0_2 p1 A0 VDD VDD pm1p2_svt_lp L=6e-08 W=5.85e-07
.ENDS

.SUBCKT AOI211X3H9R Y VDD VSS A0 A1 B0 C0
MXNA0_2 Y A0 net17__2 VSS nm1p2_svt_lp L=6e-08 W=4.45e-07
MXNA1_2 net17__2 A1 VSS VSS nm1p2_svt_lp L=6e-08 W=4.45e-07
MXNA1 net17 A1 VSS VSS nm1p2_svt_lp L=6e-08 W=4.45e-07
MXNA0 Y A0 net17 VSS nm1p2_svt_lp L=6e-08 W=4.45e-07
MXNB0 Y B0 VSS VSS nm1p2_svt_lp L=6e-08 W=2.55e-07
MXNC0 Y C0 VSS VSS nm1p2_svt_lp L=6e-08 W=2.55e-07
MXNC0_2 Y C0 VSS VSS nm1p2_svt_lp L=6e-08 W=2.55e-07
MXNB0_2 Y B0 VSS VSS nm1p2_svt_lp L=6e-08 W=2.55e-07
MXPA0 p1 A0 VDD VDD pm1p2_svt_lp L=6e-08 W=5.85e-07
MXPA1 p1 A1 VDD VDD pm1p2_svt_lp L=6e-08 W=5.85e-07
MXPA1_2 p1 A1 VDD VDD pm1p2_svt_lp L=6e-08 W=5.85e-07
MXPA0_2 p1 A0 VDD VDD pm1p2_svt_lp L=6e-08 W=5.85e-07
MXPA0_3 p1 A0 VDD VDD pm1p2_svt_lp L=6e-08 W=5.85e-07
MXPA1_3 p1 A1 VDD VDD pm1p2_svt_lp L=6e-08 W=5.85e-07
MXPB0_2 net045__2 B0 p1 VDD pm1p2_svt_lp L=6e-08 W=5.85e-07
MXPC0_2 Y C0 net045__2 VDD pm1p2_svt_lp L=6e-08 W=5.85e-07
MXPC0_3 Y C0 net045__3 VDD pm1p2_svt_lp L=6e-08 W=5.85e-07
MXPB0_3 net045__3 B0 p1 VDD pm1p2_svt_lp L=6e-08 W=5.85e-07
MXPB0 net045 B0 p1 VDD pm1p2_svt_lp L=6e-08 W=5.85e-07
MXPC0 Y C0 net045 VDD pm1p2_svt_lp L=6e-08 W=5.85e-07
.ENDS

.SUBCKT AOI211X4H9R Y VDD VSS A0 A1 B0 C0
MXNA1_2 net17__2 A1 VSS VSS nm1p2_svt_lp L=6e-08 W=3.95e-07
MXNA0_2 Y A0 net17__2 VSS nm1p2_svt_lp L=6e-08 W=3.95e-07
MXNA0_3 Y A0 net17__3 VSS nm1p2_svt_lp L=6e-08 W=3.95e-07
MXNA1_3 net17__3 A1 VSS VSS nm1p2_svt_lp L=6e-08 W=3.95e-07
MXNA1 net17 A1 VSS VSS nm1p2_svt_lp L=6e-08 W=3.95e-07
MXNA0 Y A0 net17 VSS nm1p2_svt_lp L=6e-08 W=3.95e-07
MXNB0 Y B0 VSS VSS nm1p2_svt_lp L=6e-08 W=3.4e-07
MXNC0 Y C0 VSS VSS nm1p2_svt_lp L=6e-08 W=3.4e-07
MXNC0_2 Y C0 VSS VSS nm1p2_svt_lp L=6e-08 W=3.4e-07
MXNB0_2 Y B0 VSS VSS nm1p2_svt_lp L=6e-08 W=3.4e-07
MXPA1 p1 A1 VDD VDD pm1p2_svt_lp L=6e-08 W=5.85e-07
MXPA0 p1 A0 VDD VDD pm1p2_svt_lp L=6e-08 W=5.85e-07
MXPA0_2 p1 A0 VDD VDD pm1p2_svt_lp L=6e-08 W=5.85e-07
MXPA1_2 p1 A1 VDD VDD pm1p2_svt_lp L=6e-08 W=5.85e-07
MXPA1_3 p1 A1 VDD VDD pm1p2_svt_lp L=6e-08 W=5.85e-07
MXPA0_3 p1 A0 VDD VDD pm1p2_svt_lp L=6e-08 W=5.85e-07
MXPA0_4 p1 A0 VDD VDD pm1p2_svt_lp L=6e-08 W=5.85e-07
MXPA1_4 p1 A1 VDD VDD pm1p2_svt_lp L=6e-08 W=5.85e-07
MXPB0_2 net045__2 B0 p1 VDD pm1p2_svt_lp L=6e-08 W=5.85e-07
MXPC0_2 Y C0 net045__2 VDD pm1p2_svt_lp L=6e-08 W=5.85e-07
MXPC0_3 Y C0 net045__3 VDD pm1p2_svt_lp L=6e-08 W=5.85e-07
MXPB0_3 net045__3 B0 p1 VDD pm1p2_svt_lp L=6e-08 W=5.85e-07
MXPB0_4 net045__4 B0 p1 VDD pm1p2_svt_lp L=6e-08 W=5.85e-07
MXPC0_4 Y C0 net045__4 VDD pm1p2_svt_lp L=6e-08 W=5.85e-07
MXPC0 Y C0 net045 VDD pm1p2_svt_lp L=6e-08 W=5.85e-07
MXPB0 net045 B0 p1 VDD pm1p2_svt_lp L=6e-08 W=5.85e-07
.ENDS

.SUBCKT AOI221X0P5H9R Y VDD VSS A0 A1 B0 B1 C0
MXNA1 net17 A1 VSS VSS nm1p2_svt_lp L=6e-08 W=1.5e-07
MXNA0 Y A0 net17 VSS nm1p2_svt_lp L=6e-08 W=1.5e-07
MXNB0 Y B0 net26 VSS nm1p2_svt_lp L=6e-08 W=1.5e-07
MXNB1 net26 B1 VSS VSS nm1p2_svt_lp L=6e-08 W=1.5e-07
MXNC0 Y C0 VSS VSS nm1p2_svt_lp L=6e-08 W=1.5e-07
MXPA1 p1 A1 VDD VDD pm1p2_svt_lp L=6e-08 W=2.95e-07
MXPA0 p1 A0 VDD VDD pm1p2_svt_lp L=6e-08 W=2.95e-07
MXPB0 p2 B0 p1 VDD pm1p2_svt_lp L=6e-08 W=2.95e-07
MXPB1 p2 B1 p1 VDD pm1p2_svt_lp L=6e-08 W=2.95e-07
MXPC0 Y C0 p2 VDD pm1p2_svt_lp L=6e-08 W=2.95e-07
.ENDS

.SUBCKT AOI221X0P7H9R Y VDD VSS A0 A1 B0 B1 C0
MXNA1 net17 A1 VSS VSS nm1p2_svt_lp L=6e-08 W=2.65e-07
MXNA0 Y A0 net17 VSS nm1p2_svt_lp L=6e-08 W=2.65e-07
MXNB0 Y B0 net26 VSS nm1p2_svt_lp L=6e-08 W=2.65e-07
MXNB1 net26 B1 VSS VSS nm1p2_svt_lp L=6e-08 W=2.65e-07
MXNC0 Y C0 VSS VSS nm1p2_svt_lp L=6e-08 W=1.5e-07
MXPA1 p1 A1 VDD VDD pm1p2_svt_lp L=6e-08 W=5.3e-07
MXPA0 p1 A0 VDD VDD pm1p2_svt_lp L=6e-08 W=5.3e-07
MXPB0 p2 B0 p1 VDD pm1p2_svt_lp L=6e-08 W=5.3e-07
MXPB1 p2 B1 p1 VDD pm1p2_svt_lp L=6e-08 W=5.3e-07
MXPC0 Y C0 p2 VDD pm1p2_svt_lp L=6e-08 W=5.3e-07
.ENDS

.SUBCKT AOI221X1H9R Y VDD VSS A0 A1 B0 B1 C0
MXNA1 net17 A1 VSS VSS nm1p2_svt_lp L=6e-08 W=2.95e-07
MXNA0 Y A0 net17 VSS nm1p2_svt_lp L=6e-08 W=2.95e-07
MXNB0 Y B0 net26 VSS nm1p2_svt_lp L=6e-08 W=2.95e-07
MXNB1 net26 B1 VSS VSS nm1p2_svt_lp L=6e-08 W=2.95e-07
MXNC0 Y C0 VSS VSS nm1p2_svt_lp L=6e-08 W=1.7e-07
MXPA1 p1 A1 VDD VDD pm1p2_svt_lp L=6e-08 W=5.85e-07
MXPA0 p1 A0 VDD VDD pm1p2_svt_lp L=6e-08 W=5.85e-07
MXPB0 p2 B0 p1 VDD pm1p2_svt_lp L=6e-08 W=5.85e-07
MXPB1 p2 B1 p1 VDD pm1p2_svt_lp L=6e-08 W=5.85e-07
MXPC0 Y C0 p2 VDD pm1p2_svt_lp L=6e-08 W=5.85e-07
.ENDS

.SUBCKT AOI221X1P4H9R Y VDD VSS A0 A1 B0 B1 C0
MXNA1_2 net17__2 A1 VSS VSS nm1p2_svt_lp L=6e-08 W=2.1e-07
MXNA0_2 Y A0 net17__2 VSS nm1p2_svt_lp L=6e-08 W=2.1e-07
MXNA0 Y A0 net17 VSS nm1p2_svt_lp L=6e-08 W=2.1e-07
MXNA1 net17 A1 VSS VSS nm1p2_svt_lp L=6e-08 W=2.1e-07
MXNB1_2 net26__2 B1 VSS VSS nm1p2_svt_lp L=6e-08 W=2.1e-07
MXNB0_2 Y B0 net26__2 VSS nm1p2_svt_lp L=6e-08 W=2.1e-07
MXNB0 Y B0 net26 VSS nm1p2_svt_lp L=6e-08 W=2.1e-07
MXNB1 net26 B1 VSS VSS nm1p2_svt_lp L=6e-08 W=2.1e-07
MXNC0 Y C0 VSS VSS nm1p2_svt_lp L=6e-08 W=2.4e-07
MXPA1 p1 A1 VDD VDD pm1p2_svt_lp L=6e-08 W=4.15e-07
MXPA0 p1 A0 VDD VDD pm1p2_svt_lp L=6e-08 W=4.15e-07
MXPA0_2 p1 A0 VDD VDD pm1p2_svt_lp L=6e-08 W=4.15e-07
MXPA1_2 p1 A1 VDD VDD pm1p2_svt_lp L=6e-08 W=4.15e-07
MXPB1 p2 B1 p1 VDD pm1p2_svt_lp L=6e-08 W=4.15e-07
MXPB0 p2 B0 p1 VDD pm1p2_svt_lp L=6e-08 W=4.15e-07
MXPB0_2 p2 B0 p1 VDD pm1p2_svt_lp L=6e-08 W=4.15e-07
MXPB1_2 p2 B1 p1 VDD pm1p2_svt_lp L=6e-08 W=4.15e-07
MXPC0 Y C0 p2 VDD pm1p2_svt_lp L=6e-08 W=4.15e-07
MXPC0_2 Y C0 p2 VDD pm1p2_svt_lp L=6e-08 W=4.15e-07
.ENDS

.SUBCKT AOI221X2H9R Y VDD VSS A0 A1 B0 B1 C0
MXNA1_2 net17__2 A1 VSS VSS nm1p2_svt_lp L=6e-08 W=2.95e-07
MXNA0_2 Y A0 net17__2 VSS nm1p2_svt_lp L=6e-08 W=2.95e-07
MXNA0 Y A0 net17 VSS nm1p2_svt_lp L=6e-08 W=2.95e-07
MXNA1 net17 A1 VSS VSS nm1p2_svt_lp L=6e-08 W=2.95e-07
MXNB1_2 net26__2 B1 VSS VSS nm1p2_svt_lp L=6e-08 W=2.95e-07
MXNB0_2 Y B0 net26__2 VSS nm1p2_svt_lp L=6e-08 W=2.95e-07
MXNB0 Y B0 net26 VSS nm1p2_svt_lp L=6e-08 W=2.95e-07
MXNB1 net26 B1 VSS VSS nm1p2_svt_lp L=6e-08 W=2.95e-07
MXNC0 Y C0 VSS VSS nm1p2_svt_lp L=6e-08 W=3.4e-07
MXPA1 p1 A1 VDD VDD pm1p2_svt_lp L=6e-08 W=5.85e-07
MXPA0 p1 A0 VDD VDD pm1p2_svt_lp L=6e-08 W=5.85e-07
MXPA0_2 p1 A0 VDD VDD pm1p2_svt_lp L=6e-08 W=5.85e-07
MXPA1_2 p1 A1 VDD VDD pm1p2_svt_lp L=6e-08 W=5.85e-07
MXPB1 p2 B1 p1 VDD pm1p2_svt_lp L=6e-08 W=5.85e-07
MXPB0 p2 B0 p1 VDD pm1p2_svt_lp L=6e-08 W=5.85e-07
MXPB0_2 p2 B0 p1 VDD pm1p2_svt_lp L=6e-08 W=5.85e-07
MXPB1_2 p2 B1 p1 VDD pm1p2_svt_lp L=6e-08 W=5.85e-07
MXPC0 Y C0 p2 VDD pm1p2_svt_lp L=6e-08 W=5.85e-07
MXPC0_2 Y C0 p2 VDD pm1p2_svt_lp L=6e-08 W=5.85e-07
.ENDS

.SUBCKT AOI221X3H9R Y VDD VSS A0 A1 B0 B1 C0
MXNA1_2 net17__2 A1 VSS VSS nm1p2_svt_lp L=6e-08 W=2.95e-07
MXNA0_2 Y A0 net17__2 VSS nm1p2_svt_lp L=6e-08 W=2.95e-07
MXNA0_3 Y A0 net17__3 VSS nm1p2_svt_lp L=6e-08 W=2.95e-07
MXNA1_3 net17__3 A1 VSS VSS nm1p2_svt_lp L=6e-08 W=2.95e-07
MXNA1 net17 A1 VSS VSS nm1p2_svt_lp L=6e-08 W=2.95e-07
MXNA0 Y A0 net17 VSS nm1p2_svt_lp L=6e-08 W=2.95e-07
MXNB0_2 Y B0 net26__2 VSS nm1p2_svt_lp L=6e-08 W=2.95e-07
MXNB1_2 net26__2 B1 VSS VSS nm1p2_svt_lp L=6e-08 W=2.95e-07
MXNB1_3 net26__3 B1 VSS VSS nm1p2_svt_lp L=6e-08 W=2.95e-07
MXNB0_3 Y B0 net26__3 VSS nm1p2_svt_lp L=6e-08 W=2.95e-07
MXNB0 Y B0 net26 VSS nm1p2_svt_lp L=6e-08 W=2.95e-07
MXNB1 net26 B1 VSS VSS nm1p2_svt_lp L=6e-08 W=2.95e-07
MXNC0 Y C0 VSS VSS nm1p2_svt_lp L=6e-08 W=1.7e-07
MXNC0_2 Y C0 VSS VSS nm1p2_svt_lp L=6e-08 W=1.7e-07
MXNC0_3 Y C0 VSS VSS nm1p2_svt_lp L=6e-08 W=1.7e-07
MXPA1 p1 A1 VDD VDD pm1p2_svt_lp L=6e-08 W=5.85e-07
MXPA0 p1 A0 VDD VDD pm1p2_svt_lp L=6e-08 W=5.85e-07
MXPA0_2 p1 A0 VDD VDD pm1p2_svt_lp L=6e-08 W=5.85e-07
MXPA1_2 p1 A1 VDD VDD pm1p2_svt_lp L=6e-08 W=5.85e-07
MXPA1_3 p1 A1 VDD VDD pm1p2_svt_lp L=6e-08 W=5.85e-07
MXPA0_3 p1 A0 VDD VDD pm1p2_svt_lp L=6e-08 W=5.85e-07
MXPB0 p2 B0 p1 VDD pm1p2_svt_lp L=6e-08 W=5.85e-07
MXPB1 p2 B1 p1 VDD pm1p2_svt_lp L=6e-08 W=5.85e-07
MXPB1_2 p2 B1 p1 VDD pm1p2_svt_lp L=6e-08 W=5.85e-07
MXPB0_2 p2 B0 p1 VDD pm1p2_svt_lp L=6e-08 W=5.85e-07
MXPB0_3 p2 B0 p1 VDD pm1p2_svt_lp L=6e-08 W=5.85e-07
MXPB1_3 p2 B1 p1 VDD pm1p2_svt_lp L=6e-08 W=5.85e-07
MXPC0 Y C0 p2 VDD pm1p2_svt_lp L=6e-08 W=5.85e-07
MXPC0_2 Y C0 p2 VDD pm1p2_svt_lp L=6e-08 W=5.85e-07
MXPC0_3 Y C0 p2 VDD pm1p2_svt_lp L=6e-08 W=5.85e-07
.ENDS

.SUBCKT AOI221X4H9R Y VDD VSS A0 A1 B0 B1 C0
MXNA1_2 net17__2 A1 VSS VSS nm1p2_svt_lp L=6e-08 W=2.95e-07
MXNA0_2 Y A0 net17__2 VSS nm1p2_svt_lp L=6e-08 W=2.95e-07
MXNA0_3 Y A0 net17__3 VSS nm1p2_svt_lp L=6e-08 W=2.95e-07
MXNA1_3 net17__3 A1 VSS VSS nm1p2_svt_lp L=6e-08 W=2.95e-07
MXNA1_4 net17__4 A1 VSS VSS nm1p2_svt_lp L=6e-08 W=2.95e-07
MXNA0_4 Y A0 net17__4 VSS nm1p2_svt_lp L=6e-08 W=2.95e-07
MXNA0 Y A0 net17 VSS nm1p2_svt_lp L=6e-08 W=2.95e-07
MXNA1 net17 A1 VSS VSS nm1p2_svt_lp L=6e-08 W=2.95e-07
MXNB1_2 net26__2 B1 VSS VSS nm1p2_svt_lp L=6e-08 W=2.95e-07
MXNB0_2 Y B0 net26__2 VSS nm1p2_svt_lp L=6e-08 W=2.95e-07
MXNB0_3 Y B0 net26__3 VSS nm1p2_svt_lp L=6e-08 W=2.95e-07
MXNB1_3 net26__3 B1 VSS VSS nm1p2_svt_lp L=6e-08 W=2.95e-07
MXNB1_4 net26__4 B1 VSS VSS nm1p2_svt_lp L=6e-08 W=2.95e-07
MXNB0_4 Y B0 net26__4 VSS nm1p2_svt_lp L=6e-08 W=2.95e-07
MXNB0 Y B0 net26 VSS nm1p2_svt_lp L=6e-08 W=2.95e-07
MXNB1 net26 B1 VSS VSS nm1p2_svt_lp L=6e-08 W=2.95e-07
MXNC0 Y C0 VSS VSS nm1p2_svt_lp L=6e-08 W=1.7e-07
MXNC0_2 Y C0 VSS VSS nm1p2_svt_lp L=6e-08 W=1.7e-07
MXNC0_3 Y C0 VSS VSS nm1p2_svt_lp L=6e-08 W=1.7e-07
MXNC0_4 Y C0 VSS VSS nm1p2_svt_lp L=6e-08 W=1.7e-07
MXPA1 p1 A1 VDD VDD pm1p2_svt_lp L=6e-08 W=5.85e-07
MXPA0 p1 A0 VDD VDD pm1p2_svt_lp L=6e-08 W=5.85e-07
MXPA0_2 p1 A0 VDD VDD pm1p2_svt_lp L=6e-08 W=5.85e-07
MXPA1_2 p1 A1 VDD VDD pm1p2_svt_lp L=6e-08 W=5.85e-07
MXPA1_3 p1 A1 VDD VDD pm1p2_svt_lp L=6e-08 W=5.85e-07
MXPA0_3 p1 A0 VDD VDD pm1p2_svt_lp L=6e-08 W=5.85e-07
MXPA0_4 p1 A0 VDD VDD pm1p2_svt_lp L=6e-08 W=5.85e-07
MXPA1_4 p1 A1 VDD VDD pm1p2_svt_lp L=6e-08 W=5.85e-07
MXPB1 p2 B1 p1 VDD pm1p2_svt_lp L=6e-08 W=5.85e-07
MXPB0 p2 B0 p1 VDD pm1p2_svt_lp L=6e-08 W=5.85e-07
MXPB0_2 p2 B0 p1 VDD pm1p2_svt_lp L=6e-08 W=5.85e-07
MXPB1_2 p2 B1 p1 VDD pm1p2_svt_lp L=6e-08 W=5.85e-07
MXPB1_3 p2 B1 p1 VDD pm1p2_svt_lp L=6e-08 W=5.85e-07
MXPB0_3 p2 B0 p1 VDD pm1p2_svt_lp L=6e-08 W=5.85e-07
MXPB0_4 p2 B0 p1 VDD pm1p2_svt_lp L=6e-08 W=5.85e-07
MXPB1_4 p2 B1 p1 VDD pm1p2_svt_lp L=6e-08 W=5.85e-07
MXPC0 Y C0 p2 VDD pm1p2_svt_lp L=6e-08 W=5.85e-07
MXPC0_2 Y C0 p2 VDD pm1p2_svt_lp L=6e-08 W=5.85e-07
MXPC0_3 Y C0 p2 VDD pm1p2_svt_lp L=6e-08 W=5.85e-07
MXPC0_4 Y C0 p2 VDD pm1p2_svt_lp L=6e-08 W=5.85e-07
.ENDS

.SUBCKT AOI222X0P5H9R Y VDD VSS A0 A1 B0 B1 C0 C1
MXNA1 net17 A1 VSS VSS nm1p2_svt_lp L=6e-08 W=1.5e-07
MXNA0 Y A0 net17 VSS nm1p2_svt_lp L=6e-08 W=1.5e-07
MXNB0 Y B0 net26 VSS nm1p2_svt_lp L=6e-08 W=1.5e-07
MXNB1 net26 B1 VSS VSS nm1p2_svt_lp L=6e-08 W=1.5e-07
MXNC1 net29 C1 VSS VSS nm1p2_svt_lp L=6e-08 W=1.5e-07
MXNC0 Y C0 net29 VSS nm1p2_svt_lp L=6e-08 W=1.5e-07
MXPA1 p1 A1 VDD VDD pm1p2_svt_lp L=6e-08 W=2.95e-07
MXPA0 p1 A0 VDD VDD pm1p2_svt_lp L=6e-08 W=2.95e-07
MXPB0 p2 B0 p1 VDD pm1p2_svt_lp L=6e-08 W=2.95e-07
MXPB1 p2 B1 p1 VDD pm1p2_svt_lp L=6e-08 W=2.95e-07
MXPC1 Y C1 p2 VDD pm1p2_svt_lp L=6e-08 W=2.95e-07
MXPC0 Y C0 p2 VDD pm1p2_svt_lp L=6e-08 W=2.95e-07
.ENDS

.SUBCKT AOI222X0P7H9R Y VDD VSS A0 A1 B0 B1 C0 C1
MXNA1 net17 A1 VSS VSS nm1p2_svt_lp L=6e-08 W=2.1e-07
MXNA0 Y A0 net17 VSS nm1p2_svt_lp L=6e-08 W=2.1e-07
MXNB0 Y B0 net26 VSS nm1p2_svt_lp L=6e-08 W=2.1e-07
MXNB1 net26 B1 VSS VSS nm1p2_svt_lp L=6e-08 W=2.1e-07
MXNC1 net29 C1 VSS VSS nm1p2_svt_lp L=6e-08 W=2.1e-07
MXNC0 Y C0 net29 VSS nm1p2_svt_lp L=6e-08 W=2.1e-07
MXPA1 p1 A1 VDD VDD pm1p2_svt_lp L=6e-08 W=4.15e-07
MXPA0 p1 A0 VDD VDD pm1p2_svt_lp L=6e-08 W=4.15e-07
MXPB0 p2 B0 p1 VDD pm1p2_svt_lp L=6e-08 W=4.15e-07
MXPB1 p2 B1 p1 VDD pm1p2_svt_lp L=6e-08 W=4.15e-07
MXPC1 Y C1 p2 VDD pm1p2_svt_lp L=6e-08 W=4.15e-07
MXPC0 Y C0 p2 VDD pm1p2_svt_lp L=6e-08 W=4.15e-07
.ENDS

.SUBCKT AOI222X1H9R Y VDD VSS A0 A1 B0 B1 C0 C1
MXNA1 net17 A1 VSS VSS nm1p2_svt_lp L=6e-08 W=2.95e-07
MXNA0 Y A0 net17 VSS nm1p2_svt_lp L=6e-08 W=2.95e-07
MXNB0 Y B0 net26 VSS nm1p2_svt_lp L=6e-08 W=2.95e-07
MXNB1 net26 B1 VSS VSS nm1p2_svt_lp L=6e-08 W=2.95e-07
MXNC1 net29 C1 VSS VSS nm1p2_svt_lp L=6e-08 W=2.95e-07
MXNC0 Y C0 net29 VSS nm1p2_svt_lp L=6e-08 W=2.95e-07
MXPA1 p1 A1 VDD VDD pm1p2_svt_lp L=6e-08 W=5.85e-07
MXPA0 p1 A0 VDD VDD pm1p2_svt_lp L=6e-08 W=5.85e-07
MXPB0 p2 B0 p1 VDD pm1p2_svt_lp L=6e-08 W=5.85e-07
MXPB1 p2 B1 p1 VDD pm1p2_svt_lp L=6e-08 W=5.85e-07
MXPC1 Y C1 p2 VDD pm1p2_svt_lp L=6e-08 W=5.85e-07
MXPC0 Y C0 p2 VDD pm1p2_svt_lp L=6e-08 W=5.85e-07
.ENDS

.SUBCKT AOI222X1P4H9R Y VDD VSS A0 A1 B0 B1 C0 C1
MXNA1_2 net17__2 A1 VSS VSS nm1p2_svt_lp L=6e-08 W=2.1e-07
MXNA0_2 Y A0 net17__2 VSS nm1p2_svt_lp L=6e-08 W=2.1e-07
MXNA0 Y A0 net17 VSS nm1p2_svt_lp L=6e-08 W=2.1e-07
MXNA1 net17 A1 VSS VSS nm1p2_svt_lp L=6e-08 W=2.1e-07
MXNB1_2 net26__2 B1 VSS VSS nm1p2_svt_lp L=6e-08 W=2.1e-07
MXNB0_2 Y B0 net26__2 VSS nm1p2_svt_lp L=6e-08 W=2.1e-07
MXNB0 Y B0 net26 VSS nm1p2_svt_lp L=6e-08 W=2.1e-07
MXNB1 net26 B1 VSS VSS nm1p2_svt_lp L=6e-08 W=2.1e-07
MXNC1_2 net29__2 C1 VSS VSS nm1p2_svt_lp L=6e-08 W=2.1e-07
MXNC0_2 Y C0 net29__2 VSS nm1p2_svt_lp L=6e-08 W=2.1e-07
MXNC0 Y C0 net29 VSS nm1p2_svt_lp L=6e-08 W=2.1e-07
MXNC1 net29 C1 VSS VSS nm1p2_svt_lp L=6e-08 W=2.1e-07
MXPA1 p1 A1 VDD VDD pm1p2_svt_lp L=6e-08 W=4.15e-07
MXPA0 p1 A0 VDD VDD pm1p2_svt_lp L=6e-08 W=4.15e-07
MXPA0_2 p1 A0 VDD VDD pm1p2_svt_lp L=6e-08 W=4.15e-07
MXPA1_2 p1 A1 VDD VDD pm1p2_svt_lp L=6e-08 W=4.15e-07
MXPB1 p2 B1 p1 VDD pm1p2_svt_lp L=6e-08 W=4.15e-07
MXPB0 p2 B0 p1 VDD pm1p2_svt_lp L=6e-08 W=4.15e-07
MXPB0_2 p2 B0 p1 VDD pm1p2_svt_lp L=6e-08 W=4.15e-07
MXPB1_2 p2 B1 p1 VDD pm1p2_svt_lp L=6e-08 W=4.15e-07
MXPC1 Y C1 p2 VDD pm1p2_svt_lp L=6e-08 W=4.15e-07
MXPC0 Y C0 p2 VDD pm1p2_svt_lp L=6e-08 W=4.15e-07
MXPC0_2 Y C0 p2 VDD pm1p2_svt_lp L=6e-08 W=4.15e-07
MXPC1_2 Y C1 p2 VDD pm1p2_svt_lp L=6e-08 W=4.15e-07
.ENDS

.SUBCKT AOI222X2H9R Y VDD VSS A0 A1 B0 B1 C0 C1
MXNA1_2 net17__2 A1 VSS VSS nm1p2_svt_lp L=6e-08 W=2.95e-07
MXNA0_2 Y A0 net17__2 VSS nm1p2_svt_lp L=6e-08 W=2.95e-07
MXNA0 Y A0 net17 VSS nm1p2_svt_lp L=6e-08 W=2.95e-07
MXNA1 net17 A1 VSS VSS nm1p2_svt_lp L=6e-08 W=2.95e-07
MXNB1_2 net26__2 B1 VSS VSS nm1p2_svt_lp L=6e-08 W=2.95e-07
MXNB0_2 Y B0 net26__2 VSS nm1p2_svt_lp L=6e-08 W=2.95e-07
MXNB0 Y B0 net26 VSS nm1p2_svt_lp L=6e-08 W=2.95e-07
MXNB1 net26 B1 VSS VSS nm1p2_svt_lp L=6e-08 W=2.95e-07
MXNC1_2 net29__2 C1 VSS VSS nm1p2_svt_lp L=6e-08 W=2.95e-07
MXNC0_2 Y C0 net29__2 VSS nm1p2_svt_lp L=6e-08 W=2.95e-07
MXNC0 Y C0 net29 VSS nm1p2_svt_lp L=6e-08 W=2.95e-07
MXNC1 net29 C1 VSS VSS nm1p2_svt_lp L=6e-08 W=2.95e-07
MXPA1 p1 A1 VDD VDD pm1p2_svt_lp L=6e-08 W=5.85e-07
MXPA0 p1 A0 VDD VDD pm1p2_svt_lp L=6e-08 W=5.85e-07
MXPA0_2 p1 A0 VDD VDD pm1p2_svt_lp L=6e-08 W=5.85e-07
MXPA1_2 p1 A1 VDD VDD pm1p2_svt_lp L=6e-08 W=5.85e-07
MXPB1 p2 B1 p1 VDD pm1p2_svt_lp L=6e-08 W=5.85e-07
MXPB0 p2 B0 p1 VDD pm1p2_svt_lp L=6e-08 W=5.85e-07
MXPB0_2 p2 B0 p1 VDD pm1p2_svt_lp L=6e-08 W=5.85e-07
MXPB1_2 p2 B1 p1 VDD pm1p2_svt_lp L=6e-08 W=5.85e-07
MXPC1 Y C1 p2 VDD pm1p2_svt_lp L=6e-08 W=5.85e-07
MXPC0 Y C0 p2 VDD pm1p2_svt_lp L=6e-08 W=5.85e-07
MXPC0_2 Y C0 p2 VDD pm1p2_svt_lp L=6e-08 W=5.85e-07
MXPC1_2 Y C1 p2 VDD pm1p2_svt_lp L=6e-08 W=5.85e-07
.ENDS

.SUBCKT AOI222X3H9R Y VDD VSS A0 A1 B0 B1 C0 C1
MXNA1_2 net17__2 A1 VSS VSS nm1p2_svt_lp L=6e-08 W=2.95e-07
MXNA0_2 Y A0 net17__2 VSS nm1p2_svt_lp L=6e-08 W=2.95e-07
MXNA0_3 Y A0 net17__3 VSS nm1p2_svt_lp L=6e-08 W=2.95e-07
MXNA1_3 net17__3 A1 VSS VSS nm1p2_svt_lp L=6e-08 W=2.95e-07
MXNA1 net17 A1 VSS VSS nm1p2_svt_lp L=6e-08 W=2.95e-07
MXNA0 Y A0 net17 VSS nm1p2_svt_lp L=6e-08 W=2.95e-07
MXNB0_2 Y B0 net26__2 VSS nm1p2_svt_lp L=6e-08 W=2.95e-07
MXNB1_2 net26__2 B1 VSS VSS nm1p2_svt_lp L=6e-08 W=2.95e-07
MXNB1_3 net26__3 B1 VSS VSS nm1p2_svt_lp L=6e-08 W=2.95e-07
MXNB0_3 Y B0 net26__3 VSS nm1p2_svt_lp L=6e-08 W=2.95e-07
MXNB0 Y B0 net26 VSS nm1p2_svt_lp L=6e-08 W=2.95e-07
MXNB1 net26 B1 VSS VSS nm1p2_svt_lp L=6e-08 W=2.95e-07
MXNC1_2 net29__2 C1 VSS VSS nm1p2_svt_lp L=6e-08 W=2.95e-07
MXNC0_2 Y C0 net29__2 VSS nm1p2_svt_lp L=6e-08 W=2.95e-07
MXNC0_3 Y C0 net29__3 VSS nm1p2_svt_lp L=6e-08 W=2.95e-07
MXNC1_3 net29__3 C1 VSS VSS nm1p2_svt_lp L=6e-08 W=2.95e-07
MXNC1 net29 C1 VSS VSS nm1p2_svt_lp L=6e-08 W=2.95e-07
MXNC0 Y C0 net29 VSS nm1p2_svt_lp L=6e-08 W=2.95e-07
MXPA1 p1 A1 VDD VDD pm1p2_svt_lp L=6e-08 W=5.85e-07
MXPA0 p1 A0 VDD VDD pm1p2_svt_lp L=6e-08 W=5.85e-07
MXPA0_2 p1 A0 VDD VDD pm1p2_svt_lp L=6e-08 W=5.85e-07
MXPA1_2 p1 A1 VDD VDD pm1p2_svt_lp L=6e-08 W=5.85e-07
MXPA1_3 p1 A1 VDD VDD pm1p2_svt_lp L=6e-08 W=5.85e-07
MXPA0_3 p1 A0 VDD VDD pm1p2_svt_lp L=6e-08 W=5.85e-07
MXPB0 p2 B0 p1 VDD pm1p2_svt_lp L=6e-08 W=5.85e-07
MXPB1 p2 B1 p1 VDD pm1p2_svt_lp L=6e-08 W=5.85e-07
MXPB1_2 p2 B1 p1 VDD pm1p2_svt_lp L=6e-08 W=5.85e-07
MXPB0_2 p2 B0 p1 VDD pm1p2_svt_lp L=6e-08 W=5.85e-07
MXPB0_3 p2 B0 p1 VDD pm1p2_svt_lp L=6e-08 W=5.85e-07
MXPB1_3 p2 B1 p1 VDD pm1p2_svt_lp L=6e-08 W=5.85e-07
MXPC1 Y C1 p2 VDD pm1p2_svt_lp L=6e-08 W=5.85e-07
MXPC0 Y C0 p2 VDD pm1p2_svt_lp L=6e-08 W=5.85e-07
MXPC0_2 Y C0 p2 VDD pm1p2_svt_lp L=6e-08 W=5.85e-07
MXPC1_2 Y C1 p2 VDD pm1p2_svt_lp L=6e-08 W=5.85e-07
MXPC1_3 Y C1 p2 VDD pm1p2_svt_lp L=6e-08 W=5.85e-07
MXPC0_3 Y C0 p2 VDD pm1p2_svt_lp L=6e-08 W=5.85e-07
.ENDS

.SUBCKT AOI222X4H9R Y VDD VSS A0 A1 B0 B1 C0 C1
MXNA1_2 net17__2 A1 VSS VSS nm1p2_svt_lp L=6e-08 W=2.95e-07
MXNA0_2 Y A0 net17__2 VSS nm1p2_svt_lp L=6e-08 W=2.95e-07
MXNA0_3 Y A0 net17__3 VSS nm1p2_svt_lp L=6e-08 W=2.95e-07
MXNA1_3 net17__3 A1 VSS VSS nm1p2_svt_lp L=6e-08 W=2.95e-07
MXNA1_4 net17__4 A1 VSS VSS nm1p2_svt_lp L=6e-08 W=2.95e-07
MXNA0_4 Y A0 net17__4 VSS nm1p2_svt_lp L=6e-08 W=2.95e-07
MXNA0 Y A0 net17 VSS nm1p2_svt_lp L=6e-08 W=2.95e-07
MXNA1 net17 A1 VSS VSS nm1p2_svt_lp L=6e-08 W=2.95e-07
MXNB1_2 net26__2 B1 VSS VSS nm1p2_svt_lp L=6e-08 W=2.95e-07
MXNB0_2 Y B0 net26__2 VSS nm1p2_svt_lp L=6e-08 W=2.95e-07
MXNB0_3 Y B0 net26__3 VSS nm1p2_svt_lp L=6e-08 W=2.95e-07
MXNB1_3 net26__3 B1 VSS VSS nm1p2_svt_lp L=6e-08 W=2.95e-07
MXNB1_4 net26__4 B1 VSS VSS nm1p2_svt_lp L=6e-08 W=2.95e-07
MXNB0_4 Y B0 net26__4 VSS nm1p2_svt_lp L=6e-08 W=2.95e-07
MXNB0 Y B0 net26 VSS nm1p2_svt_lp L=6e-08 W=2.95e-07
MXNB1 net26 B1 VSS VSS nm1p2_svt_lp L=6e-08 W=2.95e-07
MXNC1_2 net29__2 C1 VSS VSS nm1p2_svt_lp L=6e-08 W=2.95e-07
MXNC0_2 Y C0 net29__2 VSS nm1p2_svt_lp L=6e-08 W=2.95e-07
MXNC0_3 Y C0 net29__3 VSS nm1p2_svt_lp L=6e-08 W=2.95e-07
MXNC1_3 net29__3 C1 VSS VSS nm1p2_svt_lp L=6e-08 W=2.95e-07
MXNC1_4 net29__4 C1 VSS VSS nm1p2_svt_lp L=6e-08 W=2.95e-07
MXNC0_4 Y C0 net29__4 VSS nm1p2_svt_lp L=6e-08 W=2.95e-07
MXNC0 Y C0 net29 VSS nm1p2_svt_lp L=6e-08 W=2.95e-07
MXNC1 net29 C1 VSS VSS nm1p2_svt_lp L=6e-08 W=2.95e-07
MXPA1 p1 A1 VDD VDD pm1p2_svt_lp L=6e-08 W=5.85e-07
MXPA0 p1 A0 VDD VDD pm1p2_svt_lp L=6e-08 W=5.85e-07
MXPA0_2 p1 A0 VDD VDD pm1p2_svt_lp L=6e-08 W=5.85e-07
MXPA1_2 p1 A1 VDD VDD pm1p2_svt_lp L=6e-08 W=5.85e-07
MXPA1_3 p1 A1 VDD VDD pm1p2_svt_lp L=6e-08 W=5.85e-07
MXPA0_3 p1 A0 VDD VDD pm1p2_svt_lp L=6e-08 W=5.85e-07
MXPA0_4 p1 A0 VDD VDD pm1p2_svt_lp L=6e-08 W=5.85e-07
MXPA1_4 p1 A1 VDD VDD pm1p2_svt_lp L=6e-08 W=5.85e-07
MXPB1 p2 B1 p1 VDD pm1p2_svt_lp L=6e-08 W=5.85e-07
MXPB0 p2 B0 p1 VDD pm1p2_svt_lp L=6e-08 W=5.85e-07
MXPB0_2 p2 B0 p1 VDD pm1p2_svt_lp L=6e-08 W=5.85e-07
MXPB1_2 p2 B1 p1 VDD pm1p2_svt_lp L=6e-08 W=5.85e-07
MXPB1_3 p2 B1 p1 VDD pm1p2_svt_lp L=6e-08 W=5.85e-07
MXPB0_3 p2 B0 p1 VDD pm1p2_svt_lp L=6e-08 W=5.85e-07
MXPB0_4 p2 B0 p1 VDD pm1p2_svt_lp L=6e-08 W=5.85e-07
MXPB1_4 p2 B1 p1 VDD pm1p2_svt_lp L=6e-08 W=5.85e-07
MXPC1 Y C1 p2 VDD pm1p2_svt_lp L=6e-08 W=5.85e-07
MXPC0 Y C0 p2 VDD pm1p2_svt_lp L=6e-08 W=5.85e-07
MXPC0_2 Y C0 p2 VDD pm1p2_svt_lp L=6e-08 W=5.85e-07
MXPC1_2 Y C1 p2 VDD pm1p2_svt_lp L=6e-08 W=5.85e-07
MXPC1_3 Y C1 p2 VDD pm1p2_svt_lp L=6e-08 W=5.85e-07
MXPC0_3 Y C0 p2 VDD pm1p2_svt_lp L=6e-08 W=5.85e-07
MXPC0_4 Y C0 p2 VDD pm1p2_svt_lp L=6e-08 W=5.85e-07
MXPC1_4 Y C1 p2 VDD pm1p2_svt_lp L=6e-08 W=5.85e-07
.ENDS

.SUBCKT AOI31X0P5H9R Y VDD VSS A0 A1 A2 B0
MI0_MXNB3 XI0_n1 A2 VSS VSS nm1p2_svt_lp L=6e-08 W=3.45e-07
MI0_MXNB2 XI0_n2 A1 XI0_n1 VSS nm1p2_svt_lp L=6e-08 W=3.45e-07
MI0_MXNB1 Y A0 XI0_n2 VSS nm1p2_svt_lp L=6e-08 W=3.45e-07
MI0_MXNA1 Y B0 VSS VSS nm1p2_svt_lp L=6e-08 W=1.5e-07
MI0_MXPB3 XI0_p1 A2 VDD VDD pm1p2_svt_lp L=6e-08 W=3.75e-07
MI0_MXPB2 XI0_p1 A1 VDD VDD pm1p2_svt_lp L=6e-08 W=3.75e-07
MI0_MXPB1 XI0_p1 A0 VDD VDD pm1p2_svt_lp L=6e-08 W=3.75e-07
MI0_MXPA1 Y B0 XI0_p1 VDD pm1p2_svt_lp L=6e-08 W=3.75e-07
.ENDS

.SUBCKT AOI31X0P7H9R Y VDD VSS A0 A1 A2 B0
MI0_MXNB3 XI0_n1 A2 VSS VSS nm1p2_svt_lp L=6e-08 W=3.5e-07
MI0_MXNB2 XI0_n2 A1 XI0_n1 VSS nm1p2_svt_lp L=6e-08 W=3.5e-07
MI0_MXNB1 Y A0 XI0_n2 VSS nm1p2_svt_lp L=6e-08 W=3.5e-07
MI0_MXNA1 Y B0 VSS VSS nm1p2_svt_lp L=6e-08 W=1.55e-07
MI0_MXPB3 XI0_p1 A2 VDD VDD pm1p2_svt_lp L=6e-08 W=3.8e-07
MI0_MXPB2 XI0_p1 A1 VDD VDD pm1p2_svt_lp L=6e-08 W=3.8e-07
MI0_MXPB1 XI0_p1 A0 VDD VDD pm1p2_svt_lp L=6e-08 W=3.8e-07
MI0_MXPA1 Y B0 XI0_p1 VDD pm1p2_svt_lp L=6e-08 W=3.8e-07
.ENDS

.SUBCKT AOI31X1H9R Y VDD VSS A0 A1 A2 B0
MI0_MXNB3 XI0_n1 A2 VSS VSS nm1p2_svt_lp L=6e-08 W=4.95e-07
MI0_MXNB2 XI0_n2 A1 XI0_n1 VSS nm1p2_svt_lp L=6e-08 W=4.95e-07
MI0_MXNB1 Y A0 XI0_n2 VSS nm1p2_svt_lp L=6e-08 W=4.95e-07
MI0_MXNA1 Y B0 VSS VSS nm1p2_svt_lp L=6e-08 W=2.15e-07
MI0_MXPB3 XI0_p1 A2 VDD VDD pm1p2_svt_lp L=6e-08 W=5.4e-07
MI0_MXPB2 XI0_p1 A1 VDD VDD pm1p2_svt_lp L=6e-08 W=5.4e-07
MI0_MXPB1 XI0_p1 A0 VDD VDD pm1p2_svt_lp L=6e-08 W=5.4e-07
MI0_MXPA1 Y B0 XI0_p1 VDD pm1p2_svt_lp L=6e-08 W=5.4e-07
.ENDS

.SUBCKT AOI31X1P4H9R Y VDD VSS A0 A1 A2 B0
MI0_MXNB3_2 XI0_n1__2 A2 VSS VSS nm1p2_svt_lp L=6e-08 W=3.5e-07
MI0_MXNB2_2 XI0_n2__2 A1 XI0_n1__2 VSS nm1p2_svt_lp L=6e-08 W=3.5e-07
MI0_MXNB1_2 Y A0 XI0_n2__2 VSS nm1p2_svt_lp L=6e-08 W=3.5e-07
MI0_MXNB1 Y A0 XI0_n2 VSS nm1p2_svt_lp L=6e-08 W=3.5e-07
MI0_MXNB2 XI0_n2 A1 XI0_n1 VSS nm1p2_svt_lp L=6e-08 W=3.5e-07
MI0_MXNB3 XI0_n1 A2 VSS VSS nm1p2_svt_lp L=6e-08 W=3.5e-07
MI0_MXNA1 Y B0 VSS VSS nm1p2_svt_lp L=6e-08 W=3.1e-07
MI0_MXPB3 XI0_p1 A2 VDD VDD pm1p2_svt_lp L=6e-08 W=3.8e-07
MI0_MXPB2 XI0_p1 A1 VDD VDD pm1p2_svt_lp L=6e-08 W=3.8e-07
MI0_MXPB1 XI0_p1 A0 VDD VDD pm1p2_svt_lp L=6e-08 W=3.8e-07
MI0_MXPB1_2 XI0_p1 A0 VDD VDD pm1p2_svt_lp L=6e-08 W=3.8e-07
MI0_MXPB2_2 XI0_p1 A1 VDD VDD pm1p2_svt_lp L=6e-08 W=3.8e-07
MI0_MXPB3_2 XI0_p1 A2 VDD VDD pm1p2_svt_lp L=6e-08 W=3.8e-07
MI0_MXPA1 Y B0 XI0_p1 VDD pm1p2_svt_lp L=6e-08 W=3.8e-07
MI0_MXPA1_2 Y B0 XI0_p1 VDD pm1p2_svt_lp L=6e-08 W=3.8e-07
.ENDS

.SUBCKT AOI31X2H9R Y VDD VSS A0 A1 A2 B0
MI0_MXNB3 XI0_n1 A2 VSS VSS nm1p2_svt_lp L=6e-08 W=4.95e-07
MI0_MXNB3_2 XI0_n1 A2 VSS VSS nm1p2_svt_lp L=6e-08 W=4.95e-07
MI0_MXNB2_2 XI0_n2__2 A1 XI0_n1 VSS nm1p2_svt_lp L=6e-08 W=4.95e-07
MI0_MXNB1_2 Y A0 XI0_n2__2 VSS nm1p2_svt_lp L=6e-08 W=4.95e-07
MI0_MXNB1 Y A0 XI0_n2 VSS nm1p2_svt_lp L=6e-08 W=4.95e-07
MI0_MXNB2 XI0_n2 A1 XI0_n1 VSS nm1p2_svt_lp L=6e-08 W=4.95e-07
MI0_MXNA1 Y B0 VSS VSS nm1p2_svt_lp L=6e-08 W=4.3e-07
MI0_MXPB3 XI0_p1 A2 VDD VDD pm1p2_svt_lp L=6e-08 W=5.4e-07
MI0_MXPB3_2 XI0_p1 A2 VDD VDD pm1p2_svt_lp L=6e-08 W=5.4e-07
MI0_MXPB2 XI0_p1 A1 VDD VDD pm1p2_svt_lp L=6e-08 W=5.4e-07
MI0_MXPB1 XI0_p1 A0 VDD VDD pm1p2_svt_lp L=6e-08 W=5.4e-07
MI0_MXPB1_2 XI0_p1 A0 VDD VDD pm1p2_svt_lp L=6e-08 W=5.4e-07
MI0_MXPB2_2 XI0_p1 A1 VDD VDD pm1p2_svt_lp L=6e-08 W=5.4e-07
MI0_MXPA1 Y B0 XI0_p1 VDD pm1p2_svt_lp L=6e-08 W=5.4e-07
MI0_MXPA1_2 Y B0 XI0_p1 VDD pm1p2_svt_lp L=6e-08 W=5.4e-07
.ENDS

.SUBCKT AOI31X3H9R Y VDD VSS A0 A1 A2 B0
MI0_MXNB3 XI0_n1 A2 VSS VSS nm1p2_svt_lp L=6e-08 W=4.95e-07
MI0_MXNB3_2 XI0_n1 A2 VSS VSS nm1p2_svt_lp L=6e-08 W=4.95e-07
MI0_MXNB3_3 XI0_n1 A2 VSS VSS nm1p2_svt_lp L=6e-08 W=4.95e-07
MI0_MXNB2 XI0_n2 A1 XI0_n1 VSS nm1p2_svt_lp L=6e-08 W=4.95e-07
MI0_MXNB2_2 XI0_n2 A1 XI0_n1 VSS nm1p2_svt_lp L=6e-08 W=4.95e-07
MI0_MXNB2_3 XI0_n2 A1 XI0_n1 VSS nm1p2_svt_lp L=6e-08 W=4.95e-07
MI0_MXNB1 Y A0 XI0_n2 VSS nm1p2_svt_lp L=6e-08 W=4.95e-07
MI0_MXNB1_2 Y A0 XI0_n2 VSS nm1p2_svt_lp L=6e-08 W=4.95e-07
MI0_MXNB1_3 Y A0 XI0_n2 VSS nm1p2_svt_lp L=6e-08 W=4.95e-07
MI0_MXNA1 Y B0 VSS VSS nm1p2_svt_lp L=6e-08 W=2.15e-07
MI0_MXNA1_2 Y B0 VSS VSS nm1p2_svt_lp L=6e-08 W=2.15e-07
MI0_MXNA1_3 Y B0 VSS VSS nm1p2_svt_lp L=6e-08 W=2.15e-07
MI0_MXPB3 XI0_p1 A2 VDD VDD pm1p2_svt_lp L=6e-08 W=5.4e-07
MI0_MXPB3_2 XI0_p1 A2 VDD VDD pm1p2_svt_lp L=6e-08 W=5.4e-07
MI0_MXPB3_3 XI0_p1 A2 VDD VDD pm1p2_svt_lp L=6e-08 W=5.4e-07
MI0_MXPB2 XI0_p1 A1 VDD VDD pm1p2_svt_lp L=6e-08 W=5.4e-07
MI0_MXPB2_2 XI0_p1 A1 VDD VDD pm1p2_svt_lp L=6e-08 W=5.4e-07
MI0_MXPB2_3 XI0_p1 A1 VDD VDD pm1p2_svt_lp L=6e-08 W=5.4e-07
MI0_MXPB1 XI0_p1 A0 VDD VDD pm1p2_svt_lp L=6e-08 W=5.4e-07
MI0_MXPB1_2 XI0_p1 A0 VDD VDD pm1p2_svt_lp L=6e-08 W=5.4e-07
MI0_MXPB1_3 XI0_p1 A0 VDD VDD pm1p2_svt_lp L=6e-08 W=5.4e-07
MI0_MXPA1 Y B0 XI0_p1 VDD pm1p2_svt_lp L=6e-08 W=5.4e-07
MI0_MXPA1_2 Y B0 XI0_p1 VDD pm1p2_svt_lp L=6e-08 W=5.4e-07
MI0_MXPA1_3 Y B0 XI0_p1 VDD pm1p2_svt_lp L=6e-08 W=5.4e-07
.ENDS

.SUBCKT AOI31X4H9R Y VDD VSS A0 A1 A2 B0
MI0_MXNB3 XI0_n1 A2 VSS VSS nm1p2_svt_lp L=6e-08 W=4.95e-07
MI0_MXNB3_2 XI0_n1 A2 VSS VSS nm1p2_svt_lp L=6e-08 W=4.95e-07
MI0_MXNB3_3 XI0_n1 A2 VSS VSS nm1p2_svt_lp L=6e-08 W=4.95e-07
MI0_MXNB3_4 XI0_n1 A2 VSS VSS nm1p2_svt_lp L=6e-08 W=4.95e-07
MI0_MXNB2 XI0_n2 A1 XI0_n1 VSS nm1p2_svt_lp L=6e-08 W=4.95e-07
MI0_MXNB2_2 XI0_n2 A1 XI0_n1 VSS nm1p2_svt_lp L=6e-08 W=4.95e-07
MI0_MXNB2_3 XI0_n2 A1 XI0_n1 VSS nm1p2_svt_lp L=6e-08 W=4.95e-07
MI0_MXNB2_4 XI0_n2 A1 XI0_n1 VSS nm1p2_svt_lp L=6e-08 W=4.95e-07
MI0_MXNB1 Y A0 XI0_n2 VSS nm1p2_svt_lp L=6e-08 W=4.95e-07
MI0_MXNB1_2 Y A0 XI0_n2 VSS nm1p2_svt_lp L=6e-08 W=4.95e-07
MI0_MXNB1_3 Y A0 XI0_n2 VSS nm1p2_svt_lp L=6e-08 W=4.95e-07
MI0_MXNB1_4 Y A0 XI0_n2 VSS nm1p2_svt_lp L=6e-08 W=4.95e-07
MI0_MXNA1 Y B0 VSS VSS nm1p2_svt_lp L=6e-08 W=4.3e-07
MI0_MXNA1_2 Y B0 VSS VSS nm1p2_svt_lp L=6e-08 W=4.3e-07
MI0_MXPB3 XI0_p1 A2 VDD VDD pm1p2_svt_lp L=6e-08 W=5.4e-07
MI0_MXPB3_2 XI0_p1 A2 VDD VDD pm1p2_svt_lp L=6e-08 W=5.4e-07
MI0_MXPB3_3 XI0_p1 A2 VDD VDD pm1p2_svt_lp L=6e-08 W=5.4e-07
MI0_MXPB3_4 XI0_p1 A2 VDD VDD pm1p2_svt_lp L=6e-08 W=5.4e-07
MI0_MXPB2 XI0_p1 A1 VDD VDD pm1p2_svt_lp L=6e-08 W=5.4e-07
MI0_MXPB2_2 XI0_p1 A1 VDD VDD pm1p2_svt_lp L=6e-08 W=5.4e-07
MI0_MXPB2_3 XI0_p1 A1 VDD VDD pm1p2_svt_lp L=6e-08 W=5.4e-07
MI0_MXPB2_4 XI0_p1 A1 VDD VDD pm1p2_svt_lp L=6e-08 W=5.4e-07
MI0_MXPB1 XI0_p1 A0 VDD VDD pm1p2_svt_lp L=6e-08 W=5.4e-07
MI0_MXPB1_2 XI0_p1 A0 VDD VDD pm1p2_svt_lp L=6e-08 W=5.4e-07
MI0_MXPB1_3 XI0_p1 A0 VDD VDD pm1p2_svt_lp L=6e-08 W=5.4e-07
MI0_MXPB1_4 XI0_p1 A0 VDD VDD pm1p2_svt_lp L=6e-08 W=5.4e-07
MI0_MXPA1 Y B0 XI0_p1 VDD pm1p2_svt_lp L=6e-08 W=5.4e-07
MI0_MXPA1_2 Y B0 XI0_p1 VDD pm1p2_svt_lp L=6e-08 W=5.4e-07
MI0_MXPA1_3 Y B0 XI0_p1 VDD pm1p2_svt_lp L=6e-08 W=5.4e-07
MI0_MXPA1_4 Y B0 XI0_p1 VDD pm1p2_svt_lp L=6e-08 W=5.4e-07
.ENDS

.SUBCKT AOI31X6H9R Y VDD VSS A0 A1 A2 B0
MI0_MXNB3 XI0_n1 A2 VSS VSS nm1p2_svt_lp L=6e-08 W=4.95e-07
MI0_MXNB3_2 XI0_n1 A2 VSS VSS nm1p2_svt_lp L=6e-08 W=4.95e-07
MI0_MXNB3_3 XI0_n1 A2 VSS VSS nm1p2_svt_lp L=6e-08 W=4.95e-07
MI0_MXNB3_4 XI0_n1 A2 VSS VSS nm1p2_svt_lp L=6e-08 W=4.95e-07
MI0_MXNB3_5 XI0_n1 A2 VSS VSS nm1p2_svt_lp L=6e-08 W=4.95e-07
MI0_MXNB3_6 XI0_n1 A2 VSS VSS nm1p2_svt_lp L=6e-08 W=4.95e-07
MI0_MXNB2_2 XI0_n2__2 A1 XI0_n1 VSS nm1p2_svt_lp L=6e-08 W=4.95e-07
MI0_MXNB1_2 Y A0 XI0_n2__2 VSS nm1p2_svt_lp L=6e-08 W=4.95e-07
MI0_MXNB1_3 Y A0 XI0_n2__3 VSS nm1p2_svt_lp L=6e-08 W=4.95e-07
MI0_MXNB2_3 XI0_n2__3 A1 XI0_n1 VSS nm1p2_svt_lp L=6e-08 W=4.95e-07
MI0_MXNB2_4 XI0_n2__4 A1 XI0_n1 VSS nm1p2_svt_lp L=6e-08 W=4.95e-07
MI0_MXNB1_4 Y A0 XI0_n2__4 VSS nm1p2_svt_lp L=6e-08 W=4.95e-07
MI0_MXNB1_5 Y A0 XI0_n2__5 VSS nm1p2_svt_lp L=6e-08 W=4.95e-07
MI0_MXNB2_5 XI0_n2__5 A1 XI0_n1 VSS nm1p2_svt_lp L=6e-08 W=4.95e-07
MI0_MXNB2_6 XI0_n2__6 A1 XI0_n1 VSS nm1p2_svt_lp L=6e-08 W=4.95e-07
MI0_MXNB1_6 Y A0 XI0_n2__6 VSS nm1p2_svt_lp L=6e-08 W=4.95e-07
MI0_MXNB1 Y A0 XI0_n2 VSS nm1p2_svt_lp L=6e-08 W=4.95e-07
MI0_MXNB2 XI0_n2 A1 XI0_n1 VSS nm1p2_svt_lp L=6e-08 W=4.95e-07
MI0_MXNA1 Y B0 VSS VSS nm1p2_svt_lp L=6e-08 W=4.3e-07
MI0_MXNA1_2 Y B0 VSS VSS nm1p2_svt_lp L=6e-08 W=4.3e-07
MI0_MXNA1_3 Y B0 VSS VSS nm1p2_svt_lp L=6e-08 W=4.3e-07
MI0_MXPB3 XI0_p1 A2 VDD VDD pm1p2_svt_lp L=6e-08 W=5.4e-07
MI0_MXPB3_2 XI0_p1 A2 VDD VDD pm1p2_svt_lp L=6e-08 W=5.4e-07
MI0_MXPB3_3 XI0_p1 A2 VDD VDD pm1p2_svt_lp L=6e-08 W=5.4e-07
MI0_MXPB3_4 XI0_p1 A2 VDD VDD pm1p2_svt_lp L=6e-08 W=5.4e-07
MI0_MXPB3_5 XI0_p1 A2 VDD VDD pm1p2_svt_lp L=6e-08 W=5.4e-07
MI0_MXPB3_6 XI0_p1 A2 VDD VDD pm1p2_svt_lp L=6e-08 W=5.4e-07
MI0_MXPB2 XI0_p1 A1 VDD VDD pm1p2_svt_lp L=6e-08 W=5.4e-07
MI0_MXPB1 XI0_p1 A0 VDD VDD pm1p2_svt_lp L=6e-08 W=5.4e-07
MI0_MXPB1_2 XI0_p1 A0 VDD VDD pm1p2_svt_lp L=6e-08 W=5.4e-07
MI0_MXPB2_2 XI0_p1 A1 VDD VDD pm1p2_svt_lp L=6e-08 W=5.4e-07
MI0_MXPB2_3 XI0_p1 A1 VDD VDD pm1p2_svt_lp L=6e-08 W=5.4e-07
MI0_MXPB1_3 XI0_p1 A0 VDD VDD pm1p2_svt_lp L=6e-08 W=5.4e-07
MI0_MXPB1_4 XI0_p1 A0 VDD VDD pm1p2_svt_lp L=6e-08 W=5.4e-07
MI0_MXPB2_4 XI0_p1 A1 VDD VDD pm1p2_svt_lp L=6e-08 W=5.4e-07
MI0_MXPB2_5 XI0_p1 A1 VDD VDD pm1p2_svt_lp L=6e-08 W=5.4e-07
MI0_MXPB1_5 XI0_p1 A0 VDD VDD pm1p2_svt_lp L=6e-08 W=5.4e-07
MI0_MXPB1_6 XI0_p1 A0 VDD VDD pm1p2_svt_lp L=6e-08 W=5.4e-07
MI0_MXPB2_6 XI0_p1 A1 VDD VDD pm1p2_svt_lp L=6e-08 W=5.4e-07
MI0_MXPA1 Y B0 XI0_p1 VDD pm1p2_svt_lp L=6e-08 W=5.4e-07
MI0_MXPA1_2 Y B0 XI0_p1 VDD pm1p2_svt_lp L=6e-08 W=5.4e-07
MI0_MXPA1_3 Y B0 XI0_p1 VDD pm1p2_svt_lp L=6e-08 W=5.4e-07
MI0_MXPA1_4 Y B0 XI0_p1 VDD pm1p2_svt_lp L=6e-08 W=5.4e-07
MI0_MXPA1_5 Y B0 XI0_p1 VDD pm1p2_svt_lp L=6e-08 W=5.4e-07
MI0_MXPA1_6 Y B0 XI0_p1 VDD pm1p2_svt_lp L=6e-08 W=5.4e-07
.ENDS

.SUBCKT AOI32X0P5H9R Y VDD VSS A0 A1 A2 B0 B1
MI0_MXNB3 XI0_n1B A2 VSS VSS nm1p2_svt_lp L=6e-08 W=2.5e-07
MI0_MXNB2 XI0_n2B A1 XI0_n1B VSS nm1p2_svt_lp L=6e-08 W=2.5e-07
MI0_MXNB1 Y A0 XI0_n2B VSS nm1p2_svt_lp L=6e-08 W=2.5e-07
MI0_MXNA1 Y B0 XI0_n1A VSS nm1p2_svt_lp L=6e-08 W=1.9e-07
MI0_MXNA2 XI0_n1A B1 VSS VSS nm1p2_svt_lp L=6e-08 W=1.9e-07
MI0_MXPB3 XI0_p1 A2 VDD VDD pm1p2_svt_lp L=6e-08 W=2.7e-07
MI0_MXPB2 XI0_p1 A1 VDD VDD pm1p2_svt_lp L=6e-08 W=2.7e-07
MI0_MXPB1 XI0_p1 A0 VDD VDD pm1p2_svt_lp L=6e-08 W=2.7e-07
MI0_MXPA1 Y B0 XI0_p1 VDD pm1p2_svt_lp L=6e-08 W=2.7e-07
MI0_MXPA2 Y B1 XI0_p1 VDD pm1p2_svt_lp L=6e-08 W=2.7e-07
.ENDS

.SUBCKT AOI32X0P7H9R Y VDD VSS A0 A1 A2 B0 B1
MI0_MXNB3 XI0_n1B A2 VSS VSS nm1p2_svt_lp L=6e-08 W=3.5e-07
MI0_MXNB2 XI0_n2B A1 XI0_n1B VSS nm1p2_svt_lp L=6e-08 W=3.5e-07
MI0_MXNB1 Y A0 XI0_n2B VSS nm1p2_svt_lp L=6e-08 W=3.5e-07
MI0_MXNA1 Y B0 XI0_n1A VSS nm1p2_svt_lp L=6e-08 W=2.7e-07
MI0_MXNA2 XI0_n1A B1 VSS VSS nm1p2_svt_lp L=6e-08 W=2.7e-07
MI0_MXPB3 XI0_p1 A2 VDD VDD pm1p2_svt_lp L=6e-08 W=3.8e-07
MI0_MXPB2 XI0_p1 A1 VDD VDD pm1p2_svt_lp L=6e-08 W=3.8e-07
MI0_MXPB1 XI0_p1 A0 VDD VDD pm1p2_svt_lp L=6e-08 W=3.8e-07
MI0_MXPA1 Y B0 XI0_p1 VDD pm1p2_svt_lp L=6e-08 W=3.8e-07
MI0_MXPA2 Y B1 XI0_p1 VDD pm1p2_svt_lp L=6e-08 W=3.8e-07
.ENDS

.SUBCKT AOI32X1H9R Y VDD VSS A0 A1 A2 B0 B1
MI0_MXNB3 XI0_n1B A2 VSS VSS nm1p2_svt_lp L=6e-08 W=4.95e-07
MI0_MXNB2 XI0_n2B A1 XI0_n1B VSS nm1p2_svt_lp L=6e-08 W=4.95e-07
MI0_MXNB1 Y A0 XI0_n2B VSS nm1p2_svt_lp L=6e-08 W=4.95e-07
MI0_MXNA1 Y B0 XI0_n1A VSS nm1p2_svt_lp L=6e-08 W=3.8e-07
MI0_MXNA2 XI0_n1A B1 VSS VSS nm1p2_svt_lp L=6e-08 W=3.8e-07
MI0_MXPB3 XI0_p1 A2 VDD VDD pm1p2_svt_lp L=6e-08 W=5.4e-07
MI0_MXPB2 XI0_p1 A1 VDD VDD pm1p2_svt_lp L=6e-08 W=5.4e-07
MI0_MXPB1 XI0_p1 A0 VDD VDD pm1p2_svt_lp L=6e-08 W=5.4e-07
MI0_MXPA1 Y B0 XI0_p1 VDD pm1p2_svt_lp L=6e-08 W=5.4e-07
MI0_MXPA2 Y B1 XI0_p1 VDD pm1p2_svt_lp L=6e-08 W=5.4e-07
.ENDS

.SUBCKT AOI32X1P4H9R Y VDD VSS A0 A1 A2 B0 B1
MI0_MXNB3_2 XI0_n1B__2 A2 VSS VSS nm1p2_svt_lp L=6e-08 W=3.5e-07
MI0_MXNB2_2 XI0_n2B__2 A1 XI0_n1B__2 VSS nm1p2_svt_lp L=6e-08 W=3.5e-07
MI0_MXNB1_2 Y A0 XI0_n2B__2 VSS nm1p2_svt_lp L=6e-08 W=3.5e-07
MI0_MXNB1 Y A0 XI0_n2B VSS nm1p2_svt_lp L=6e-08 W=3.5e-07
MI0_MXNB2 XI0_n2B A1 XI0_n1B VSS nm1p2_svt_lp L=6e-08 W=3.5e-07
MI0_MXNB3 XI0_n1B A2 VSS VSS nm1p2_svt_lp L=6e-08 W=3.5e-07
MI0_MXNA2_2 XI0_n1A__2 B1 VSS VSS nm1p2_svt_lp L=6e-08 W=2.7e-07
MI0_MXNA1_2 Y B0 XI0_n1A__2 VSS nm1p2_svt_lp L=6e-08 W=2.7e-07
MI0_MXNA1 Y B0 XI0_n1A VSS nm1p2_svt_lp L=6e-08 W=2.7e-07
MI0_MXNA2 XI0_n1A B1 VSS VSS nm1p2_svt_lp L=6e-08 W=2.7e-07
MI0_MXPB3 XI0_p1 A2 VDD VDD pm1p2_svt_lp L=6e-08 W=3.8e-07
MI0_MXPB2 XI0_p1 A1 VDD VDD pm1p2_svt_lp L=6e-08 W=3.8e-07
MI0_MXPB1 XI0_p1 A0 VDD VDD pm1p2_svt_lp L=6e-08 W=3.8e-07
MI0_MXPB1_2 XI0_p1 A0 VDD VDD pm1p2_svt_lp L=6e-08 W=3.8e-07
MI0_MXPB2_2 XI0_p1 A1 VDD VDD pm1p2_svt_lp L=6e-08 W=3.8e-07
MI0_MXPB3_2 XI0_p1 A2 VDD VDD pm1p2_svt_lp L=6e-08 W=3.8e-07
MI0_MXPA2 Y B1 XI0_p1 VDD pm1p2_svt_lp L=6e-08 W=3.8e-07
MI0_MXPA1 Y B0 XI0_p1 VDD pm1p2_svt_lp L=6e-08 W=3.8e-07
MI0_MXPA1_2 Y B0 XI0_p1 VDD pm1p2_svt_lp L=6e-08 W=3.8e-07
MI0_MXPA2_2 Y B1 XI0_p1 VDD pm1p2_svt_lp L=6e-08 W=3.8e-07
.ENDS

.SUBCKT AOI32X2H9R Y VDD VSS A0 A1 A2 B0 B1
MI0_MXNB3_2 XI0_n1B__2 A2 VSS VSS nm1p2_svt_lp L=6e-08 W=4.95e-07
MI0_MXNB2_2 XI0_n2B__2 A1 XI0_n1B__2 VSS nm1p2_svt_lp L=6e-08 W=4.95e-07
MI0_MXNB1_2 Y A0 XI0_n2B__2 VSS nm1p2_svt_lp L=6e-08 W=4.95e-07
MI0_MXNB1 Y A0 XI0_n2B VSS nm1p2_svt_lp L=6e-08 W=4.95e-07
MI0_MXNB2 XI0_n2B A1 XI0_n1B VSS nm1p2_svt_lp L=6e-08 W=4.95e-07
MI0_MXNB3 XI0_n1B A2 VSS VSS nm1p2_svt_lp L=6e-08 W=4.95e-07
MI0_MXNA2_2 XI0_n1A__2 B1 VSS VSS nm1p2_svt_lp L=6e-08 W=3.8e-07
MI0_MXNA1_2 Y B0 XI0_n1A__2 VSS nm1p2_svt_lp L=6e-08 W=3.8e-07
MI0_MXNA1 Y B0 XI0_n1A VSS nm1p2_svt_lp L=6e-08 W=3.8e-07
MI0_MXNA2 XI0_n1A B1 VSS VSS nm1p2_svt_lp L=6e-08 W=3.8e-07
MI0_MXPB3 XI0_p1 A2 VDD VDD pm1p2_svt_lp L=6e-08 W=5.4e-07
MI0_MXPB2 XI0_p1 A1 VDD VDD pm1p2_svt_lp L=6e-08 W=5.4e-07
MI0_MXPB1 XI0_p1 A0 VDD VDD pm1p2_svt_lp L=6e-08 W=5.4e-07
MI0_MXPB1_2 XI0_p1 A0 VDD VDD pm1p2_svt_lp L=6e-08 W=5.4e-07
MI0_MXPB2_2 XI0_p1 A1 VDD VDD pm1p2_svt_lp L=6e-08 W=5.4e-07
MI0_MXPB3_2 XI0_p1 A2 VDD VDD pm1p2_svt_lp L=6e-08 W=5.4e-07
MI0_MXPA2 Y B1 XI0_p1 VDD pm1p2_svt_lp L=6e-08 W=5.4e-07
MI0_MXPA1 Y B0 XI0_p1 VDD pm1p2_svt_lp L=6e-08 W=5.4e-07
MI0_MXPA1_2 Y B0 XI0_p1 VDD pm1p2_svt_lp L=6e-08 W=5.4e-07
MI0_MXPA2_2 Y B1 XI0_p1 VDD pm1p2_svt_lp L=6e-08 W=5.4e-07
.ENDS

.SUBCKT AOI32X3H9R Y VDD VSS A0 A1 A2 B0 B1
MI0_MXNB3 XI0_n1B A2 VSS VSS nm1p2_svt_lp L=6e-08 W=4.95e-07
MI0_MXNB3_2 XI0_n1B A2 VSS VSS nm1p2_svt_lp L=6e-08 W=4.95e-07
MI0_MXNB3_3 XI0_n1B A2 VSS VSS nm1p2_svt_lp L=6e-08 W=4.95e-07
MI0_MXNB2 XI0_n2B A1 XI0_n1B VSS nm1p2_svt_lp L=6e-08 W=4.95e-07
MI0_MXNB2_2 XI0_n2B A1 XI0_n1B VSS nm1p2_svt_lp L=6e-08 W=4.95e-07
MI0_MXNB2_3 XI0_n2B A1 XI0_n1B VSS nm1p2_svt_lp L=6e-08 W=4.95e-07
MI0_MXNB1 Y A0 XI0_n2B VSS nm1p2_svt_lp L=6e-08 W=4.95e-07
MI0_MXNB1_2 Y A0 XI0_n2B VSS nm1p2_svt_lp L=6e-08 W=4.95e-07
MI0_MXNB1_3 Y A0 XI0_n2B VSS nm1p2_svt_lp L=6e-08 W=4.95e-07
MI0_MXNA1 Y B0 XI0_n1A VSS nm1p2_svt_lp L=6e-08 W=3.8e-07
MI0_MXNA1_2 Y B0 XI0_n1A VSS nm1p2_svt_lp L=6e-08 W=3.8e-07
MI0_MXNA1_3 Y B0 XI0_n1A VSS nm1p2_svt_lp L=6e-08 W=3.8e-07
MI0_MXNA2 XI0_n1A B1 VSS VSS nm1p2_svt_lp L=6e-08 W=3.8e-07
MI0_MXNA2_2 XI0_n1A B1 VSS VSS nm1p2_svt_lp L=6e-08 W=3.8e-07
MI0_MXNA2_3 XI0_n1A B1 VSS VSS nm1p2_svt_lp L=6e-08 W=3.8e-07
MI0_MXPB3 XI0_p1 A2 VDD VDD pm1p2_svt_lp L=6e-08 W=5.4e-07
MI0_MXPB3_2 XI0_p1 A2 VDD VDD pm1p2_svt_lp L=6e-08 W=5.4e-07
MI0_MXPB3_3 XI0_p1 A2 VDD VDD pm1p2_svt_lp L=6e-08 W=5.4e-07
MI0_MXPB2 XI0_p1 A1 VDD VDD pm1p2_svt_lp L=6e-08 W=5.4e-07
MI0_MXPB2_2 XI0_p1 A1 VDD VDD pm1p2_svt_lp L=6e-08 W=5.4e-07
MI0_MXPB2_3 XI0_p1 A1 VDD VDD pm1p2_svt_lp L=6e-08 W=5.4e-07
MI0_MXPB1 XI0_p1 A0 VDD VDD pm1p2_svt_lp L=6e-08 W=5.4e-07
MI0_MXPB1_2 XI0_p1 A0 VDD VDD pm1p2_svt_lp L=6e-08 W=5.4e-07
MI0_MXPB1_3 XI0_p1 A0 VDD VDD pm1p2_svt_lp L=6e-08 W=5.4e-07
MI0_MXPA1 Y B0 XI0_p1 VDD pm1p2_svt_lp L=6e-08 W=5.4e-07
MI0_MXPA1_2 Y B0 XI0_p1 VDD pm1p2_svt_lp L=6e-08 W=5.4e-07
MI0_MXPA1_3 Y B0 XI0_p1 VDD pm1p2_svt_lp L=6e-08 W=5.4e-07
MI0_MXPA2 Y B1 XI0_p1 VDD pm1p2_svt_lp L=6e-08 W=5.4e-07
MI0_MXPA2_2 Y B1 XI0_p1 VDD pm1p2_svt_lp L=6e-08 W=5.4e-07
MI0_MXPA2_3 Y B1 XI0_p1 VDD pm1p2_svt_lp L=6e-08 W=5.4e-07
.ENDS

.SUBCKT AOI32X4H9R Y VDD VSS A0 A1 A2 B0 B1
MI0_MXNB3 XI0_n1B A2 VSS VSS nm1p2_svt_lp L=6e-08 W=4.95e-07
MI0_MXNB3_2 XI0_n1B A2 VSS VSS nm1p2_svt_lp L=6e-08 W=4.95e-07
MI0_MXNB3_3 XI0_n1B A2 VSS VSS nm1p2_svt_lp L=6e-08 W=4.95e-07
MI0_MXNB3_4 XI0_n1B A2 VSS VSS nm1p2_svt_lp L=6e-08 W=4.95e-07
MI0_MXNB2_2 XI0_n2B__2 A1 XI0_n1B VSS nm1p2_svt_lp L=6e-08 W=4.95e-07
MI0_MXNB1_2 Y A0 XI0_n2B__2 VSS nm1p2_svt_lp L=6e-08 W=4.95e-07
MI0_MXNB1_3 Y A0 XI0_n2B__3 VSS nm1p2_svt_lp L=6e-08 W=4.95e-07
MI0_MXNB2_3 XI0_n2B__3 A1 XI0_n1B VSS nm1p2_svt_lp L=6e-08 W=4.95e-07
MI0_MXNB2_4 XI0_n2B__4 A1 XI0_n1B VSS nm1p2_svt_lp L=6e-08 W=4.95e-07
MI0_MXNB1_4 Y A0 XI0_n2B__4 VSS nm1p2_svt_lp L=6e-08 W=4.95e-07
MI0_MXNB1 Y A0 XI0_n2B VSS nm1p2_svt_lp L=6e-08 W=4.95e-07
MI0_MXNB2 XI0_n2B A1 XI0_n1B VSS nm1p2_svt_lp L=6e-08 W=4.95e-07
MI0_MXNA2_2 XI0_n1A__2 B1 VSS VSS nm1p2_svt_lp L=6e-08 W=3.8e-07
MI0_MXNA1_2 Y B0 XI0_n1A__2 VSS nm1p2_svt_lp L=6e-08 W=3.8e-07
MI0_MXNA1_3 Y B0 XI0_n1A__3 VSS nm1p2_svt_lp L=6e-08 W=3.8e-07
MI0_MXNA2_3 XI0_n1A__3 B1 VSS VSS nm1p2_svt_lp L=6e-08 W=3.8e-07
MI0_MXNA2_4 XI0_n1A__4 B1 VSS VSS nm1p2_svt_lp L=6e-08 W=3.8e-07
MI0_MXNA1_4 Y B0 XI0_n1A__4 VSS nm1p2_svt_lp L=6e-08 W=3.8e-07
MI0_MXNA1 Y B0 XI0_n1A VSS nm1p2_svt_lp L=6e-08 W=3.8e-07
MI0_MXNA2 XI0_n1A B1 VSS VSS nm1p2_svt_lp L=6e-08 W=3.8e-07
MI0_MXPB3 XI0_p1 A2 VDD VDD pm1p2_svt_lp L=6e-08 W=5.4e-07
MI0_MXPB3_2 XI0_p1 A2 VDD VDD pm1p2_svt_lp L=6e-08 W=5.4e-07
MI0_MXPB3_3 XI0_p1 A2 VDD VDD pm1p2_svt_lp L=6e-08 W=5.4e-07
MI0_MXPB3_4 XI0_p1 A2 VDD VDD pm1p2_svt_lp L=6e-08 W=5.4e-07
MI0_MXPB2 XI0_p1 A1 VDD VDD pm1p2_svt_lp L=6e-08 W=5.4e-07
MI0_MXPB1 XI0_p1 A0 VDD VDD pm1p2_svt_lp L=6e-08 W=5.4e-07
MI0_MXPB1_2 XI0_p1 A0 VDD VDD pm1p2_svt_lp L=6e-08 W=5.4e-07
MI0_MXPB2_2 XI0_p1 A1 VDD VDD pm1p2_svt_lp L=6e-08 W=5.4e-07
MI0_MXPB2_3 XI0_p1 A1 VDD VDD pm1p2_svt_lp L=6e-08 W=5.4e-07
MI0_MXPB1_3 XI0_p1 A0 VDD VDD pm1p2_svt_lp L=6e-08 W=5.4e-07
MI0_MXPB1_4 XI0_p1 A0 VDD VDD pm1p2_svt_lp L=6e-08 W=5.4e-07
MI0_MXPB2_4 XI0_p1 A1 VDD VDD pm1p2_svt_lp L=6e-08 W=5.4e-07
MI0_MXPA2 Y B1 XI0_p1 VDD pm1p2_svt_lp L=6e-08 W=5.4e-07
MI0_MXPA1 Y B0 XI0_p1 VDD pm1p2_svt_lp L=6e-08 W=5.4e-07
MI0_MXPA1_2 Y B0 XI0_p1 VDD pm1p2_svt_lp L=6e-08 W=5.4e-07
MI0_MXPA2_2 Y B1 XI0_p1 VDD pm1p2_svt_lp L=6e-08 W=5.4e-07
MI0_MXPA2_3 Y B1 XI0_p1 VDD pm1p2_svt_lp L=6e-08 W=5.4e-07
MI0_MXPA1_3 Y B0 XI0_p1 VDD pm1p2_svt_lp L=6e-08 W=5.4e-07
MI0_MXPA1_4 Y B0 XI0_p1 VDD pm1p2_svt_lp L=6e-08 W=5.4e-07
MI0_MXPA2_4 Y B1 XI0_p1 VDD pm1p2_svt_lp L=6e-08 W=5.4e-07
.ENDS

.SUBCKT AOI32X6H9R Y VDD VSS A0 A1 A2 B0 B1
MI0_MXNB3 XI0_n1B A2 VSS VSS nm1p2_svt_lp L=6e-08 W=4.95e-07
MI0_MXNB3_2 XI0_n1B A2 VSS VSS nm1p2_svt_lp L=6e-08 W=4.95e-07
MI0_MXNB3_3 XI0_n1B A2 VSS VSS nm1p2_svt_lp L=6e-08 W=4.95e-07
MI0_MXNB3_4 XI0_n1B A2 VSS VSS nm1p2_svt_lp L=6e-08 W=4.95e-07
MI0_MXNB3_5 XI0_n1B A2 VSS VSS nm1p2_svt_lp L=6e-08 W=4.95e-07
MI0_MXNB3_6 XI0_n1B A2 VSS VSS nm1p2_svt_lp L=6e-08 W=4.95e-07
MI0_MXNB2_2 XI0_n2B__2 A1 XI0_n1B VSS nm1p2_svt_lp L=6e-08 W=4.95e-07
MI0_MXNB1_2 Y A0 XI0_n2B__2 VSS nm1p2_svt_lp L=6e-08 W=4.95e-07
MI0_MXNB1_3 Y A0 XI0_n2B__3 VSS nm1p2_svt_lp L=6e-08 W=4.95e-07
MI0_MXNB2_3 XI0_n2B__3 A1 XI0_n1B VSS nm1p2_svt_lp L=6e-08 W=4.95e-07
MI0_MXNB2_4 XI0_n2B__4 A1 XI0_n1B VSS nm1p2_svt_lp L=6e-08 W=4.95e-07
MI0_MXNB1_4 Y A0 XI0_n2B__4 VSS nm1p2_svt_lp L=6e-08 W=4.95e-07
MI0_MXNB1_5 Y A0 XI0_n2B__5 VSS nm1p2_svt_lp L=6e-08 W=4.95e-07
MI0_MXNB2_5 XI0_n2B__5 A1 XI0_n1B VSS nm1p2_svt_lp L=6e-08 W=4.95e-07
MI0_MXNB2_6 XI0_n2B__6 A1 XI0_n1B VSS nm1p2_svt_lp L=6e-08 W=4.95e-07
MI0_MXNB1_6 Y A0 XI0_n2B__6 VSS nm1p2_svt_lp L=6e-08 W=4.95e-07
MI0_MXNB1 Y A0 XI0_n2B VSS nm1p2_svt_lp L=6e-08 W=4.95e-07
MI0_MXNB2 XI0_n2B A1 XI0_n1B VSS nm1p2_svt_lp L=6e-08 W=4.95e-07
MI0_MXNA2_2 XI0_n1A__2 B1 VSS VSS nm1p2_svt_lp L=6e-08 W=3.8e-07
MI0_MXNA1_2 Y B0 XI0_n1A__2 VSS nm1p2_svt_lp L=6e-08 W=3.8e-07
MI0_MXNA1_3 Y B0 XI0_n1A__3 VSS nm1p2_svt_lp L=6e-08 W=3.8e-07
MI0_MXNA2_3 XI0_n1A__3 B1 VSS VSS nm1p2_svt_lp L=6e-08 W=3.8e-07
MI0_MXNA2_4 XI0_n1A__4 B1 VSS VSS nm1p2_svt_lp L=6e-08 W=3.8e-07
MI0_MXNA1_4 Y B0 XI0_n1A__4 VSS nm1p2_svt_lp L=6e-08 W=3.8e-07
MI0_MXNA1_5 Y B0 XI0_n1A__5 VSS nm1p2_svt_lp L=6e-08 W=3.8e-07
MI0_MXNA2_5 XI0_n1A__5 B1 VSS VSS nm1p2_svt_lp L=6e-08 W=3.8e-07
MI0_MXNA2_6 XI0_n1A__6 B1 VSS VSS nm1p2_svt_lp L=6e-08 W=3.8e-07
MI0_MXNA1_6 Y B0 XI0_n1A__6 VSS nm1p2_svt_lp L=6e-08 W=3.8e-07
MI0_MXNA1 Y B0 XI0_n1A VSS nm1p2_svt_lp L=6e-08 W=3.8e-07
MI0_MXNA2 XI0_n1A B1 VSS VSS nm1p2_svt_lp L=6e-08 W=3.8e-07
MI0_MXPB3 XI0_p1 A2 VDD VDD pm1p2_svt_lp L=6e-08 W=5.4e-07
MI0_MXPB3_2 XI0_p1 A2 VDD VDD pm1p2_svt_lp L=6e-08 W=5.4e-07
MI0_MXPB3_3 XI0_p1 A2 VDD VDD pm1p2_svt_lp L=6e-08 W=5.4e-07
MI0_MXPB3_4 XI0_p1 A2 VDD VDD pm1p2_svt_lp L=6e-08 W=5.4e-07
MI0_MXPB3_5 XI0_p1 A2 VDD VDD pm1p2_svt_lp L=6e-08 W=5.4e-07
MI0_MXPB3_6 XI0_p1 A2 VDD VDD pm1p2_svt_lp L=6e-08 W=5.4e-07
MI0_MXPB2 XI0_p1 A1 VDD VDD pm1p2_svt_lp L=6e-08 W=5.4e-07
MI0_MXPB1 XI0_p1 A0 VDD VDD pm1p2_svt_lp L=6e-08 W=5.4e-07
MI0_MXPB1_2 XI0_p1 A0 VDD VDD pm1p2_svt_lp L=6e-08 W=5.4e-07
MI0_MXPB2_2 XI0_p1 A1 VDD VDD pm1p2_svt_lp L=6e-08 W=5.4e-07
MI0_MXPB2_3 XI0_p1 A1 VDD VDD pm1p2_svt_lp L=6e-08 W=5.4e-07
MI0_MXPB1_3 XI0_p1 A0 VDD VDD pm1p2_svt_lp L=6e-08 W=5.4e-07
MI0_MXPB1_4 XI0_p1 A0 VDD VDD pm1p2_svt_lp L=6e-08 W=5.4e-07
MI0_MXPB2_4 XI0_p1 A1 VDD VDD pm1p2_svt_lp L=6e-08 W=5.4e-07
MI0_MXPB2_5 XI0_p1 A1 VDD VDD pm1p2_svt_lp L=6e-08 W=5.4e-07
MI0_MXPB1_5 XI0_p1 A0 VDD VDD pm1p2_svt_lp L=6e-08 W=5.4e-07
MI0_MXPB1_6 XI0_p1 A0 VDD VDD pm1p2_svt_lp L=6e-08 W=5.4e-07
MI0_MXPB2_6 XI0_p1 A1 VDD VDD pm1p2_svt_lp L=6e-08 W=5.4e-07
MI0_MXPA2 Y B1 XI0_p1 VDD pm1p2_svt_lp L=6e-08 W=5.4e-07
MI0_MXPA1 Y B0 XI0_p1 VDD pm1p2_svt_lp L=6e-08 W=5.4e-07
MI0_MXPA1_2 Y B0 XI0_p1 VDD pm1p2_svt_lp L=6e-08 W=5.4e-07
MI0_MXPA2_2 Y B1 XI0_p1 VDD pm1p2_svt_lp L=6e-08 W=5.4e-07
MI0_MXPA2_3 Y B1 XI0_p1 VDD pm1p2_svt_lp L=6e-08 W=5.4e-07
MI0_MXPA1_3 Y B0 XI0_p1 VDD pm1p2_svt_lp L=6e-08 W=5.4e-07
MI0_MXPA1_4 Y B0 XI0_p1 VDD pm1p2_svt_lp L=6e-08 W=5.4e-07
MI0_MXPA2_4 Y B1 XI0_p1 VDD pm1p2_svt_lp L=6e-08 W=5.4e-07
MI0_MXPA2_5 Y B1 XI0_p1 VDD pm1p2_svt_lp L=6e-08 W=5.4e-07
MI0_MXPA1_5 Y B0 XI0_p1 VDD pm1p2_svt_lp L=6e-08 W=5.4e-07
MI0_MXPA1_6 Y B0 XI0_p1 VDD pm1p2_svt_lp L=6e-08 W=5.4e-07
MI0_MXPA2_6 Y B1 XI0_p1 VDD pm1p2_svt_lp L=6e-08 W=5.4e-07
.ENDS

.SUBCKT OA21X0P5H9R Y VDD VSS A0 A1 B0
MI0_MXNB2 XI0_n1 A1 VSS VSS nm1p2_svt_lp L=6e-08 W=2.5e-07
MI0_MXNB1 XI0_n1 A0 VSS VSS nm1p2_svt_lp L=6e-08 W=2.5e-07
MI0_MXNA1 ny B0 XI0_n1 VSS nm1p2_svt_lp L=6e-08 W=2.5e-07
MI1_MXNA1 Y ny VSS VSS nm1p2_svt_lp L=6e-08 W=2.1e-07
MI0_MXPB2 XI0_p1 A1 VDD VDD pm1p2_svt_lp L=6e-08 W=3.55e-07
MI0_MXPB1 ny A0 XI0_p1 VDD pm1p2_svt_lp L=6e-08 W=3.55e-07
MI0_MXPA1 ny B0 VDD VDD pm1p2_svt_lp L=6e-08 W=2e-07
MI1_MXPA1 Y ny VDD VDD pm1p2_svt_lp L=6e-08 W=2.95e-07
.ENDS

.SUBCKT OA21X0P7H9R Y VDD VSS A0 A1 B0
MI0_MXNB2 XI0_n1 A1 VSS VSS nm1p2_svt_lp L=6e-08 W=2.95e-07
MI0_MXNB1 XI0_n1 A0 VSS VSS nm1p2_svt_lp L=6e-08 W=2.95e-07
MI0_MXNA1 ny B0 XI0_n1 VSS nm1p2_svt_lp L=6e-08 W=2.95e-07
MI1_MXNA1 Y ny VSS VSS nm1p2_svt_lp L=6e-08 W=2.95e-07
MI0_MXPB2 XI0_p1 A1 VDD VDD pm1p2_svt_lp L=6e-08 W=4.2e-07
MI0_MXPB1 ny A0 XI0_p1 VDD pm1p2_svt_lp L=6e-08 W=4.2e-07
MI0_MXPA1 ny B0 VDD VDD pm1p2_svt_lp L=6e-08 W=2.35e-07
MI1_MXPA1 Y ny VDD VDD pm1p2_svt_lp L=6e-08 W=4.15e-07
.ENDS

.SUBCKT OA21X1H9R Y VDD VSS A0 A1 B0
MI0_MXNB2 XI0_n1 A1 VSS VSS nm1p2_svt_lp L=6e-08 W=3.65e-07
MI0_MXNB1 XI0_n1 A0 VSS VSS nm1p2_svt_lp L=6e-08 W=3.65e-07
MI0_MXNA1 ny B0 XI0_n1 VSS nm1p2_svt_lp L=6e-08 W=3.65e-07
MI1_MXNA1 Y ny VSS VSS nm1p2_svt_lp L=6e-08 W=4.2e-07
MI0_MXPB2 XI0_p1 A1 VDD VDD pm1p2_svt_lp L=6e-08 W=5.15e-07
MI0_MXPB1 ny A0 XI0_p1 VDD pm1p2_svt_lp L=6e-08 W=5.15e-07
MI0_MXPA1 ny B0 VDD VDD pm1p2_svt_lp L=6e-08 W=2.9e-07
MI1_MXPA1 Y ny VDD VDD pm1p2_svt_lp L=6e-08 W=5.85e-07
.ENDS

.SUBCKT OA21X1P4H9R Y VDD VSS A0 A1 B0
MI0_MXNA1 ny B0 XI0_n1 VSS nm1p2_svt_lp L=6e-08 W=5.3e-07
MI0_MXNB1 XI0_n1 A0 VSS VSS nm1p2_svt_lp L=6e-08 W=5.3e-07
MI0_MXNB2 XI0_n1 A1 VSS VSS nm1p2_svt_lp L=6e-08 W=5.3e-07
MI1_MXNA1 Y ny VSS VSS nm1p2_svt_lp L=6e-08 W=2.95e-07
MI1_MXNA1_2 Y ny VSS VSS nm1p2_svt_lp L=6e-08 W=2.95e-07
MI0_MXPA1 ny B0 VDD VDD pm1p2_svt_lp L=6e-08 W=4.2e-07
MI0_MXPB2_2 XI0_p1__2 A1 VDD VDD pm1p2_svt_lp L=6e-08 W=3.75e-07
MI0_MXPB1_2 ny A0 XI0_p1__2 VDD pm1p2_svt_lp L=6e-08 W=3.75e-07
MI0_MXPB1 ny A0 XI0_p1 VDD pm1p2_svt_lp L=6e-08 W=3.75e-07
MI0_MXPB2 XI0_p1 A1 VDD VDD pm1p2_svt_lp L=6e-08 W=3.75e-07
MI1_MXPA1 Y ny VDD VDD pm1p2_svt_lp L=6e-08 W=4.15e-07
MI1_MXPA1_2 Y ny VDD VDD pm1p2_svt_lp L=6e-08 W=4.15e-07
.ENDS

.SUBCKT OA21X2H9R Y VDD VSS A0 A1 B0
MI0_MXNB2 XI0_n1 A1 VSS VSS nm1p2_svt_lp L=6e-08 W=3.35e-07
MI0_MXNB1 XI0_n1 A0 VSS VSS nm1p2_svt_lp L=6e-08 W=3.35e-07
MI0_MXNB1_2 XI0_n1 A0 VSS VSS nm1p2_svt_lp L=6e-08 W=3.35e-07
MI0_MXNB2_2 XI0_n1 A1 VSS VSS nm1p2_svt_lp L=6e-08 W=3.35e-07
MI0_MXNA1 ny B0 XI0_n1 VSS nm1p2_svt_lp L=6e-08 W=3.35e-07
MI0_MXNA1_2 ny B0 XI0_n1 VSS nm1p2_svt_lp L=6e-08 W=3.35e-07
MI1_MXNA1 Y ny VSS VSS nm1p2_svt_lp L=6e-08 W=4.2e-07
MI1_MXNA1_2 Y ny VSS VSS nm1p2_svt_lp L=6e-08 W=4.2e-07
MI0_MXPB2_2 XI0_p1__2 A1 VDD VDD pm1p2_svt_lp L=6e-08 W=4.7e-07
MI0_MXPB1_2 ny A0 XI0_p1__2 VDD pm1p2_svt_lp L=6e-08 W=4.7e-07
MI0_MXPB1 ny A0 XI0_p1 VDD pm1p2_svt_lp L=6e-08 W=4.7e-07
MI0_MXPB2 XI0_p1 A1 VDD VDD pm1p2_svt_lp L=6e-08 W=4.7e-07
MI0_MXPA1 ny B0 VDD VDD pm1p2_svt_lp L=6e-08 W=2.65e-07
MI0_MXPA1_2 ny B0 VDD VDD pm1p2_svt_lp L=6e-08 W=2.65e-07
MI1_MXPA1 Y ny VDD VDD pm1p2_svt_lp L=6e-08 W=5.85e-07
MI1_MXPA1_2 Y ny VDD VDD pm1p2_svt_lp L=6e-08 W=5.85e-07
.ENDS

.SUBCKT OA21X3H9R Y VDD VSS A0 A1 B0
MI0_MXNB2 XI0_n1 A1 VSS VSS nm1p2_svt_lp L=6e-08 W=3.35e-07
MI0_MXNB1 XI0_n1 A0 VSS VSS nm1p2_svt_lp L=6e-08 W=3.35e-07
MI0_MXNB1_2 XI0_n1 A0 VSS VSS nm1p2_svt_lp L=6e-08 W=3.35e-07
MI0_MXNB2_2 XI0_n1 A1 VSS VSS nm1p2_svt_lp L=6e-08 W=3.35e-07
MI0_MXNB2_3 XI0_n1 A1 VSS VSS nm1p2_svt_lp L=6e-08 W=3.35e-07
MI0_MXNB1_3 XI0_n1 A0 VSS VSS nm1p2_svt_lp L=6e-08 W=3.35e-07
MI0_MXNA1 ny B0 XI0_n1 VSS nm1p2_svt_lp L=6e-08 W=3.35e-07
MI0_MXNA1_2 ny B0 XI0_n1 VSS nm1p2_svt_lp L=6e-08 W=3.35e-07
MI0_MXNA1_3 ny B0 XI0_n1 VSS nm1p2_svt_lp L=6e-08 W=3.35e-07
MI1_MXNA1 Y ny VSS VSS nm1p2_svt_lp L=6e-08 W=4.2e-07
MI1_MXNA1_2 Y ny VSS VSS nm1p2_svt_lp L=6e-08 W=4.2e-07
MI1_MXNA1_3 Y ny VSS VSS nm1p2_svt_lp L=6e-08 W=4.2e-07
MI0_MXPB2_2 XI0_p1__2 A1 VDD VDD pm1p2_svt_lp L=6e-08 W=4.75e-07
MI0_MXPB1_2 ny A0 XI0_p1__2 VDD pm1p2_svt_lp L=6e-08 W=4.75e-07
MI0_MXPB1_3 ny A0 XI0_p1__3 VDD pm1p2_svt_lp L=6e-08 W=4.75e-07
MI0_MXPB2_3 XI0_p1__3 A1 VDD VDD pm1p2_svt_lp L=6e-08 W=4.75e-07
MI0_MXPB2 XI0_p1 A1 VDD VDD pm1p2_svt_lp L=6e-08 W=4.75e-07
MI0_MXPB1 ny A0 XI0_p1 VDD pm1p2_svt_lp L=6e-08 W=4.75e-07
MI0_MXPA1 ny B0 VDD VDD pm1p2_svt_lp L=6e-08 W=4.05e-07
MI0_MXPA1_2 ny B0 VDD VDD pm1p2_svt_lp L=6e-08 W=4.05e-07
MI1_MXPA1 Y ny VDD VDD pm1p2_svt_lp L=6e-08 W=5.85e-07
MI1_MXPA1_2 Y ny VDD VDD pm1p2_svt_lp L=6e-08 W=5.85e-07
MI1_MXPA1_3 Y ny VDD VDD pm1p2_svt_lp L=6e-08 W=5.85e-07
.ENDS

.SUBCKT OA21X4H9R Y VDD VSS A0 A1 B0
MI0_MXNB2 XI0_n1 A1 VSS VSS nm1p2_svt_lp L=6e-08 W=4.1e-07
MI0_MXNB2_2 XI0_n1 A1 VSS VSS nm1p2_svt_lp L=6e-08 W=4.1e-07
MI0_MXNB2_3 XI0_n1 A1 VSS VSS nm1p2_svt_lp L=6e-08 W=4.1e-07
MI0_MXNB1 XI0_n1 A0 VSS VSS nm1p2_svt_lp L=6e-08 W=4.1e-07
MI0_MXNB1_2 XI0_n1 A0 VSS VSS nm1p2_svt_lp L=6e-08 W=4.1e-07
MI0_MXNB1_3 XI0_n1 A0 VSS VSS nm1p2_svt_lp L=6e-08 W=4.1e-07
MI0_MXNA1 ny B0 XI0_n1 VSS nm1p2_svt_lp L=6e-08 W=4.1e-07
MI0_MXNA1_2 ny B0 XI0_n1 VSS nm1p2_svt_lp L=6e-08 W=4.1e-07
MI0_MXNA1_3 ny B0 XI0_n1 VSS nm1p2_svt_lp L=6e-08 W=4.1e-07
MI1_MXNA1 Y ny VSS VSS nm1p2_svt_lp L=6e-08 W=4.2e-07
MI1_MXNA1_2 Y ny VSS VSS nm1p2_svt_lp L=6e-08 W=4.2e-07
MI1_MXNA1_3 Y ny VSS VSS nm1p2_svt_lp L=6e-08 W=4.2e-07
MI1_MXNA1_4 Y ny VSS VSS nm1p2_svt_lp L=6e-08 W=4.2e-07
MI0_MXPB2 XI0_p1 A1 VDD VDD pm1p2_svt_lp L=6e-08 W=5.85e-07
MI0_MXPB2_2 XI0_p1 A1 VDD VDD pm1p2_svt_lp L=6e-08 W=5.85e-07
MI0_MXPB2_3 XI0_p1 A1 VDD VDD pm1p2_svt_lp L=6e-08 W=5.85e-07
MI0_MXPB1 ny A0 XI0_p1 VDD pm1p2_svt_lp L=6e-08 W=5.85e-07
MI0_MXPB1_2 ny A0 XI0_p1 VDD pm1p2_svt_lp L=6e-08 W=5.85e-07
MI0_MXPB1_3 ny A0 XI0_p1 VDD pm1p2_svt_lp L=6e-08 W=5.85e-07
MI0_MXPA1 ny B0 VDD VDD pm1p2_svt_lp L=6e-08 W=4.95e-07
MI0_MXPA1_2 ny B0 VDD VDD pm1p2_svt_lp L=6e-08 W=4.95e-07
MI1_MXPA1 Y ny VDD VDD pm1p2_svt_lp L=6e-08 W=5.85e-07
MI1_MXPA1_2 Y ny VDD VDD pm1p2_svt_lp L=6e-08 W=5.85e-07
MI1_MXPA1_3 Y ny VDD VDD pm1p2_svt_lp L=6e-08 W=5.85e-07
MI1_MXPA1_4 Y ny VDD VDD pm1p2_svt_lp L=6e-08 W=5.85e-07
.ENDS

.SUBCKT OA21X6H9R Y VDD VSS A0 A1 B0
MI0_MXNB2 XI0_n1 A1 VSS VSS nm1p2_svt_lp L=6e-08 W=4.7e-07
MI0_MXNB2_2 XI0_n1 A1 VSS VSS nm1p2_svt_lp L=6e-08 W=4.7e-07
MI0_MXNB2_3 XI0_n1 A1 VSS VSS nm1p2_svt_lp L=6e-08 W=4.7e-07
MI0_MXNB2_4 XI0_n1 A1 VSS VSS nm1p2_svt_lp L=6e-08 W=4.7e-07
MI0_MXNB1 XI0_n1 A0 VSS VSS nm1p2_svt_lp L=6e-08 W=4.7e-07
MI0_MXNB1_2 XI0_n1 A0 VSS VSS nm1p2_svt_lp L=6e-08 W=4.7e-07
MI0_MXNB1_3 XI0_n1 A0 VSS VSS nm1p2_svt_lp L=6e-08 W=4.7e-07
MI0_MXNB1_4 XI0_n1 A0 VSS VSS nm1p2_svt_lp L=6e-08 W=4.7e-07
MI0_MXNA1 ny B0 XI0_n1 VSS nm1p2_svt_lp L=6e-08 W=4.7e-07
MI0_MXNA1_2 ny B0 XI0_n1 VSS nm1p2_svt_lp L=6e-08 W=4.7e-07
MI0_MXNA1_3 ny B0 XI0_n1 VSS nm1p2_svt_lp L=6e-08 W=4.7e-07
MI0_MXNA1_4 ny B0 XI0_n1 VSS nm1p2_svt_lp L=6e-08 W=4.7e-07
MI1_MXNA1 Y ny VSS VSS nm1p2_svt_lp L=6e-08 W=4.2e-07
MI1_MXNA1_2 Y ny VSS VSS nm1p2_svt_lp L=6e-08 W=4.2e-07
MI1_MXNA1_3 Y ny VSS VSS nm1p2_svt_lp L=6e-08 W=4.2e-07
MI1_MXNA1_4 Y ny VSS VSS nm1p2_svt_lp L=6e-08 W=4.2e-07
MI1_MXNA1_5 Y ny VSS VSS nm1p2_svt_lp L=6e-08 W=4.2e-07
MI1_MXNA1_6 Y ny VSS VSS nm1p2_svt_lp L=6e-08 W=4.2e-07
MI0_MXPB2 XI0_p1 A1 VDD VDD pm1p2_svt_lp L=6e-08 W=5.35e-07
MI0_MXPB2_2 XI0_p1 A1 VDD VDD pm1p2_svt_lp L=6e-08 W=5.35e-07
MI0_MXPB2_3 XI0_p1 A1 VDD VDD pm1p2_svt_lp L=6e-08 W=5.35e-07
MI0_MXPB2_4 XI0_p1 A1 VDD VDD pm1p2_svt_lp L=6e-08 W=5.35e-07
MI0_MXPB2_5 XI0_p1 A1 VDD VDD pm1p2_svt_lp L=6e-08 W=5.35e-07
MI0_MXPB1 ny A0 XI0_p1 VDD pm1p2_svt_lp L=6e-08 W=5.35e-07
MI0_MXPB1_2 ny A0 XI0_p1 VDD pm1p2_svt_lp L=6e-08 W=5.35e-07
MI0_MXPB1_3 ny A0 XI0_p1 VDD pm1p2_svt_lp L=6e-08 W=5.35e-07
MI0_MXPB1_4 ny A0 XI0_p1 VDD pm1p2_svt_lp L=6e-08 W=5.35e-07
MI0_MXPB1_5 ny A0 XI0_p1 VDD pm1p2_svt_lp L=6e-08 W=5.35e-07
MI0_MXPA1 ny B0 VDD VDD pm1p2_svt_lp L=6e-08 W=5e-07
MI0_MXPA1_2 ny B0 VDD VDD pm1p2_svt_lp L=6e-08 W=5e-07
MI0_MXPA1_3 ny B0 VDD VDD pm1p2_svt_lp L=6e-08 W=5e-07
MI1_MXPA1 Y ny VDD VDD pm1p2_svt_lp L=6e-08 W=5.85e-07
MI1_MXPA1_2 Y ny VDD VDD pm1p2_svt_lp L=6e-08 W=5.85e-07
MI1_MXPA1_3 Y ny VDD VDD pm1p2_svt_lp L=6e-08 W=5.85e-07
MI1_MXPA1_4 Y ny VDD VDD pm1p2_svt_lp L=6e-08 W=5.85e-07
MI1_MXPA1_5 Y ny VDD VDD pm1p2_svt_lp L=6e-08 W=5.85e-07
MI1_MXPA1_6 Y ny VDD VDD pm1p2_svt_lp L=6e-08 W=5.85e-07
.ENDS

.SUBCKT OA21X8H9R Y VDD VSS A0 A1 B0
MI0_MXNB2 XI0_n1 A1 VSS VSS nm1p2_svt_lp L=6e-08 W=4.15e-07
MI0_MXNB1 XI0_n1 A0 VSS VSS nm1p2_svt_lp L=6e-08 W=4.15e-07
MI0_MXNB1_2 XI0_n1 A0 VSS VSS nm1p2_svt_lp L=6e-08 W=4.15e-07
MI0_MXNB2_2 XI0_n1 A1 VSS VSS nm1p2_svt_lp L=6e-08 W=4.15e-07
MI0_MXNB2_3 XI0_n1 A1 VSS VSS nm1p2_svt_lp L=6e-08 W=4.15e-07
MI0_MXNB1_3 XI0_n1 A0 VSS VSS nm1p2_svt_lp L=6e-08 W=4.15e-07
MI0_MXNB1_4 XI0_n1 A0 VSS VSS nm1p2_svt_lp L=6e-08 W=4.15e-07
MI0_MXNB2_4 XI0_n1 A1 VSS VSS nm1p2_svt_lp L=6e-08 W=4.15e-07
MI0_MXNB2_5 XI0_n1 A1 VSS VSS nm1p2_svt_lp L=6e-08 W=4.15e-07
MI0_MXNB1_5 XI0_n1 A0 VSS VSS nm1p2_svt_lp L=6e-08 W=4.15e-07
MI0_MXNB1_6 XI0_n1 A0 VSS VSS nm1p2_svt_lp L=6e-08 W=4.15e-07
MI0_MXNB2_6 XI0_n1 A1 VSS VSS nm1p2_svt_lp L=6e-08 W=4.15e-07
MI0_MXNA1 ny B0 XI0_n1 VSS nm1p2_svt_lp L=6e-08 W=4.15e-07
MI0_MXNA1_2 ny B0 XI0_n1 VSS nm1p2_svt_lp L=6e-08 W=4.15e-07
MI0_MXNA1_3 ny B0 XI0_n1 VSS nm1p2_svt_lp L=6e-08 W=4.15e-07
MI0_MXNA1_4 ny B0 XI0_n1 VSS nm1p2_svt_lp L=6e-08 W=4.15e-07
MI0_MXNA1_5 ny B0 XI0_n1 VSS nm1p2_svt_lp L=6e-08 W=4.15e-07
MI0_MXNA1_6 ny B0 XI0_n1 VSS nm1p2_svt_lp L=6e-08 W=4.15e-07
MI1_MXNA1 Y ny VSS VSS nm1p2_svt_lp L=6e-08 W=4.8e-07
MI1_MXNA1_2 Y ny VSS VSS nm1p2_svt_lp L=6e-08 W=4.8e-07
MI1_MXNA1_3 Y ny VSS VSS nm1p2_svt_lp L=6e-08 W=4.8e-07
MI1_MXNA1_4 Y ny VSS VSS nm1p2_svt_lp L=6e-08 W=4.8e-07
MI1_MXNA1_5 Y ny VSS VSS nm1p2_svt_lp L=6e-08 W=4.8e-07
MI1_MXNA1_6 Y ny VSS VSS nm1p2_svt_lp L=6e-08 W=4.8e-07
MI1_MXNA1_7 Y ny VSS VSS nm1p2_svt_lp L=6e-08 W=4.8e-07
MI0_MXPB2_2 XI0_p1__2 A1 VDD VDD pm1p2_svt_lp L=6e-08 W=5.85e-07
MI0_MXPB1_2 ny A0 XI0_p1__2 VDD pm1p2_svt_lp L=6e-08 W=5.85e-07
MI0_MXPB1_3 ny A0 XI0_p1__3 VDD pm1p2_svt_lp L=6e-08 W=5.85e-07
MI0_MXPB2_3 XI0_p1__3 A1 VDD VDD pm1p2_svt_lp L=6e-08 W=5.85e-07
MI0_MXPB2_4 XI0_p1__4 A1 VDD VDD pm1p2_svt_lp L=6e-08 W=5.85e-07
MI0_MXPB1_4 ny A0 XI0_p1__4 VDD pm1p2_svt_lp L=6e-08 W=5.85e-07
MI0_MXPB1_5 ny A0 XI0_p1__5 VDD pm1p2_svt_lp L=6e-08 W=5.85e-07
MI0_MXPB2_5 XI0_p1__5 A1 VDD VDD pm1p2_svt_lp L=6e-08 W=5.85e-07
MI0_MXPB2_6 XI0_p1__6 A1 VDD VDD pm1p2_svt_lp L=6e-08 W=5.85e-07
MI0_MXPB1_6 ny A0 XI0_p1__6 VDD pm1p2_svt_lp L=6e-08 W=5.85e-07
MI0_MXPB1 ny A0 XI0_p1 VDD pm1p2_svt_lp L=6e-08 W=5.85e-07
MI0_MXPB2 XI0_p1 A1 VDD VDD pm1p2_svt_lp L=6e-08 W=5.85e-07
MI0_MXPA1 ny B0 VDD VDD pm1p2_svt_lp L=6e-08 W=4.95e-07
MI0_MXPA1_2 ny B0 VDD VDD pm1p2_svt_lp L=6e-08 W=4.95e-07
MI0_MXPA1_3 ny B0 VDD VDD pm1p2_svt_lp L=6e-08 W=4.95e-07
MI0_MXPA1_4 ny B0 VDD VDD pm1p2_svt_lp L=6e-08 W=4.95e-07
MI1_MXPA1 Y ny VDD VDD pm1p2_svt_lp L=6e-08 W=5.85e-07
MI1_MXPA1_2 Y ny VDD VDD pm1p2_svt_lp L=6e-08 W=5.85e-07
MI1_MXPA1_3 Y ny VDD VDD pm1p2_svt_lp L=6e-08 W=5.85e-07
MI1_MXPA1_4 Y ny VDD VDD pm1p2_svt_lp L=6e-08 W=5.85e-07
MI1_MXPA1_5 Y ny VDD VDD pm1p2_svt_lp L=6e-08 W=5.85e-07
MI1_MXPA1_6 Y ny VDD VDD pm1p2_svt_lp L=6e-08 W=5.85e-07
MI1_MXPA1_7 Y ny VDD VDD pm1p2_svt_lp L=6e-08 W=5.85e-07
MI1_MXPA1_8 Y ny VDD VDD pm1p2_svt_lp L=6e-08 W=5.85e-07
.ENDS

.SUBCKT OAI21X0P5H9R Y VDD VSS A0 A1 B0
MI0_MXNB2 XI0_n1 A1 VSS VSS nm1p2_svt_lp L=6e-08 W=2.1e-07
MI0_MXNB1 XI0_n1 A0 VSS VSS nm1p2_svt_lp L=6e-08 W=2.1e-07
MI0_MXNA1 Y B0 XI0_n1 VSS nm1p2_svt_lp L=6e-08 W=2.1e-07
MI0_MXPB2 XI0_p1 A1 VDD VDD pm1p2_svt_lp L=6e-08 W=2.95e-07
MI0_MXPB1 Y A0 XI0_p1 VDD pm1p2_svt_lp L=6e-08 W=2.95e-07
MI0_MXPA1 Y B0 VDD VDD pm1p2_svt_lp L=6e-08 W=1.65e-07
.ENDS

.SUBCKT OAI21X0P7H9R Y VDD VSS A0 A1 B0
MI0_MXNB2 XI0_n1 A1 VSS VSS nm1p2_svt_lp L=6e-08 W=2.9e-07
MI0_MXNB1 XI0_n1 A0 VSS VSS nm1p2_svt_lp L=6e-08 W=2.9e-07
MI0_MXNA1 Y B0 XI0_n1 VSS nm1p2_svt_lp L=6e-08 W=2.9e-07
MI0_MXPB2 XI0_p1 A1 VDD VDD pm1p2_svt_lp L=6e-08 W=4.15e-07
MI0_MXPB1 Y A0 XI0_p1 VDD pm1p2_svt_lp L=6e-08 W=4.15e-07
MI0_MXPA1 Y B0 VDD VDD pm1p2_svt_lp L=6e-08 W=2.35e-07
.ENDS

.SUBCKT OAI21X1H9R Y VDD VSS A0 A1 B0
MI0_MXNB2 XI0_n1 A1 VSS VSS nm1p2_svt_lp L=6e-08 W=4.1e-07
MI0_MXNB1 XI0_n1 A0 VSS VSS nm1p2_svt_lp L=6e-08 W=4.1e-07
MI0_MXNA1 Y B0 XI0_n1 VSS nm1p2_svt_lp L=6e-08 W=4.1e-07
MI0_MXPB2 XI0_p1 A1 VDD VDD pm1p2_svt_lp L=6e-08 W=5.85e-07
MI0_MXPB1 Y A0 XI0_p1 VDD pm1p2_svt_lp L=6e-08 W=5.85e-07
MI0_MXPA1 Y B0 VDD VDD pm1p2_svt_lp L=6e-08 W=3.3e-07
.ENDS

.SUBCKT OAI21X1P4H9R Y VDD VSS A0 A1 B0
MI0_MXNB2 XI0_n1 A1 VSS VSS nm1p2_svt_lp L=6e-08 W=2.9e-07
MI0_MXNB1 XI0_n1 A0 VSS VSS nm1p2_svt_lp L=6e-08 W=2.9e-07
MI0_MXNB1_2 XI0_n1 A0 VSS VSS nm1p2_svt_lp L=6e-08 W=2.9e-07
MI0_MXNB2_2 XI0_n1 A1 VSS VSS nm1p2_svt_lp L=6e-08 W=2.9e-07
MI0_MXNA1 Y B0 XI0_n1 VSS nm1p2_svt_lp L=6e-08 W=2.9e-07
MI0_MXNA1_2 Y B0 XI0_n1 VSS nm1p2_svt_lp L=6e-08 W=2.9e-07
MI0_MXPB2_2 XI0_p1__2 A1 VDD VDD pm1p2_svt_lp L=6e-08 W=4.15e-07
MI0_MXPB1_2 Y A0 XI0_p1__2 VDD pm1p2_svt_lp L=6e-08 W=4.15e-07
MI0_MXPB1 Y A0 XI0_p1 VDD pm1p2_svt_lp L=6e-08 W=4.15e-07
MI0_MXPB2 XI0_p1 A1 VDD VDD pm1p2_svt_lp L=6e-08 W=4.15e-07
MI0_MXPA1 Y B0 VDD VDD pm1p2_svt_lp L=6e-08 W=2.35e-07
MI0_MXPA1_2 Y B0 VDD VDD pm1p2_svt_lp L=6e-08 W=2.35e-07
.ENDS

.SUBCKT OAI21X2H9R Y VDD VSS A0 A1 B0
MI0_MXNB2 XI0_n1 A1 VSS VSS nm1p2_svt_lp L=6e-08 W=4.1e-07
MI0_MXNB1 XI0_n1 A0 VSS VSS nm1p2_svt_lp L=6e-08 W=4.1e-07
MI0_MXNB1_2 XI0_n1 A0 VSS VSS nm1p2_svt_lp L=6e-08 W=4.1e-07
MI0_MXNB2_2 XI0_n1 A1 VSS VSS nm1p2_svt_lp L=6e-08 W=4.1e-07
MI0_MXNA1 Y B0 XI0_n1 VSS nm1p2_svt_lp L=6e-08 W=4.1e-07
MI0_MXNA1_2 Y B0 XI0_n1 VSS nm1p2_svt_lp L=6e-08 W=4.1e-07
MI0_MXPB2_2 XI0_p1__2 A1 VDD VDD pm1p2_svt_lp L=6e-08 W=5.85e-07
MI0_MXPB1_2 Y A0 XI0_p1__2 VDD pm1p2_svt_lp L=6e-08 W=5.85e-07
MI0_MXPB1 Y A0 XI0_p1 VDD pm1p2_svt_lp L=6e-08 W=5.85e-07
MI0_MXPB2 XI0_p1 A1 VDD VDD pm1p2_svt_lp L=6e-08 W=5.85e-07
MI0_MXPA1 Y B0 VDD VDD pm1p2_svt_lp L=6e-08 W=3.3e-07
MI0_MXPA1_2 Y B0 VDD VDD pm1p2_svt_lp L=6e-08 W=3.3e-07
.ENDS

.SUBCKT OAI21X3H9R Y VDD VSS A0 A1 B0
MI0_MXNB2 XI0_n1 A1 VSS VSS nm1p2_svt_lp L=6e-08 W=4.1e-07
MI0_MXNB2_2 XI0_n1 A1 VSS VSS nm1p2_svt_lp L=6e-08 W=4.1e-07
MI0_MXNB2_3 XI0_n1 A1 VSS VSS nm1p2_svt_lp L=6e-08 W=4.1e-07
MI0_MXNB1 XI0_n1 A0 VSS VSS nm1p2_svt_lp L=6e-08 W=4.1e-07
MI0_MXNB1_2 XI0_n1 A0 VSS VSS nm1p2_svt_lp L=6e-08 W=4.1e-07
MI0_MXNB1_3 XI0_n1 A0 VSS VSS nm1p2_svt_lp L=6e-08 W=4.1e-07
MI0_MXNA1 Y B0 XI0_n1 VSS nm1p2_svt_lp L=6e-08 W=4.1e-07
MI0_MXNA1_2 Y B0 XI0_n1 VSS nm1p2_svt_lp L=6e-08 W=4.1e-07
MI0_MXNA1_3 Y B0 XI0_n1 VSS nm1p2_svt_lp L=6e-08 W=4.1e-07
MI0_MXPB2 XI0_p1 A1 VDD VDD pm1p2_svt_lp L=6e-08 W=5.85e-07
MI0_MXPB2_2 XI0_p1 A1 VDD VDD pm1p2_svt_lp L=6e-08 W=5.85e-07
MI0_MXPB2_3 XI0_p1 A1 VDD VDD pm1p2_svt_lp L=6e-08 W=5.85e-07
MI0_MXPB1 Y A0 XI0_p1 VDD pm1p2_svt_lp L=6e-08 W=5.85e-07
MI0_MXPB1_2 Y A0 XI0_p1 VDD pm1p2_svt_lp L=6e-08 W=5.85e-07
MI0_MXPB1_3 Y A0 XI0_p1 VDD pm1p2_svt_lp L=6e-08 W=5.85e-07
MI0_MXPA1 Y B0 VDD VDD pm1p2_svt_lp L=6e-08 W=4.95e-07
MI0_MXPA1_2 Y B0 VDD VDD pm1p2_svt_lp L=6e-08 W=4.95e-07
.ENDS

.SUBCKT OAI21X4H9R Y VDD VSS A0 A1 B0
MI0_MXNB2 XI0_n1 A1 VSS VSS nm1p2_svt_lp L=6e-08 W=4.1e-07
MI0_MXNB2_2 XI0_n1 A1 VSS VSS nm1p2_svt_lp L=6e-08 W=4.1e-07
MI0_MXNB2_3 XI0_n1 A1 VSS VSS nm1p2_svt_lp L=6e-08 W=4.1e-07
MI0_MXNB2_4 XI0_n1 A1 VSS VSS nm1p2_svt_lp L=6e-08 W=4.1e-07
MI0_MXNB1 XI0_n1 A0 VSS VSS nm1p2_svt_lp L=6e-08 W=4.1e-07
MI0_MXNB1_2 XI0_n1 A0 VSS VSS nm1p2_svt_lp L=6e-08 W=4.1e-07
MI0_MXNB1_3 XI0_n1 A0 VSS VSS nm1p2_svt_lp L=6e-08 W=4.1e-07
MI0_MXNB1_4 XI0_n1 A0 VSS VSS nm1p2_svt_lp L=6e-08 W=4.1e-07
MI0_MXNA1 Y B0 XI0_n1 VSS nm1p2_svt_lp L=6e-08 W=4.1e-07
MI0_MXNA1_2 Y B0 XI0_n1 VSS nm1p2_svt_lp L=6e-08 W=4.1e-07
MI0_MXNA1_3 Y B0 XI0_n1 VSS nm1p2_svt_lp L=6e-08 W=4.1e-07
MI0_MXNA1_4 Y B0 XI0_n1 VSS nm1p2_svt_lp L=6e-08 W=4.1e-07
MI0_MXPB2 XI0_p1 A1 VDD VDD pm1p2_svt_lp L=6e-08 W=5.85e-07
MI0_MXPB2_2 XI0_p1 A1 VDD VDD pm1p2_svt_lp L=6e-08 W=5.85e-07
MI0_MXPB2_3 XI0_p1 A1 VDD VDD pm1p2_svt_lp L=6e-08 W=5.85e-07
MI0_MXPB2_4 XI0_p1 A1 VDD VDD pm1p2_svt_lp L=6e-08 W=5.85e-07
MI0_MXPB1 Y A0 XI0_p1 VDD pm1p2_svt_lp L=6e-08 W=5.85e-07
MI0_MXPB1_2 Y A0 XI0_p1 VDD pm1p2_svt_lp L=6e-08 W=5.85e-07
MI0_MXPB1_3 Y A0 XI0_p1 VDD pm1p2_svt_lp L=6e-08 W=5.85e-07
MI0_MXPB1_4 Y A0 XI0_p1 VDD pm1p2_svt_lp L=6e-08 W=5.85e-07
MI0_MXPA1 Y B0 VDD VDD pm1p2_svt_lp L=6e-08 W=4.4e-07
MI0_MXPA1_2 Y B0 VDD VDD pm1p2_svt_lp L=6e-08 W=4.4e-07
MI0_MXPA1_3 Y B0 VDD VDD pm1p2_svt_lp L=6e-08 W=4.4e-07
.ENDS

.SUBCKT OAI21X6H9R Y VDD VSS A0 A1 B0
MI0_MXNB2 XI0_n1 A1 VSS VSS nm1p2_svt_lp L=6e-08 W=4.95e-07
MI0_MXNB1 XI0_n1 A0 VSS VSS nm1p2_svt_lp L=6e-08 W=4.95e-07
MI0_MXNB1_2 XI0_n1 A0 VSS VSS nm1p2_svt_lp L=6e-08 W=4.95e-07
MI0_MXNB2_2 XI0_n1 A1 VSS VSS nm1p2_svt_lp L=6e-08 W=4.95e-07
MI0_MXNB2_3 XI0_n1 A1 VSS VSS nm1p2_svt_lp L=6e-08 W=4.95e-07
MI0_MXNB1_3 XI0_n1 A0 VSS VSS nm1p2_svt_lp L=6e-08 W=4.95e-07
MI0_MXNB1_4 XI0_n1 A0 VSS VSS nm1p2_svt_lp L=6e-08 W=4.95e-07
MI0_MXNB2_4 XI0_n1 A1 VSS VSS nm1p2_svt_lp L=6e-08 W=4.95e-07
MI0_MXNB2_5 XI0_n1 A1 VSS VSS nm1p2_svt_lp L=6e-08 W=4.95e-07
MI0_MXNB1_5 XI0_n1 A0 VSS VSS nm1p2_svt_lp L=6e-08 W=4.95e-07
MI0_MXNA1 Y B0 XI0_n1 VSS nm1p2_svt_lp L=6e-08 W=4.95e-07
MI0_MXNA1_2 Y B0 XI0_n1 VSS nm1p2_svt_lp L=6e-08 W=4.95e-07
MI0_MXNA1_3 Y B0 XI0_n1 VSS nm1p2_svt_lp L=6e-08 W=4.95e-07
MI0_MXNA1_4 Y B0 XI0_n1 VSS nm1p2_svt_lp L=6e-08 W=4.95e-07
MI0_MXNA1_5 Y B0 XI0_n1 VSS nm1p2_svt_lp L=6e-08 W=4.95e-07
MI0_MXPB2_2 XI0_p1__2 A1 VDD VDD pm1p2_svt_lp L=6e-08 W=5.85e-07
MI0_MXPB1_2 Y A0 XI0_p1__2 VDD pm1p2_svt_lp L=6e-08 W=5.85e-07
MI0_MXPB1_3 Y A0 XI0_p1__3 VDD pm1p2_svt_lp L=6e-08 W=5.85e-07
MI0_MXPB2_3 XI0_p1__3 A1 VDD VDD pm1p2_svt_lp L=6e-08 W=5.85e-07
MI0_MXPB2_4 XI0_p1__4 A1 VDD VDD pm1p2_svt_lp L=6e-08 W=5.85e-07
MI0_MXPB1_4 Y A0 XI0_p1__4 VDD pm1p2_svt_lp L=6e-08 W=5.85e-07
MI0_MXPB1_5 Y A0 XI0_p1__5 VDD pm1p2_svt_lp L=6e-08 W=5.85e-07
MI0_MXPB2_5 XI0_p1__5 A1 VDD VDD pm1p2_svt_lp L=6e-08 W=5.85e-07
MI0_MXPB2_6 XI0_p1__6 A1 VDD VDD pm1p2_svt_lp L=6e-08 W=5.85e-07
MI0_MXPB1_6 Y A0 XI0_p1__6 VDD pm1p2_svt_lp L=6e-08 W=5.85e-07
MI0_MXPB1 Y A0 XI0_p1 VDD pm1p2_svt_lp L=6e-08 W=5.85e-07
MI0_MXPB2 XI0_p1 A1 VDD VDD pm1p2_svt_lp L=6e-08 W=5.85e-07
MI0_MXPA1 Y B0 VDD VDD pm1p2_svt_lp L=6e-08 W=4.95e-07
MI0_MXPA1_2 Y B0 VDD VDD pm1p2_svt_lp L=6e-08 W=4.95e-07
MI0_MXPA1_3 Y B0 VDD VDD pm1p2_svt_lp L=6e-08 W=4.95e-07
MI0_MXPA1_4 Y B0 VDD VDD pm1p2_svt_lp L=6e-08 W=4.95e-07
.ENDS

.SUBCKT OAI21X8H9R Y VDD VSS A0 A1 B0
MI0_MXNB2 XI0_n1 A1 VSS VSS nm1p2_svt_lp L=6e-08 W=4.7e-07
MI0_MXNB2_2 XI0_n1 A1 VSS VSS nm1p2_svt_lp L=6e-08 W=4.7e-07
MI0_MXNB2_3 XI0_n1 A1 VSS VSS nm1p2_svt_lp L=6e-08 W=4.7e-07
MI0_MXNB2_4 XI0_n1 A1 VSS VSS nm1p2_svt_lp L=6e-08 W=4.7e-07
MI0_MXNB2_5 XI0_n1 A1 VSS VSS nm1p2_svt_lp L=6e-08 W=4.7e-07
MI0_MXNB2_6 XI0_n1 A1 VSS VSS nm1p2_svt_lp L=6e-08 W=4.7e-07
MI0_MXNB2_7 XI0_n1 A1 VSS VSS nm1p2_svt_lp L=6e-08 W=4.7e-07
MI0_MXNB1 XI0_n1 A0 VSS VSS nm1p2_svt_lp L=6e-08 W=4.7e-07
MI0_MXNB1_2 XI0_n1 A0 VSS VSS nm1p2_svt_lp L=6e-08 W=4.7e-07
MI0_MXNB1_3 XI0_n1 A0 VSS VSS nm1p2_svt_lp L=6e-08 W=4.7e-07
MI0_MXNB1_4 XI0_n1 A0 VSS VSS nm1p2_svt_lp L=6e-08 W=4.7e-07
MI0_MXNB1_5 XI0_n1 A0 VSS VSS nm1p2_svt_lp L=6e-08 W=4.7e-07
MI0_MXNB1_6 XI0_n1 A0 VSS VSS nm1p2_svt_lp L=6e-08 W=4.7e-07
MI0_MXNB1_7 XI0_n1 A0 VSS VSS nm1p2_svt_lp L=6e-08 W=4.7e-07
MI0_MXNA1 Y B0 XI0_n1 VSS nm1p2_svt_lp L=6e-08 W=4.7e-07
MI0_MXNA1_2 Y B0 XI0_n1 VSS nm1p2_svt_lp L=6e-08 W=4.7e-07
MI0_MXNA1_3 Y B0 XI0_n1 VSS nm1p2_svt_lp L=6e-08 W=4.7e-07
MI0_MXNA1_4 Y B0 XI0_n1 VSS nm1p2_svt_lp L=6e-08 W=4.7e-07
MI0_MXNA1_5 Y B0 XI0_n1 VSS nm1p2_svt_lp L=6e-08 W=4.7e-07
MI0_MXNA1_6 Y B0 XI0_n1 VSS nm1p2_svt_lp L=6e-08 W=4.7e-07
MI0_MXNA1_7 Y B0 XI0_n1 VSS nm1p2_svt_lp L=6e-08 W=4.7e-07
MI0_MXPB2 XI0_p1 A1 VDD VDD pm1p2_svt_lp L=6e-08 W=5.85e-07
MI0_MXPB2_2 XI0_p1 A1 VDD VDD pm1p2_svt_lp L=6e-08 W=5.85e-07
MI0_MXPB2_3 XI0_p1 A1 VDD VDD pm1p2_svt_lp L=6e-08 W=5.85e-07
MI0_MXPB2_4 XI0_p1 A1 VDD VDD pm1p2_svt_lp L=6e-08 W=5.85e-07
MI0_MXPB2_5 XI0_p1 A1 VDD VDD pm1p2_svt_lp L=6e-08 W=5.85e-07
MI0_MXPB2_6 XI0_p1 A1 VDD VDD pm1p2_svt_lp L=6e-08 W=5.85e-07
MI0_MXPB2_7 XI0_p1 A1 VDD VDD pm1p2_svt_lp L=6e-08 W=5.85e-07
MI0_MXPB2_8 XI0_p1 A1 VDD VDD pm1p2_svt_lp L=6e-08 W=5.85e-07
MI0_MXPB1 Y A0 XI0_p1 VDD pm1p2_svt_lp L=6e-08 W=5.85e-07
MI0_MXPB1_2 Y A0 XI0_p1 VDD pm1p2_svt_lp L=6e-08 W=5.85e-07
MI0_MXPB1_3 Y A0 XI0_p1 VDD pm1p2_svt_lp L=6e-08 W=5.85e-07
MI0_MXPB1_4 Y A0 XI0_p1 VDD pm1p2_svt_lp L=6e-08 W=5.85e-07
MI0_MXPB1_5 Y A0 XI0_p1 VDD pm1p2_svt_lp L=6e-08 W=5.85e-07
MI0_MXPB1_6 Y A0 XI0_p1 VDD pm1p2_svt_lp L=6e-08 W=5.85e-07
MI0_MXPB1_7 Y A0 XI0_p1 VDD pm1p2_svt_lp L=6e-08 W=5.85e-07
MI0_MXPB1_8 Y A0 XI0_p1 VDD pm1p2_svt_lp L=6e-08 W=5.85e-07
MI0_MXPA1 Y B0 VDD VDD pm1p2_svt_lp L=6e-08 W=5.3e-07
MI0_MXPA1_2 Y B0 VDD VDD pm1p2_svt_lp L=6e-08 W=5.3e-07
MI0_MXPA1_3 Y B0 VDD VDD pm1p2_svt_lp L=6e-08 W=5.3e-07
MI0_MXPA1_4 Y B0 VDD VDD pm1p2_svt_lp L=6e-08 W=5.3e-07
MI0_MXPA1_5 Y B0 VDD VDD pm1p2_svt_lp L=6e-08 W=5.3e-07
.ENDS

.SUBCKT OAI2XB1X0P5H9R Y VDD VSS A0 A1N B0
MI0_MXNA1 a1 A1N VSS VSS nm1p2_svt_lp L=6e-08 W=1.5e-07
MI1_MXNB2 XI1_n1 a1 VSS VSS nm1p2_svt_lp L=6e-08 W=2.1e-07
MI1_MXNB1 XI1_n1 A0 VSS VSS nm1p2_svt_lp L=6e-08 W=2.1e-07
MI1_MXNA1 Y B0 XI1_n1 VSS nm1p2_svt_lp L=6e-08 W=2.1e-07
MI0_MXPA1 a1 A1N VDD VDD pm1p2_svt_lp L=6e-08 W=2.1e-07
MI1_MXPB2 XI1_p1 a1 VDD VDD pm1p2_svt_lp L=6e-08 W=2.95e-07
MI1_MXPB1 Y A0 XI1_p1 VDD pm1p2_svt_lp L=6e-08 W=2.95e-07
MI1_MXPA1 Y B0 VDD VDD pm1p2_svt_lp L=6e-08 W=1.65e-07
.ENDS

.SUBCKT OAI2XB1X0P7H9R Y VDD VSS A0 A1N B0
MI0_MXNA1 a1 A1N VSS VSS nm1p2_svt_lp L=6e-08 W=1.5e-07
MI1_MXNB2 XI1_n1 a1 VSS VSS nm1p2_svt_lp L=6e-08 W=2.9e-07
MI1_MXNB1 XI1_n1 A0 VSS VSS nm1p2_svt_lp L=6e-08 W=2.9e-07
MI1_MXNA1 Y B0 XI1_n1 VSS nm1p2_svt_lp L=6e-08 W=2.9e-07
MI0_MXPA1 a1 A1N VDD VDD pm1p2_svt_lp L=6e-08 W=2.1e-07
MI1_MXPB2 XI1_p1 a1 VDD VDD pm1p2_svt_lp L=6e-08 W=4.15e-07
MI1_MXPB1 Y A0 XI1_p1 VDD pm1p2_svt_lp L=6e-08 W=4.15e-07
MI1_MXPA1 Y B0 VDD VDD pm1p2_svt_lp L=6e-08 W=2.35e-07
.ENDS

.SUBCKT OAI2XB1X1H9R Y VDD VSS A0 A1N B0
MI0_MXNA1 a1 A1N VSS VSS nm1p2_svt_lp L=6e-08 W=1.5e-07
MI1_MXNB2 XI1_n1 a1 VSS VSS nm1p2_svt_lp L=6e-08 W=4.1e-07
MI1_MXNB1 XI1_n1 A0 VSS VSS nm1p2_svt_lp L=6e-08 W=4.1e-07
MI1_MXNA1 Y B0 XI1_n1 VSS nm1p2_svt_lp L=6e-08 W=4.1e-07
MI0_MXPA1 a1 A1N VDD VDD pm1p2_svt_lp L=6e-08 W=2.1e-07
MI1_MXPB2 XI1_p1 a1 VDD VDD pm1p2_svt_lp L=6e-08 W=5.85e-07
MI1_MXPB1 Y A0 XI1_p1 VDD pm1p2_svt_lp L=6e-08 W=5.85e-07
MI1_MXPA1 Y B0 VDD VDD pm1p2_svt_lp L=6e-08 W=3.3e-07
.ENDS

.SUBCKT OAI2XB1X1P4H9R Y VDD VSS A0 A1N B0
MI0_MXNA1 a1 A1N VSS VSS nm1p2_svt_lp L=6e-08 W=2e-07
MI1_MXNB2 XI1_n1 a1 VSS VSS nm1p2_svt_lp L=6e-08 W=5.8e-07
MI1_MXNB1 XI1_n1 A0 VSS VSS nm1p2_svt_lp L=6e-08 W=5.8e-07
MI1_MXNA1 Y B0 XI1_n1 VSS nm1p2_svt_lp L=6e-08 W=2.9e-07
MI1_MXNA1_2 Y B0 XI1_n1 VSS nm1p2_svt_lp L=6e-08 W=2.9e-07
MI0_MXPA1 a1 A1N VDD VDD pm1p2_svt_lp L=6e-08 W=2.8e-07
MI1_MXPB2_2 XI1_p1__2 a1 VDD VDD pm1p2_svt_lp L=6e-08 W=4.15e-07
MI1_MXPB1_2 Y A0 XI1_p1__2 VDD pm1p2_svt_lp L=6e-08 W=4.15e-07
MI1_MXPB1 Y A0 XI1_p1 VDD pm1p2_svt_lp L=6e-08 W=4.15e-07
MI1_MXPB2 XI1_p1 a1 VDD VDD pm1p2_svt_lp L=6e-08 W=4.15e-07
MI1_MXPA1 Y B0 VDD VDD pm1p2_svt_lp L=6e-08 W=2.35e-07
MI1_MXPA1_2 Y B0 VDD VDD pm1p2_svt_lp L=6e-08 W=2.35e-07
.ENDS

.SUBCKT OAI2XB1X2H9R Y VDD VSS A0 A1N B0
MI0_MXNA1 a1 A1N VSS VSS nm1p2_svt_lp L=6e-08 W=2.6e-07
MI1_MXNB2 XI1_n1 a1 VSS VSS nm1p2_svt_lp L=6e-08 W=4.1e-07
MI1_MXNB1 XI1_n1 A0 VSS VSS nm1p2_svt_lp L=6e-08 W=4.1e-07
MI1_MXNB1_2 XI1_n1 A0 VSS VSS nm1p2_svt_lp L=6e-08 W=4.1e-07
MI1_MXNB2_2 XI1_n1 a1 VSS VSS nm1p2_svt_lp L=6e-08 W=4.1e-07
MI1_MXNA1 Y B0 XI1_n1 VSS nm1p2_svt_lp L=6e-08 W=4.1e-07
MI1_MXNA1_2 Y B0 XI1_n1 VSS nm1p2_svt_lp L=6e-08 W=4.1e-07
MI0_MXPA1 a1 A1N VDD VDD pm1p2_svt_lp L=6e-08 W=3.65e-07
MI1_MXPB2_2 XI1_p1__2 a1 VDD VDD pm1p2_svt_lp L=6e-08 W=5.85e-07
MI1_MXPB1_2 Y A0 XI1_p1__2 VDD pm1p2_svt_lp L=6e-08 W=5.85e-07
MI1_MXPB1 Y A0 XI1_p1 VDD pm1p2_svt_lp L=6e-08 W=5.85e-07
MI1_MXPB2 XI1_p1 a1 VDD VDD pm1p2_svt_lp L=6e-08 W=5.85e-07
MI1_MXPA1 Y B0 VDD VDD pm1p2_svt_lp L=6e-08 W=3.3e-07
MI1_MXPA1_2 Y B0 VDD VDD pm1p2_svt_lp L=6e-08 W=3.3e-07
.ENDS

.SUBCKT OAI2XB1X3H9R Y VDD VSS A0 A1N B0
MI0_MXNA1 a1 A1N VSS VSS nm1p2_svt_lp L=6e-08 W=3.75e-07
MI1_MXNB2 XI1_n1 a1 VSS VSS nm1p2_svt_lp L=6e-08 W=4.1e-07
MI1_MXNB2_2 XI1_n1 a1 VSS VSS nm1p2_svt_lp L=6e-08 W=4.1e-07
MI1_MXNB2_3 XI1_n1 a1 VSS VSS nm1p2_svt_lp L=6e-08 W=4.1e-07
MI1_MXNB1 XI1_n1 A0 VSS VSS nm1p2_svt_lp L=6e-08 W=4.1e-07
MI1_MXNB1_2 XI1_n1 A0 VSS VSS nm1p2_svt_lp L=6e-08 W=4.1e-07
MI1_MXNB1_3 XI1_n1 A0 VSS VSS nm1p2_svt_lp L=6e-08 W=4.1e-07
MI1_MXNA1 Y B0 XI1_n1 VSS nm1p2_svt_lp L=6e-08 W=4.1e-07
MI1_MXNA1_2 Y B0 XI1_n1 VSS nm1p2_svt_lp L=6e-08 W=4.1e-07
MI1_MXNA1_3 Y B0 XI1_n1 VSS nm1p2_svt_lp L=6e-08 W=4.1e-07
MI0_MXPA1 a1 A1N VDD VDD pm1p2_svt_lp L=6e-08 W=5.25e-07
MI1_MXPB2 XI1_p1 a1 VDD VDD pm1p2_svt_lp L=6e-08 W=5.85e-07
MI1_MXPB2_2 XI1_p1 a1 VDD VDD pm1p2_svt_lp L=6e-08 W=5.85e-07
MI1_MXPB2_3 XI1_p1 a1 VDD VDD pm1p2_svt_lp L=6e-08 W=5.85e-07
MI1_MXPB1 Y A0 XI1_p1 VDD pm1p2_svt_lp L=6e-08 W=5.85e-07
MI1_MXPB1_2 Y A0 XI1_p1 VDD pm1p2_svt_lp L=6e-08 W=5.85e-07
MI1_MXPB1_3 Y A0 XI1_p1 VDD pm1p2_svt_lp L=6e-08 W=5.85e-07
MI1_MXPA1 Y B0 VDD VDD pm1p2_svt_lp L=6e-08 W=4.95e-07
MI1_MXPA1_2 Y B0 VDD VDD pm1p2_svt_lp L=6e-08 W=4.95e-07
.ENDS

.SUBCKT OAI2XB1X4H9R Y VDD VSS A0 A1N B0
MI0_MXNA1 a1 A1N VSS VSS nm1p2_svt_lp L=6e-08 W=2.55e-07
MI0_MXNA1_2 a1 A1N VSS VSS nm1p2_svt_lp L=6e-08 W=2.55e-07
MI1_MXNB2 XI1_n1 a1 VSS VSS nm1p2_svt_lp L=6e-08 W=4.1e-07
MI1_MXNB1 XI1_n1 A0 VSS VSS nm1p2_svt_lp L=6e-08 W=4.1e-07
MI1_MXNB1_2 XI1_n1 A0 VSS VSS nm1p2_svt_lp L=6e-08 W=4.1e-07
MI1_MXNB2_2 XI1_n1 a1 VSS VSS nm1p2_svt_lp L=6e-08 W=4.1e-07
MI1_MXNB2_3 XI1_n1 a1 VSS VSS nm1p2_svt_lp L=6e-08 W=4.1e-07
MI1_MXNB1_3 XI1_n1 A0 VSS VSS nm1p2_svt_lp L=6e-08 W=4.1e-07
MI1_MXNB1_4 XI1_n1 A0 VSS VSS nm1p2_svt_lp L=6e-08 W=4.1e-07
MI1_MXNB2_4 XI1_n1 a1 VSS VSS nm1p2_svt_lp L=6e-08 W=4.1e-07
MI1_MXNA1 Y B0 XI1_n1 VSS nm1p2_svt_lp L=6e-08 W=4.1e-07
MI1_MXNA1_2 Y B0 XI1_n1 VSS nm1p2_svt_lp L=6e-08 W=4.1e-07
MI1_MXNA1_3 Y B0 XI1_n1 VSS nm1p2_svt_lp L=6e-08 W=4.1e-07
MI1_MXNA1_4 Y B0 XI1_n1 VSS nm1p2_svt_lp L=6e-08 W=4.1e-07
MI0_MXPA1 a1 A1N VDD VDD pm1p2_svt_lp L=6e-08 W=3.55e-07
MI0_MXPA1_2 a1 A1N VDD VDD pm1p2_svt_lp L=6e-08 W=3.55e-07
MI1_MXPB2_2 XI1_p1__2 a1 VDD VDD pm1p2_svt_lp L=6e-08 W=5.85e-07
MI1_MXPB1_2 Y A0 XI1_p1__2 VDD pm1p2_svt_lp L=6e-08 W=5.85e-07
MI1_MXPB1_3 Y A0 XI1_p1__3 VDD pm1p2_svt_lp L=6e-08 W=5.85e-07
MI1_MXPB2_3 XI1_p1__3 a1 VDD VDD pm1p2_svt_lp L=6e-08 W=5.85e-07
MI1_MXPB2_4 XI1_p1__4 a1 VDD VDD pm1p2_svt_lp L=6e-08 W=5.85e-07
MI1_MXPB1_4 Y A0 XI1_p1__4 VDD pm1p2_svt_lp L=6e-08 W=5.85e-07
MI1_MXPB1 Y A0 XI1_p1 VDD pm1p2_svt_lp L=6e-08 W=5.85e-07
MI1_MXPB2 XI1_p1 a1 VDD VDD pm1p2_svt_lp L=6e-08 W=5.85e-07
MI1_MXPA1 Y B0 VDD VDD pm1p2_svt_lp L=6e-08 W=4.4e-07
MI1_MXPA1_2 Y B0 VDD VDD pm1p2_svt_lp L=6e-08 W=4.4e-07
MI1_MXPA1_3 Y B0 VDD VDD pm1p2_svt_lp L=6e-08 W=4.4e-07
.ENDS

.SUBCKT OAI2XB1X6H9R Y VDD VSS A0 A1N B0
MI0_MXNA1 a1 A1N VSS VSS nm1p2_svt_lp L=6e-08 W=3.75e-07
MI0_MXNA1_2 a1 A1N VSS VSS nm1p2_svt_lp L=6e-08 W=3.75e-07
MI1_MXNB2 XI1_n1 a1 VSS VSS nm1p2_svt_lp L=6e-08 W=4.95e-07
MI1_MXNB1 XI1_n1 A0 VSS VSS nm1p2_svt_lp L=6e-08 W=4.95e-07
MI1_MXNB1_2 XI1_n1 A0 VSS VSS nm1p2_svt_lp L=6e-08 W=4.95e-07
MI1_MXNB2_2 XI1_n1 a1 VSS VSS nm1p2_svt_lp L=6e-08 W=4.95e-07
MI1_MXNB2_3 XI1_n1 a1 VSS VSS nm1p2_svt_lp L=6e-08 W=4.95e-07
MI1_MXNB1_3 XI1_n1 A0 VSS VSS nm1p2_svt_lp L=6e-08 W=4.95e-07
MI1_MXNB1_4 XI1_n1 A0 VSS VSS nm1p2_svt_lp L=6e-08 W=4.95e-07
MI1_MXNB2_4 XI1_n1 a1 VSS VSS nm1p2_svt_lp L=6e-08 W=4.95e-07
MI1_MXNB2_5 XI1_n1 a1 VSS VSS nm1p2_svt_lp L=6e-08 W=4.95e-07
MI1_MXNB1_5 XI1_n1 A0 VSS VSS nm1p2_svt_lp L=6e-08 W=4.95e-07
MI1_MXNA1 Y B0 XI1_n1 VSS nm1p2_svt_lp L=6e-08 W=4.95e-07
MI1_MXNA1_2 Y B0 XI1_n1 VSS nm1p2_svt_lp L=6e-08 W=4.95e-07
MI1_MXNA1_3 Y B0 XI1_n1 VSS nm1p2_svt_lp L=6e-08 W=4.95e-07
MI1_MXNA1_4 Y B0 XI1_n1 VSS nm1p2_svt_lp L=6e-08 W=4.95e-07
MI1_MXNA1_5 Y B0 XI1_n1 VSS nm1p2_svt_lp L=6e-08 W=4.95e-07
MI0_MXPA1 a1 A1N VDD VDD pm1p2_svt_lp L=6e-08 W=5.2e-07
MI0_MXPA1_2 a1 A1N VDD VDD pm1p2_svt_lp L=6e-08 W=5.2e-07
MI1_MXPB2_2 XI1_p1__2 a1 VDD VDD pm1p2_svt_lp L=6e-08 W=5.85e-07
MI1_MXPB1_2 Y A0 XI1_p1__2 VDD pm1p2_svt_lp L=6e-08 W=5.85e-07
MI1_MXPB1_3 Y A0 XI1_p1__3 VDD pm1p2_svt_lp L=6e-08 W=5.85e-07
MI1_MXPB2_3 XI1_p1__3 a1 VDD VDD pm1p2_svt_lp L=6e-08 W=5.85e-07
MI1_MXPB2_4 XI1_p1__4 a1 VDD VDD pm1p2_svt_lp L=6e-08 W=5.85e-07
MI1_MXPB1_4 Y A0 XI1_p1__4 VDD pm1p2_svt_lp L=6e-08 W=5.85e-07
MI1_MXPB1_5 Y A0 XI1_p1__5 VDD pm1p2_svt_lp L=6e-08 W=5.85e-07
MI1_MXPB2_5 XI1_p1__5 a1 VDD VDD pm1p2_svt_lp L=6e-08 W=5.85e-07
MI1_MXPB2_6 XI1_p1__6 a1 VDD VDD pm1p2_svt_lp L=6e-08 W=5.85e-07
MI1_MXPB1_6 Y A0 XI1_p1__6 VDD pm1p2_svt_lp L=6e-08 W=5.85e-07
MI1_MXPB1 Y A0 XI1_p1 VDD pm1p2_svt_lp L=6e-08 W=5.85e-07
MI1_MXPB2 XI1_p1 a1 VDD VDD pm1p2_svt_lp L=6e-08 W=5.85e-07
MI1_MXPA1 Y B0 VDD VDD pm1p2_svt_lp L=6e-08 W=4.95e-07
MI1_MXPA1_2 Y B0 VDD VDD pm1p2_svt_lp L=6e-08 W=4.95e-07
MI1_MXPA1_3 Y B0 VDD VDD pm1p2_svt_lp L=6e-08 W=4.95e-07
MI1_MXPA1_4 Y B0 VDD VDD pm1p2_svt_lp L=6e-08 W=4.95e-07
.ENDS

.SUBCKT OAI2XB1X8H9R Y VDD VSS A0 A1N B0
MI0_MXNA1 a1 A1N VSS VSS nm1p2_svt_lp L=6e-08 W=3.4e-07
MI0_MXNA1_2 a1 A1N VSS VSS nm1p2_svt_lp L=6e-08 W=3.4e-07
MI0_MXNA1_3 a1 A1N VSS VSS nm1p2_svt_lp L=6e-08 W=3.4e-07
MI1_MXNB2 XI1_n1 a1 VSS VSS nm1p2_svt_lp L=6e-08 W=4.7e-07
MI1_MXNB2_2 XI1_n1 a1 VSS VSS nm1p2_svt_lp L=6e-08 W=4.7e-07
MI1_MXNB2_3 XI1_n1 a1 VSS VSS nm1p2_svt_lp L=6e-08 W=4.7e-07
MI1_MXNB2_4 XI1_n1 a1 VSS VSS nm1p2_svt_lp L=6e-08 W=4.7e-07
MI1_MXNB2_5 XI1_n1 a1 VSS VSS nm1p2_svt_lp L=6e-08 W=4.7e-07
MI1_MXNB2_6 XI1_n1 a1 VSS VSS nm1p2_svt_lp L=6e-08 W=4.7e-07
MI1_MXNB2_7 XI1_n1 a1 VSS VSS nm1p2_svt_lp L=6e-08 W=4.7e-07
MI1_MXNB1 XI1_n1 A0 VSS VSS nm1p2_svt_lp L=6e-08 W=4.7e-07
MI1_MXNB1_2 XI1_n1 A0 VSS VSS nm1p2_svt_lp L=6e-08 W=4.7e-07
MI1_MXNB1_3 XI1_n1 A0 VSS VSS nm1p2_svt_lp L=6e-08 W=4.7e-07
MI1_MXNB1_4 XI1_n1 A0 VSS VSS nm1p2_svt_lp L=6e-08 W=4.7e-07
MI1_MXNB1_5 XI1_n1 A0 VSS VSS nm1p2_svt_lp L=6e-08 W=4.7e-07
MI1_MXNB1_6 XI1_n1 A0 VSS VSS nm1p2_svt_lp L=6e-08 W=4.7e-07
MI1_MXNB1_7 XI1_n1 A0 VSS VSS nm1p2_svt_lp L=6e-08 W=4.7e-07
MI1_MXNA1 Y B0 XI1_n1 VSS nm1p2_svt_lp L=6e-08 W=4.7e-07
MI1_MXNA1_2 Y B0 XI1_n1 VSS nm1p2_svt_lp L=6e-08 W=4.7e-07
MI1_MXNA1_3 Y B0 XI1_n1 VSS nm1p2_svt_lp L=6e-08 W=4.7e-07
MI1_MXNA1_4 Y B0 XI1_n1 VSS nm1p2_svt_lp L=6e-08 W=4.7e-07
MI1_MXNA1_5 Y B0 XI1_n1 VSS nm1p2_svt_lp L=6e-08 W=4.7e-07
MI1_MXNA1_6 Y B0 XI1_n1 VSS nm1p2_svt_lp L=6e-08 W=4.7e-07
MI1_MXNA1_7 Y B0 XI1_n1 VSS nm1p2_svt_lp L=6e-08 W=4.7e-07
MI0_MXPA1 a1 A1N VDD VDD pm1p2_svt_lp L=6e-08 W=4.75e-07
MI0_MXPA1_2 a1 A1N VDD VDD pm1p2_svt_lp L=6e-08 W=4.75e-07
MI0_MXPA1_3 a1 A1N VDD VDD pm1p2_svt_lp L=6e-08 W=4.75e-07
MI1_MXPB2 XI1_p1 a1 VDD VDD pm1p2_svt_lp L=6e-08 W=5.85e-07
MI1_MXPB2_2 XI1_p1 a1 VDD VDD pm1p2_svt_lp L=6e-08 W=5.85e-07
MI1_MXPB2_3 XI1_p1 a1 VDD VDD pm1p2_svt_lp L=6e-08 W=5.85e-07
MI1_MXPB2_4 XI1_p1 a1 VDD VDD pm1p2_svt_lp L=6e-08 W=5.85e-07
MI1_MXPB2_5 XI1_p1 a1 VDD VDD pm1p2_svt_lp L=6e-08 W=5.85e-07
MI1_MXPB2_6 XI1_p1 a1 VDD VDD pm1p2_svt_lp L=6e-08 W=5.85e-07
MI1_MXPB2_7 XI1_p1 a1 VDD VDD pm1p2_svt_lp L=6e-08 W=5.85e-07
MI1_MXPB2_8 XI1_p1 a1 VDD VDD pm1p2_svt_lp L=6e-08 W=5.85e-07
MI1_MXPB1 Y A0 XI1_p1 VDD pm1p2_svt_lp L=6e-08 W=5.85e-07
MI1_MXPB1_2 Y A0 XI1_p1 VDD pm1p2_svt_lp L=6e-08 W=5.85e-07
MI1_MXPB1_3 Y A0 XI1_p1 VDD pm1p2_svt_lp L=6e-08 W=5.85e-07
MI1_MXPB1_4 Y A0 XI1_p1 VDD pm1p2_svt_lp L=6e-08 W=5.85e-07
MI1_MXPB1_5 Y A0 XI1_p1 VDD pm1p2_svt_lp L=6e-08 W=5.85e-07
MI1_MXPB1_6 Y A0 XI1_p1 VDD pm1p2_svt_lp L=6e-08 W=5.85e-07
MI1_MXPB1_7 Y A0 XI1_p1 VDD pm1p2_svt_lp L=6e-08 W=5.85e-07
MI1_MXPB1_8 Y A0 XI1_p1 VDD pm1p2_svt_lp L=6e-08 W=5.85e-07
MI1_MXPA1 Y B0 VDD VDD pm1p2_svt_lp L=6e-08 W=5.3e-07
MI1_MXPA1_2 Y B0 VDD VDD pm1p2_svt_lp L=6e-08 W=5.3e-07
MI1_MXPA1_3 Y B0 VDD VDD pm1p2_svt_lp L=6e-08 W=5.3e-07
MI1_MXPA1_4 Y B0 VDD VDD pm1p2_svt_lp L=6e-08 W=5.3e-07
MI1_MXPA1_5 Y B0 VDD VDD pm1p2_svt_lp L=6e-08 W=5.3e-07
.ENDS

.SUBCKT OAI21BX0P5H9R Y VDD VSS A0 A1 B0N
MI1_MXNB2 XI1_n1 A1 VSS VSS nm1p2_svt_lp L=6e-08 W=2.1e-07
MI1_MXNB1 XI1_n1 A0 VSS VSS nm1p2_svt_lp L=6e-08 W=2.1e-07
MI1_MXNA1 Y b0 XI1_n1 VSS nm1p2_svt_lp L=6e-08 W=2.1e-07
MI0_MXNA1 b0 B0N VSS VSS nm1p2_svt_lp L=6e-08 W=1.5e-07
MI1_MXPB2 XI1_p1 A1 VDD VDD pm1p2_svt_lp L=6e-08 W=2.95e-07
MI1_MXPB1 Y A0 XI1_p1 VDD pm1p2_svt_lp L=6e-08 W=2.95e-07
MI1_MXPA1 Y b0 VDD VDD pm1p2_svt_lp L=6e-08 W=1.65e-07
MI0_MXPA1 b0 B0N VDD VDD pm1p2_svt_lp L=6e-08 W=2.1e-07
.ENDS

.SUBCKT OAI21BX0P7H9R Y VDD VSS A0 A1 B0N
MI1_MXNB2 XI1_n1 A1 VSS VSS nm1p2_svt_lp L=6e-08 W=2.9e-07
MI1_MXNB1 XI1_n1 A0 VSS VSS nm1p2_svt_lp L=6e-08 W=2.9e-07
MI1_MXNA1 Y b0 XI1_n1 VSS nm1p2_svt_lp L=6e-08 W=2.9e-07
MI0_MXNA1 b0 B0N VSS VSS nm1p2_svt_lp L=6e-08 W=1.5e-07
MI1_MXPB2 XI1_p1 A1 VDD VDD pm1p2_svt_lp L=6e-08 W=4.15e-07
MI1_MXPB1 Y A0 XI1_p1 VDD pm1p2_svt_lp L=6e-08 W=4.15e-07
MI1_MXPA1 Y b0 VDD VDD pm1p2_svt_lp L=6e-08 W=2.35e-07
MI0_MXPA1 b0 B0N VDD VDD pm1p2_svt_lp L=6e-08 W=2.1e-07
.ENDS

.SUBCKT OAI21BX1H9R Y VDD VSS A0 A1 B0N
MI1_MXNB2 XI1_n1 A1 VSS VSS nm1p2_svt_lp L=6e-08 W=4.1e-07
MI1_MXNB1 XI1_n1 A0 VSS VSS nm1p2_svt_lp L=6e-08 W=4.1e-07
MI1_MXNA1 Y b0 XI1_n1 VSS nm1p2_svt_lp L=6e-08 W=4.1e-07
MI0_MXNA1 b0 B0N VSS VSS nm1p2_svt_lp L=6e-08 W=1.5e-07
MI1_MXPB2 XI1_p1 A1 VDD VDD pm1p2_svt_lp L=6e-08 W=5.85e-07
MI1_MXPB1 Y A0 XI1_p1 VDD pm1p2_svt_lp L=6e-08 W=5.85e-07
MI1_MXPA1 Y b0 VDD VDD pm1p2_svt_lp L=6e-08 W=3.3e-07
MI0_MXPA1 b0 B0N VDD VDD pm1p2_svt_lp L=6e-08 W=2.1e-07
.ENDS

.SUBCKT OAI21BX1P4H9R Y VDD VSS A0 A1 B0N
MI0_MXNA1 b0 B0N VSS VSS nm1p2_svt_lp L=6e-08 W=1.65e-07
MI1_MXNB2 XI1_n1 A1 VSS VSS nm1p2_svt_lp L=6e-08 W=5.8e-07
MI1_MXNB1 XI1_n1 A0 VSS VSS nm1p2_svt_lp L=6e-08 W=5.8e-07
MI1_MXNA1 Y b0 XI1_n1 VSS nm1p2_svt_lp L=6e-08 W=2.9e-07
MI1_MXNA1_2 Y b0 XI1_n1 VSS nm1p2_svt_lp L=6e-08 W=2.9e-07
MI0_MXPA1 b0 B0N VDD VDD pm1p2_svt_lp L=6e-08 W=2.3e-07
MI1_MXPB2_2 XI1_p1__2 A1 VDD VDD pm1p2_svt_lp L=6e-08 W=4.15e-07
MI1_MXPB1_2 Y A0 XI1_p1__2 VDD pm1p2_svt_lp L=6e-08 W=4.15e-07
MI1_MXPB1 Y A0 XI1_p1 VDD pm1p2_svt_lp L=6e-08 W=4.15e-07
MI1_MXPB2 XI1_p1 A1 VDD VDD pm1p2_svt_lp L=6e-08 W=4.15e-07
MI1_MXPA1 Y b0 VDD VDD pm1p2_svt_lp L=6e-08 W=2.35e-07
MI1_MXPA1_2 Y b0 VDD VDD pm1p2_svt_lp L=6e-08 W=2.35e-07
.ENDS

.SUBCKT OAI21BX2H9R Y VDD VSS A0 A1 B0N
MI1_MXNB2 XI1_n1 A1 VSS VSS nm1p2_svt_lp L=6e-08 W=4.1e-07
MI1_MXNB1 XI1_n1 A0 VSS VSS nm1p2_svt_lp L=6e-08 W=4.1e-07
MI1_MXNB1_2 XI1_n1 A0 VSS VSS nm1p2_svt_lp L=6e-08 W=4.1e-07
MI1_MXNB2_2 XI1_n1 A1 VSS VSS nm1p2_svt_lp L=6e-08 W=4.1e-07
MI1_MXNA1 Y b0 XI1_n1 VSS nm1p2_svt_lp L=6e-08 W=4.1e-07
MI1_MXNA1_2 Y b0 XI1_n1 VSS nm1p2_svt_lp L=6e-08 W=4.1e-07
MI0_MXNA1 b0 B0N VSS VSS nm1p2_svt_lp L=6e-08 W=2.1e-07
MI1_MXPB2_2 XI1_p1__2 A1 VDD VDD pm1p2_svt_lp L=6e-08 W=5.85e-07
MI1_MXPB1_2 Y A0 XI1_p1__2 VDD pm1p2_svt_lp L=6e-08 W=5.85e-07
MI1_MXPB1 Y A0 XI1_p1 VDD pm1p2_svt_lp L=6e-08 W=5.85e-07
MI1_MXPB2 XI1_p1 A1 VDD VDD pm1p2_svt_lp L=6e-08 W=5.85e-07
MI1_MXPA1 Y b0 VDD VDD pm1p2_svt_lp L=6e-08 W=3.3e-07
MI1_MXPA1_2 Y b0 VDD VDD pm1p2_svt_lp L=6e-08 W=3.3e-07
MI0_MXPA1 b0 B0N VDD VDD pm1p2_svt_lp L=6e-08 W=2.9e-07
.ENDS

.SUBCKT OAI21BX3H9R Y VDD VSS A0 A1 B0N
MI1_MXNB2 XI1_n1 A1 VSS VSS nm1p2_svt_lp L=6e-08 W=4.1e-07
MI1_MXNB2_2 XI1_n1 A1 VSS VSS nm1p2_svt_lp L=6e-08 W=4.1e-07
MI1_MXNB2_3 XI1_n1 A1 VSS VSS nm1p2_svt_lp L=6e-08 W=4.1e-07
MI1_MXNB1 XI1_n1 A0 VSS VSS nm1p2_svt_lp L=6e-08 W=4.1e-07
MI1_MXNB1_2 XI1_n1 A0 VSS VSS nm1p2_svt_lp L=6e-08 W=4.1e-07
MI1_MXNB1_3 XI1_n1 A0 VSS VSS nm1p2_svt_lp L=6e-08 W=4.1e-07
MI1_MXNA1 Y b0 XI1_n1 VSS nm1p2_svt_lp L=6e-08 W=4.1e-07
MI1_MXNA1_2 Y b0 XI1_n1 VSS nm1p2_svt_lp L=6e-08 W=4.1e-07
MI1_MXNA1_3 Y b0 XI1_n1 VSS nm1p2_svt_lp L=6e-08 W=4.1e-07
MI0_MXNA1 b0 B0N VSS VSS nm1p2_svt_lp L=6e-08 W=2.95e-07
MI1_MXPB2 XI1_p1 A1 VDD VDD pm1p2_svt_lp L=6e-08 W=5.85e-07
MI1_MXPB2_2 XI1_p1 A1 VDD VDD pm1p2_svt_lp L=6e-08 W=5.85e-07
MI1_MXPB2_3 XI1_p1 A1 VDD VDD pm1p2_svt_lp L=6e-08 W=5.85e-07
MI1_MXPB1 Y A0 XI1_p1 VDD pm1p2_svt_lp L=6e-08 W=5.85e-07
MI1_MXPB1_2 Y A0 XI1_p1 VDD pm1p2_svt_lp L=6e-08 W=5.85e-07
MI1_MXPB1_3 Y A0 XI1_p1 VDD pm1p2_svt_lp L=6e-08 W=5.85e-07
MI1_MXPA1 Y b0 VDD VDD pm1p2_svt_lp L=6e-08 W=4.95e-07
MI1_MXPA1_2 Y b0 VDD VDD pm1p2_svt_lp L=6e-08 W=4.95e-07
MI0_MXPA1 b0 B0N VDD VDD pm1p2_svt_lp L=6e-08 W=4.15e-07
.ENDS

.SUBCKT OAI21BX4H9R Y VDD VSS A0 A1 B0N
MI1_MXNB2 XI1_n1 A1 VSS VSS nm1p2_svt_lp L=6e-08 W=4.1e-07
MI1_MXNB2_2 XI1_n1 A1 VSS VSS nm1p2_svt_lp L=6e-08 W=4.1e-07
MI1_MXNB2_3 XI1_n1 A1 VSS VSS nm1p2_svt_lp L=6e-08 W=4.1e-07
MI1_MXNB2_4 XI1_n1 A1 VSS VSS nm1p2_svt_lp L=6e-08 W=4.1e-07
MI1_MXNB1 XI1_n1 A0 VSS VSS nm1p2_svt_lp L=6e-08 W=4.1e-07
MI1_MXNB1_2 XI1_n1 A0 VSS VSS nm1p2_svt_lp L=6e-08 W=4.1e-07
MI1_MXNB1_3 XI1_n1 A0 VSS VSS nm1p2_svt_lp L=6e-08 W=4.1e-07
MI1_MXNB1_4 XI1_n1 A0 VSS VSS nm1p2_svt_lp L=6e-08 W=4.1e-07
MI1_MXNA1 Y b0 XI1_n1 VSS nm1p2_svt_lp L=6e-08 W=4.1e-07
MI1_MXNA1_2 Y b0 XI1_n1 VSS nm1p2_svt_lp L=6e-08 W=4.1e-07
MI1_MXNA1_3 Y b0 XI1_n1 VSS nm1p2_svt_lp L=6e-08 W=4.1e-07
MI1_MXNA1_4 Y b0 XI1_n1 VSS nm1p2_svt_lp L=6e-08 W=4.1e-07
MI0_MXNA1 b0 B0N VSS VSS nm1p2_svt_lp L=6e-08 W=3.9e-07
MI1_MXPB2 XI1_p1 A1 VDD VDD pm1p2_svt_lp L=6e-08 W=5.85e-07
MI1_MXPB2_2 XI1_p1 A1 VDD VDD pm1p2_svt_lp L=6e-08 W=5.85e-07
MI1_MXPB2_3 XI1_p1 A1 VDD VDD pm1p2_svt_lp L=6e-08 W=5.85e-07
MI1_MXPB2_4 XI1_p1 A1 VDD VDD pm1p2_svt_lp L=6e-08 W=5.85e-07
MI1_MXPB1 Y A0 XI1_p1 VDD pm1p2_svt_lp L=6e-08 W=5.85e-07
MI1_MXPB1_2 Y A0 XI1_p1 VDD pm1p2_svt_lp L=6e-08 W=5.85e-07
MI1_MXPB1_3 Y A0 XI1_p1 VDD pm1p2_svt_lp L=6e-08 W=5.85e-07
MI1_MXPB1_4 Y A0 XI1_p1 VDD pm1p2_svt_lp L=6e-08 W=5.85e-07
MI1_MXPA1 Y b0 VDD VDD pm1p2_svt_lp L=6e-08 W=4.4e-07
MI1_MXPA1_2 Y b0 VDD VDD pm1p2_svt_lp L=6e-08 W=4.4e-07
MI1_MXPA1_3 Y b0 VDD VDD pm1p2_svt_lp L=6e-08 W=4.4e-07
MI0_MXPA1 b0 B0N VDD VDD pm1p2_svt_lp L=6e-08 W=5.45e-07
.ENDS

.SUBCKT OAI21BX6H9R Y VDD VSS A0 A1 B0N
MI1_MXNB2 XI1_n1 A1 VSS VSS nm1p2_svt_lp L=6e-08 W=4.1e-07
MI1_MXNB1 XI1_n1 A0 VSS VSS nm1p2_svt_lp L=6e-08 W=4.1e-07
MI1_MXNB1_2 XI1_n1 A0 VSS VSS nm1p2_svt_lp L=6e-08 W=4.1e-07
MI1_MXNB2_2 XI1_n1 A1 VSS VSS nm1p2_svt_lp L=6e-08 W=4.1e-07
MI1_MXNB2_3 XI1_n1 A1 VSS VSS nm1p2_svt_lp L=6e-08 W=4.1e-07
MI1_MXNB1_3 XI1_n1 A0 VSS VSS nm1p2_svt_lp L=6e-08 W=4.1e-07
MI1_MXNB1_4 XI1_n1 A0 VSS VSS nm1p2_svt_lp L=6e-08 W=4.1e-07
MI1_MXNB2_4 XI1_n1 A1 VSS VSS nm1p2_svt_lp L=6e-08 W=4.1e-07
MI1_MXNB2_5 XI1_n1 A1 VSS VSS nm1p2_svt_lp L=6e-08 W=4.1e-07
MI1_MXNB1_5 XI1_n1 A0 VSS VSS nm1p2_svt_lp L=6e-08 W=4.1e-07
MI1_MXNB1_6 XI1_n1 A0 VSS VSS nm1p2_svt_lp L=6e-08 W=4.1e-07
MI1_MXNB2_6 XI1_n1 A1 VSS VSS nm1p2_svt_lp L=6e-08 W=4.1e-07
MI1_MXNA1 Y b0 XI1_n1 VSS nm1p2_svt_lp L=6e-08 W=4.8e-07
MI1_MXNA1_2 Y b0 XI1_n1 VSS nm1p2_svt_lp L=6e-08 W=4.95e-07
MI1_MXNA1_3 Y b0 XI1_n1 VSS nm1p2_svt_lp L=6e-08 W=4.95e-07
MI1_MXNA1_4 Y b0 XI1_n1 VSS nm1p2_svt_lp L=6e-08 W=4.95e-07
MI1_MXNA1_5 Y b0 XI1_n1 VSS nm1p2_svt_lp L=6e-08 W=4.95e-07
MI0_MXNA1 b0 B0N VSS VSS nm1p2_svt_lp L=6e-08 W=2.95e-07
MI0_MXNA1_2 b0 B0N VSS VSS nm1p2_svt_lp L=6e-08 W=2.95e-07
MI1_MXPB2_2 XI1_p1__2 A1 VDD VDD pm1p2_svt_lp L=6e-08 W=5.85e-07
MI1_MXPB1_2 Y A0 XI1_p1__2 VDD pm1p2_svt_lp L=6e-08 W=5.85e-07
MI1_MXPB1_3 Y A0 XI1_p1__3 VDD pm1p2_svt_lp L=6e-08 W=5.85e-07
MI1_MXPB2_3 XI1_p1__3 A1 VDD VDD pm1p2_svt_lp L=6e-08 W=5.85e-07
MI1_MXPB2_4 XI1_p1__4 A1 VDD VDD pm1p2_svt_lp L=6e-08 W=5.85e-07
MI1_MXPB1_4 Y A0 XI1_p1__4 VDD pm1p2_svt_lp L=6e-08 W=5.85e-07
MI1_MXPB1_5 Y A0 XI1_p1__5 VDD pm1p2_svt_lp L=6e-08 W=5.85e-07
MI1_MXPB2_5 XI1_p1__5 A1 VDD VDD pm1p2_svt_lp L=6e-08 W=5.85e-07
MI1_MXPB2_6 XI1_p1__6 A1 VDD VDD pm1p2_svt_lp L=6e-08 W=5.85e-07
MI1_MXPB1_6 Y A0 XI1_p1__6 VDD pm1p2_svt_lp L=6e-08 W=5.85e-07
MI1_MXPB1 Y A0 XI1_p1 VDD pm1p2_svt_lp L=6e-08 W=5.85e-07
MI1_MXPB2 XI1_p1 A1 VDD VDD pm1p2_svt_lp L=6e-08 W=5.85e-07
MI1_MXPA1 Y b0 VDD VDD pm1p2_svt_lp L=6e-08 W=4.95e-07
MI1_MXPA1_2 Y b0 VDD VDD pm1p2_svt_lp L=6e-08 W=4.95e-07
MI1_MXPA1_3 Y b0 VDD VDD pm1p2_svt_lp L=6e-08 W=4.95e-07
MI1_MXPA1_4 Y b0 VDD VDD pm1p2_svt_lp L=6e-08 W=4.95e-07
MI0_MXPA1 b0 B0N VDD VDD pm1p2_svt_lp L=6e-08 W=4.1e-07
MI0_MXPA1_2 b0 B0N VDD VDD pm1p2_svt_lp L=6e-08 W=4.1e-07
.ENDS

.SUBCKT OAI21BX8H9R Y VDD VSS A0 A1 B0N
MI1_MXNB2 XI1_n1 A1 VSS VSS nm1p2_svt_lp L=6e-08 W=4.7e-07
MI1_MXNB2_2 XI1_n1 A1 VSS VSS nm1p2_svt_lp L=6e-08 W=4.7e-07
MI1_MXNB2_3 XI1_n1 A1 VSS VSS nm1p2_svt_lp L=6e-08 W=4.7e-07
MI1_MXNB2_4 XI1_n1 A1 VSS VSS nm1p2_svt_lp L=6e-08 W=4.7e-07
MI1_MXNB2_5 XI1_n1 A1 VSS VSS nm1p2_svt_lp L=6e-08 W=4.7e-07
MI1_MXNB2_6 XI1_n1 A1 VSS VSS nm1p2_svt_lp L=6e-08 W=4.7e-07
MI1_MXNB2_7 XI1_n1 A1 VSS VSS nm1p2_svt_lp L=6e-08 W=4.7e-07
MI1_MXNB1 XI1_n1 A0 VSS VSS nm1p2_svt_lp L=6e-08 W=4.7e-07
MI1_MXNB1_2 XI1_n1 A0 VSS VSS nm1p2_svt_lp L=6e-08 W=4.7e-07
MI1_MXNB1_3 XI1_n1 A0 VSS VSS nm1p2_svt_lp L=6e-08 W=4.7e-07
MI1_MXNB1_4 XI1_n1 A0 VSS VSS nm1p2_svt_lp L=6e-08 W=4.7e-07
MI1_MXNB1_5 XI1_n1 A0 VSS VSS nm1p2_svt_lp L=6e-08 W=4.7e-07
MI1_MXNB1_6 XI1_n1 A0 VSS VSS nm1p2_svt_lp L=6e-08 W=4.7e-07
MI1_MXNB1_7 XI1_n1 A0 VSS VSS nm1p2_svt_lp L=6e-08 W=4.7e-07
MI1_MXNA1 Y b0 XI1_n1 VSS nm1p2_svt_lp L=6e-08 W=4.7e-07
MI1_MXNA1_2 Y b0 XI1_n1 VSS nm1p2_svt_lp L=6e-08 W=4.7e-07
MI1_MXNA1_3 Y b0 XI1_n1 VSS nm1p2_svt_lp L=6e-08 W=4.7e-07
MI1_MXNA1_4 Y b0 XI1_n1 VSS nm1p2_svt_lp L=6e-08 W=4.7e-07
MI1_MXNA1_5 Y b0 XI1_n1 VSS nm1p2_svt_lp L=6e-08 W=4.7e-07
MI1_MXNA1_6 Y b0 XI1_n1 VSS nm1p2_svt_lp L=6e-08 W=4.7e-07
MI1_MXNA1_7 Y b0 XI1_n1 VSS nm1p2_svt_lp L=6e-08 W=4.7e-07
MI0_MXNA1 b0 B0N VSS VSS nm1p2_svt_lp L=6e-08 W=3.85e-07
MI0_MXNA1_2 b0 B0N VSS VSS nm1p2_svt_lp L=6e-08 W=3.85e-07
MI1_MXPB2 XI1_p1 A1 VDD VDD pm1p2_svt_lp L=6e-08 W=5.85e-07
MI1_MXPB2_2 XI1_p1 A1 VDD VDD pm1p2_svt_lp L=6e-08 W=5.85e-07
MI1_MXPB2_3 XI1_p1 A1 VDD VDD pm1p2_svt_lp L=6e-08 W=5.85e-07
MI1_MXPB2_4 XI1_p1 A1 VDD VDD pm1p2_svt_lp L=6e-08 W=5.85e-07
MI1_MXPB2_5 XI1_p1 A1 VDD VDD pm1p2_svt_lp L=6e-08 W=5.85e-07
MI1_MXPB2_6 XI1_p1 A1 VDD VDD pm1p2_svt_lp L=6e-08 W=5.85e-07
MI1_MXPB2_7 XI1_p1 A1 VDD VDD pm1p2_svt_lp L=6e-08 W=5.85e-07
MI1_MXPB2_8 XI1_p1 A1 VDD VDD pm1p2_svt_lp L=6e-08 W=5.85e-07
MI1_MXPB1 Y A0 XI1_p1 VDD pm1p2_svt_lp L=6e-08 W=5.85e-07
MI1_MXPB1_2 Y A0 XI1_p1 VDD pm1p2_svt_lp L=6e-08 W=5.85e-07
MI1_MXPB1_3 Y A0 XI1_p1 VDD pm1p2_svt_lp L=6e-08 W=5.85e-07
MI1_MXPB1_4 Y A0 XI1_p1 VDD pm1p2_svt_lp L=6e-08 W=5.85e-07
MI1_MXPB1_5 Y A0 XI1_p1 VDD pm1p2_svt_lp L=6e-08 W=5.85e-07
MI1_MXPB1_6 Y A0 XI1_p1 VDD pm1p2_svt_lp L=6e-08 W=5.85e-07
MI1_MXPB1_7 Y A0 XI1_p1 VDD pm1p2_svt_lp L=6e-08 W=5.85e-07
MI1_MXPB1_8 Y A0 XI1_p1 VDD pm1p2_svt_lp L=6e-08 W=5.85e-07
MI1_MXPA1 Y b0 VDD VDD pm1p2_svt_lp L=6e-08 W=5.3e-07
MI1_MXPA1_2 Y b0 VDD VDD pm1p2_svt_lp L=6e-08 W=5.3e-07
MI1_MXPA1_3 Y b0 VDD VDD pm1p2_svt_lp L=6e-08 W=5.3e-07
MI1_MXPA1_4 Y b0 VDD VDD pm1p2_svt_lp L=6e-08 W=5.3e-07
MI1_MXPA1_5 Y b0 VDD VDD pm1p2_svt_lp L=6e-08 W=5.3e-07
MI0_MXPA1 b0 B0N VDD VDD pm1p2_svt_lp L=6e-08 W=5.4e-07
MI0_MXPA1_2 b0 B0N VDD VDD pm1p2_svt_lp L=6e-08 W=5.4e-07
.ENDS

.SUBCKT OA22X0P5H9R Y VDD VSS A0 A1 B0 B1
MI0_MXNB2 XI0_n1 A1 VSS VSS nm1p2_svt_lp L=6e-08 W=2.65e-07
MI0_MXNB1 XI0_n1 A0 VSS VSS nm1p2_svt_lp L=6e-08 W=2.65e-07
MI0_MXNA1 ny B0 XI0_n1 VSS nm1p2_svt_lp L=6e-08 W=2.65e-07
MI0_MXNA2 ny B1 XI0_n1 VSS nm1p2_svt_lp L=6e-08 W=2.65e-07
MI1_MXNA1 Y ny VSS VSS nm1p2_svt_lp L=6e-08 W=2.1e-07
MI0_MXPB2 XI0_p1B A1 VDD VDD pm1p2_svt_lp L=6e-08 W=3.75e-07
MI0_MXPB1 ny A0 XI0_p1B VDD pm1p2_svt_lp L=6e-08 W=3.75e-07
MI0_MXPA1 ny B0 XI0_p1A VDD pm1p2_svt_lp L=6e-08 W=3.75e-07
MI0_MXPA2 XI0_p1A B1 VDD VDD pm1p2_svt_lp L=6e-08 W=3.75e-07
MI1_MXPA1 Y ny VDD VDD pm1p2_svt_lp L=6e-08 W=2.95e-07
.ENDS

.SUBCKT OA22X0P7H9R Y VDD VSS A0 A1 B0 B1
MI0_MXNB2 XI0_n1 A1 VSS VSS nm1p2_svt_lp L=6e-08 W=3.1e-07
MI0_MXNB1 XI0_n1 A0 VSS VSS nm1p2_svt_lp L=6e-08 W=3.1e-07
MI0_MXNA1 ny B0 XI0_n1 VSS nm1p2_svt_lp L=6e-08 W=3.1e-07
MI0_MXNA2 ny B1 XI0_n1 VSS nm1p2_svt_lp L=6e-08 W=3.1e-07
MI1_MXNA1 Y ny VSS VSS nm1p2_svt_lp L=6e-08 W=2.95e-07
MI0_MXPB2 XI0_p1B A1 VDD VDD pm1p2_svt_lp L=6e-08 W=4.4e-07
MI0_MXPB1 ny A0 XI0_p1B VDD pm1p2_svt_lp L=6e-08 W=4.4e-07
MI0_MXPA1 ny B0 XI0_p1A VDD pm1p2_svt_lp L=6e-08 W=4.4e-07
MI0_MXPA2 XI0_p1A B1 VDD VDD pm1p2_svt_lp L=6e-08 W=4.4e-07
MI1_MXPA1 Y ny VDD VDD pm1p2_svt_lp L=6e-08 W=4.15e-07
.ENDS

.SUBCKT OA22X1H9R Y VDD VSS A0 A1 B0 B1
MI0_MXNB2 XI0_n1 A1 VSS VSS nm1p2_svt_lp L=6e-08 W=3.8e-07
MI0_MXNB1 XI0_n1 A0 VSS VSS nm1p2_svt_lp L=6e-08 W=3.8e-07
MI0_MXNA1 ny B0 XI0_n1 VSS nm1p2_svt_lp L=6e-08 W=3.8e-07
MI0_MXNA2 ny B1 XI0_n1 VSS nm1p2_svt_lp L=6e-08 W=3.8e-07
MI1_MXNA1 Y ny VSS VSS nm1p2_svt_lp L=6e-08 W=4.2e-07
MI0_MXPB2 XI0_p1B A1 VDD VDD pm1p2_svt_lp L=6e-08 W=5.35e-07
MI0_MXPB1 ny A0 XI0_p1B VDD pm1p2_svt_lp L=6e-08 W=5.35e-07
MI0_MXPA1 ny B0 XI0_p1A VDD pm1p2_svt_lp L=6e-08 W=5.35e-07
MI0_MXPA2 XI0_p1A B1 VDD VDD pm1p2_svt_lp L=6e-08 W=5.35e-07
MI1_MXPA1 Y ny VDD VDD pm1p2_svt_lp L=6e-08 W=5.85e-07
.ENDS

.SUBCKT OA22X1P4H9R Y VDD VSS A0 A1 B0 B1
MI0_MXNB2 XI0_n1 A1 VSS VSS nm1p2_svt_lp L=6e-08 W=3.15e-07
MI0_MXNB1 XI0_n1 A0 VSS VSS nm1p2_svt_lp L=6e-08 W=3.15e-07
MI0_MXNB1_2 XI0_n1 A0 VSS VSS nm1p2_svt_lp L=6e-08 W=3.15e-07
MI0_MXNB2_2 XI0_n1 A1 VSS VSS nm1p2_svt_lp L=6e-08 W=3.15e-07
MI0_MXNA2 ny B1 XI0_n1 VSS nm1p2_svt_lp L=6e-08 W=6.3e-07
MI0_MXNA1 ny B0 XI0_n1 VSS nm1p2_svt_lp L=6e-08 W=6.3e-07
MI1_MXNA1 Y ny VSS VSS nm1p2_svt_lp L=6e-08 W=2.95e-07
MI1_MXNA1_2 Y ny VSS VSS nm1p2_svt_lp L=6e-08 W=2.95e-07
MI0_MXPB2_2 XI0_p1B__2 A1 VDD VDD pm1p2_svt_lp L=6e-08 W=4.45e-07
MI0_MXPB1_2 ny A0 XI0_p1B__2 VDD pm1p2_svt_lp L=6e-08 W=4.45e-07
MI0_MXPB1 ny A0 XI0_p1B VDD pm1p2_svt_lp L=6e-08 W=4.45e-07
MI0_MXPB2 XI0_p1B A1 VDD VDD pm1p2_svt_lp L=6e-08 W=4.45e-07
MI0_MXPA2_2 XI0_p1A__2 B1 VDD VDD pm1p2_svt_lp L=6e-08 W=4.45e-07
MI0_MXPA1_2 ny B0 XI0_p1A__2 VDD pm1p2_svt_lp L=6e-08 W=4.45e-07
MI0_MXPA1 ny B0 XI0_p1A VDD pm1p2_svt_lp L=6e-08 W=4.45e-07
MI0_MXPA2 XI0_p1A B1 VDD VDD pm1p2_svt_lp L=6e-08 W=4.45e-07
MI1_MXPA1 Y ny VDD VDD pm1p2_svt_lp L=6e-08 W=4.15e-07
MI1_MXPA1_2 Y ny VDD VDD pm1p2_svt_lp L=6e-08 W=4.15e-07
.ENDS

.SUBCKT OA22X2H9R Y VDD VSS A0 A1 B0 B1
MI0_MXNB2 XI0_n1 A1 VSS VSS nm1p2_svt_lp L=6e-08 W=3.8e-07
MI0_MXNB1 XI0_n1 A0 VSS VSS nm1p2_svt_lp L=6e-08 W=3.8e-07
MI0_MXNB1_2 XI0_n1 A0 VSS VSS nm1p2_svt_lp L=6e-08 W=3.8e-07
MI0_MXNB2_2 XI0_n1 A1 VSS VSS nm1p2_svt_lp L=6e-08 W=3.8e-07
MI0_MXNA2 ny B1 XI0_n1 VSS nm1p2_svt_lp L=6e-08 W=3.8e-07
MI0_MXNA1 ny B0 XI0_n1 VSS nm1p2_svt_lp L=6e-08 W=3.8e-07
MI0_MXNA1_2 ny B0 XI0_n1 VSS nm1p2_svt_lp L=6e-08 W=3.8e-07
MI0_MXNA2_2 ny B1 XI0_n1 VSS nm1p2_svt_lp L=6e-08 W=3.8e-07
MI1_MXNA1 Y ny VSS VSS nm1p2_svt_lp L=6e-08 W=4.2e-07
MI1_MXNA1_2 Y ny VSS VSS nm1p2_svt_lp L=6e-08 W=4.2e-07
MI0_MXPB2_2 XI0_p1B__2 A1 VDD VDD pm1p2_svt_lp L=6e-08 W=5.4e-07
MI0_MXPB1_2 ny A0 XI0_p1B__2 VDD pm1p2_svt_lp L=6e-08 W=5.4e-07
MI0_MXPB1 ny A0 XI0_p1B VDD pm1p2_svt_lp L=6e-08 W=5.4e-07
MI0_MXPB2 XI0_p1B A1 VDD VDD pm1p2_svt_lp L=6e-08 W=5.4e-07
MI0_MXPA2_2 XI0_p1A__2 B1 VDD VDD pm1p2_svt_lp L=6e-08 W=5.4e-07
MI0_MXPA1_2 ny B0 XI0_p1A__2 VDD pm1p2_svt_lp L=6e-08 W=5.4e-07
MI0_MXPA1 ny B0 XI0_p1A VDD pm1p2_svt_lp L=6e-08 W=5.4e-07
MI0_MXPA2 XI0_p1A B1 VDD VDD pm1p2_svt_lp L=6e-08 W=5.4e-07
MI1_MXPA1 Y ny VDD VDD pm1p2_svt_lp L=6e-08 W=5.85e-07
MI1_MXPA1_2 Y ny VDD VDD pm1p2_svt_lp L=6e-08 W=5.85e-07
.ENDS

.SUBCKT OA22X3H9R Y VDD VSS A0 A1 B0 B1
MI0_MXNB2 XI0_n1 A1 VSS VSS nm1p2_svt_lp L=6e-08 W=4e-07
MI0_MXNB2_2 XI0_n1 A1 VSS VSS nm1p2_svt_lp L=6e-08 W=4e-07
MI0_MXNB2_3 XI0_n1 A1 VSS VSS nm1p2_svt_lp L=6e-08 W=4e-07
MI0_MXNB1 XI0_n1 A0 VSS VSS nm1p2_svt_lp L=6e-08 W=4e-07
MI0_MXNB1_2 XI0_n1 A0 VSS VSS nm1p2_svt_lp L=6e-08 W=4e-07
MI0_MXNB1_3 XI0_n1 A0 VSS VSS nm1p2_svt_lp L=6e-08 W=4e-07
MI0_MXNA1 ny B0 XI0_n1 VSS nm1p2_svt_lp L=6e-08 W=4e-07
MI0_MXNA1_2 ny B0 XI0_n1 VSS nm1p2_svt_lp L=6e-08 W=4e-07
MI0_MXNA1_3 ny B0 XI0_n1 VSS nm1p2_svt_lp L=6e-08 W=4e-07
MI0_MXNA2 ny B1 XI0_n1 VSS nm1p2_svt_lp L=6e-08 W=4e-07
MI0_MXNA2_2 ny B1 XI0_n1 VSS nm1p2_svt_lp L=6e-08 W=4e-07
MI0_MXNA2_3 ny B1 XI0_n1 VSS nm1p2_svt_lp L=6e-08 W=4e-07
MI1_MXNA1 Y ny VSS VSS nm1p2_svt_lp L=6e-08 W=4.2e-07
MI1_MXNA1_2 Y ny VSS VSS nm1p2_svt_lp L=6e-08 W=4.2e-07
MI1_MXNA1_3 Y ny VSS VSS nm1p2_svt_lp L=6e-08 W=4.2e-07
MI0_MXPB2 XI0_p1B A1 VDD VDD pm1p2_svt_lp L=6e-08 W=5.65e-07
MI0_MXPB2_2 XI0_p1B A1 VDD VDD pm1p2_svt_lp L=6e-08 W=5.65e-07
MI0_MXPB2_3 XI0_p1B A1 VDD VDD pm1p2_svt_lp L=6e-08 W=5.65e-07
MI0_MXPB1 ny A0 XI0_p1B VDD pm1p2_svt_lp L=6e-08 W=5.65e-07
MI0_MXPB1_2 ny A0 XI0_p1B VDD pm1p2_svt_lp L=6e-08 W=5.65e-07
MI0_MXPB1_3 ny A0 XI0_p1B VDD pm1p2_svt_lp L=6e-08 W=5.65e-07
MI0_MXPA1 ny B0 XI0_p1A VDD pm1p2_svt_lp L=6e-08 W=5.65e-07
MI0_MXPA1_2 ny B0 XI0_p1A VDD pm1p2_svt_lp L=6e-08 W=5.65e-07
MI0_MXPA1_3 ny B0 XI0_p1A VDD pm1p2_svt_lp L=6e-08 W=5.65e-07
MI0_MXPA2 XI0_p1A B1 VDD VDD pm1p2_svt_lp L=6e-08 W=5.65e-07
MI0_MXPA2_2 XI0_p1A B1 VDD VDD pm1p2_svt_lp L=6e-08 W=5.65e-07
MI0_MXPA2_3 XI0_p1A B1 VDD VDD pm1p2_svt_lp L=6e-08 W=5.65e-07
MI1_MXPA1 Y ny VDD VDD pm1p2_svt_lp L=6e-08 W=5.85e-07
MI1_MXPA1_2 Y ny VDD VDD pm1p2_svt_lp L=6e-08 W=5.85e-07
MI1_MXPA1_3 Y ny VDD VDD pm1p2_svt_lp L=6e-08 W=5.85e-07
.ENDS

.SUBCKT OA22X4H9R Y VDD VSS A0 A1 B0 B1
MI0_MXNB2 XI0_n1 A1 VSS VSS nm1p2_svt_lp L=6e-08 W=5.1e-07
MI0_MXNB1 XI0_n1 A0 VSS VSS nm1p2_svt_lp L=6e-08 W=5.1e-07
MI0_MXNB1_2 XI0_n1 A0 VSS VSS nm1p2_svt_lp L=6e-08 W=5.1e-07
MI0_MXNB2_2 XI0_n1 A1 VSS VSS nm1p2_svt_lp L=6e-08 W=5.1e-07
MI0_MXNB2_3 XI0_n1 A1 VSS VSS nm1p2_svt_lp L=6e-08 W=5.1e-07
MI0_MXNB1_3 XI0_n1 A0 VSS VSS nm1p2_svt_lp L=6e-08 W=5.1e-07
MI0_MXNA2 ny B1 XI0_n1 VSS nm1p2_svt_lp L=6e-08 W=5.1e-07
MI0_MXNA1 ny B0 XI0_n1 VSS nm1p2_svt_lp L=6e-08 W=5.1e-07
MI0_MXNA1_2 ny B0 XI0_n1 VSS nm1p2_svt_lp L=6e-08 W=5.1e-07
MI0_MXNA2_2 ny B1 XI0_n1 VSS nm1p2_svt_lp L=6e-08 W=5.1e-07
MI0_MXNA2_3 ny B1 XI0_n1 VSS nm1p2_svt_lp L=6e-08 W=5.1e-07
MI0_MXNA1_3 ny B0 XI0_n1 VSS nm1p2_svt_lp L=6e-08 W=5.1e-07
MI1_MXNA1 Y ny VSS VSS nm1p2_svt_lp L=6e-08 W=4.2e-07
MI1_MXNA1_2 Y ny VSS VSS nm1p2_svt_lp L=6e-08 W=4.2e-07
MI1_MXNA1_3 Y ny VSS VSS nm1p2_svt_lp L=6e-08 W=4.2e-07
MI1_MXNA1_4 Y ny VSS VSS nm1p2_svt_lp L=6e-08 W=4.2e-07
MI0_MXPB2_2 XI0_p1B__2 A1 VDD VDD pm1p2_svt_lp L=6e-08 W=5.4e-07
MI0_MXPB1_2 ny A0 XI0_p1B__2 VDD pm1p2_svt_lp L=6e-08 W=5.4e-07
MI0_MXPB1_3 ny A0 XI0_p1B__3 VDD pm1p2_svt_lp L=6e-08 W=5.4e-07
MI0_MXPB2_3 XI0_p1B__3 A1 VDD VDD pm1p2_svt_lp L=6e-08 W=5.4e-07
MI0_MXPB2_4 XI0_p1B__4 A1 VDD VDD pm1p2_svt_lp L=6e-08 W=5.4e-07
MI0_MXPB1_4 ny A0 XI0_p1B__4 VDD pm1p2_svt_lp L=6e-08 W=5.4e-07
MI0_MXPB1 ny A0 XI0_p1B VDD pm1p2_svt_lp L=6e-08 W=5.4e-07
MI0_MXPB2 XI0_p1B A1 VDD VDD pm1p2_svt_lp L=6e-08 W=5.4e-07
MI0_MXPA2_2 XI0_p1A__2 B1 VDD VDD pm1p2_svt_lp L=6e-08 W=5.4e-07
MI0_MXPA1_2 ny B0 XI0_p1A__2 VDD pm1p2_svt_lp L=6e-08 W=5.4e-07
MI0_MXPA1_3 ny B0 XI0_p1A__3 VDD pm1p2_svt_lp L=6e-08 W=5.4e-07
MI0_MXPA2_3 XI0_p1A__3 B1 VDD VDD pm1p2_svt_lp L=6e-08 W=5.4e-07
MI0_MXPA2_4 XI0_p1A__4 B1 VDD VDD pm1p2_svt_lp L=6e-08 W=5.4e-07
MI0_MXPA1_4 ny B0 XI0_p1A__4 VDD pm1p2_svt_lp L=6e-08 W=5.4e-07
MI0_MXPA1 ny B0 XI0_p1A VDD pm1p2_svt_lp L=6e-08 W=5.4e-07
MI0_MXPA2 XI0_p1A B1 VDD VDD pm1p2_svt_lp L=6e-08 W=5.4e-07
MI1_MXPA1 Y ny VDD VDD pm1p2_svt_lp L=6e-08 W=5.85e-07
MI1_MXPA1_2 Y ny VDD VDD pm1p2_svt_lp L=6e-08 W=5.85e-07
MI1_MXPA1_3 Y ny VDD VDD pm1p2_svt_lp L=6e-08 W=5.85e-07
MI1_MXPA1_4 Y ny VDD VDD pm1p2_svt_lp L=6e-08 W=5.85e-07
.ENDS

.SUBCKT OA22X6H9R Y VDD VSS A0 A1 B0 B1
MI0_MXNB2 XI0_n1 A1 VSS VSS nm1p2_svt_lp L=6e-08 W=4.45e-07
MI0_MXNB1 XI0_n1 A0 VSS VSS nm1p2_svt_lp L=6e-08 W=4.45e-07
MI0_MXNB1_2 XI0_n1 A0 VSS VSS nm1p2_svt_lp L=6e-08 W=4.45e-07
MI0_MXNB2_2 XI0_n1 A1 VSS VSS nm1p2_svt_lp L=6e-08 W=4.45e-07
MI0_MXNB2_3 XI0_n1 A1 VSS VSS nm1p2_svt_lp L=6e-08 W=4.45e-07
MI0_MXNB1_3 XI0_n1 A0 VSS VSS nm1p2_svt_lp L=6e-08 W=4.45e-07
MI0_MXNB1_4 XI0_n1 A0 VSS VSS nm1p2_svt_lp L=6e-08 W=4.45e-07
MI0_MXNB2_4 XI0_n1 A1 VSS VSS nm1p2_svt_lp L=6e-08 W=4.45e-07
MI0_MXNB2_5 XI0_n1 A1 VSS VSS nm1p2_svt_lp L=6e-08 W=4.45e-07
MI0_MXNB1_5 XI0_n1 A0 VSS VSS nm1p2_svt_lp L=6e-08 W=4.45e-07
MI0_MXNA2 ny B1 XI0_n1 VSS nm1p2_svt_lp L=6e-08 W=4.45e-07
MI0_MXNA1 ny B0 XI0_n1 VSS nm1p2_svt_lp L=6e-08 W=4.45e-07
MI0_MXNA1_2 ny B0 XI0_n1 VSS nm1p2_svt_lp L=6e-08 W=4.45e-07
MI0_MXNA2_2 ny B1 XI0_n1 VSS nm1p2_svt_lp L=6e-08 W=4.45e-07
MI0_MXNA2_3 ny B1 XI0_n1 VSS nm1p2_svt_lp L=6e-08 W=4.45e-07
MI0_MXNA1_3 ny B0 XI0_n1 VSS nm1p2_svt_lp L=6e-08 W=4.45e-07
MI0_MXNA1_4 ny B0 XI0_n1 VSS nm1p2_svt_lp L=6e-08 W=4.45e-07
MI0_MXNA2_4 ny B1 XI0_n1 VSS nm1p2_svt_lp L=6e-08 W=4.45e-07
MI0_MXNA2_5 ny B1 XI0_n1 VSS nm1p2_svt_lp L=6e-08 W=4.45e-07
MI0_MXNA1_5 ny B0 XI0_n1 VSS nm1p2_svt_lp L=6e-08 W=4.45e-07
MI1_MXNA1 Y ny VSS VSS nm1p2_svt_lp L=6e-08 W=4.2e-07
MI1_MXNA1_2 Y ny VSS VSS nm1p2_svt_lp L=6e-08 W=4.2e-07
MI1_MXNA1_3 Y ny VSS VSS nm1p2_svt_lp L=6e-08 W=4.2e-07
MI1_MXNA1_4 Y ny VSS VSS nm1p2_svt_lp L=6e-08 W=4.2e-07
MI1_MXNA1_5 Y ny VSS VSS nm1p2_svt_lp L=6e-08 W=4.2e-07
MI1_MXNA1_6 Y ny VSS VSS nm1p2_svt_lp L=6e-08 W=4.2e-07
MI0_MXPB2_2 XI0_p1B__2 A1 VDD VDD pm1p2_svt_lp L=6e-08 W=5.3e-07
MI0_MXPB1_2 ny A0 XI0_p1B__2 VDD pm1p2_svt_lp L=6e-08 W=5.3e-07
MI0_MXPB1_3 ny A0 XI0_p1B__3 VDD pm1p2_svt_lp L=6e-08 W=5.3e-07
MI0_MXPB2_3 XI0_p1B__3 A1 VDD VDD pm1p2_svt_lp L=6e-08 W=5.3e-07
MI0_MXPB2_4 XI0_p1B__4 A1 VDD VDD pm1p2_svt_lp L=6e-08 W=5.3e-07
MI0_MXPB1_4 ny A0 XI0_p1B__4 VDD pm1p2_svt_lp L=6e-08 W=5.3e-07
MI0_MXPB1_5 ny A0 XI0_p1B__5 VDD pm1p2_svt_lp L=6e-08 W=5.3e-07
MI0_MXPB2_5 XI0_p1B__5 A1 VDD VDD pm1p2_svt_lp L=6e-08 W=5.3e-07
MI0_MXPB2_6 XI0_p1B__6 A1 VDD VDD pm1p2_svt_lp L=6e-08 W=5.3e-07
MI0_MXPB1_6 ny A0 XI0_p1B__6 VDD pm1p2_svt_lp L=6e-08 W=5.3e-07
MI0_MXPB1 ny A0 XI0_p1B VDD pm1p2_svt_lp L=6e-08 W=5.3e-07
MI0_MXPB2 XI0_p1B A1 VDD VDD pm1p2_svt_lp L=6e-08 W=5.3e-07
MI0_MXPA2_2 XI0_p1A__2 B1 VDD VDD pm1p2_svt_lp L=6e-08 W=5.3e-07
MI0_MXPA1_2 ny B0 XI0_p1A__2 VDD pm1p2_svt_lp L=6e-08 W=5.3e-07
MI0_MXPA1_3 ny B0 XI0_p1A__3 VDD pm1p2_svt_lp L=6e-08 W=5.3e-07
MI0_MXPA2_3 XI0_p1A__3 B1 VDD VDD pm1p2_svt_lp L=6e-08 W=5.3e-07
MI0_MXPA2_4 XI0_p1A__4 B1 VDD VDD pm1p2_svt_lp L=6e-08 W=5.3e-07
MI0_MXPA1_4 ny B0 XI0_p1A__4 VDD pm1p2_svt_lp L=6e-08 W=5.3e-07
MI0_MXPA1_5 ny B0 XI0_p1A__5 VDD pm1p2_svt_lp L=6e-08 W=5.3e-07
MI0_MXPA2_5 XI0_p1A__5 B1 VDD VDD pm1p2_svt_lp L=6e-08 W=5.3e-07
MI0_MXPA2_6 XI0_p1A__6 B1 VDD VDD pm1p2_svt_lp L=6e-08 W=5.3e-07
MI0_MXPA1_6 ny B0 XI0_p1A__6 VDD pm1p2_svt_lp L=6e-08 W=5.3e-07
MI0_MXPA1 ny B0 XI0_p1A VDD pm1p2_svt_lp L=6e-08 W=5.3e-07
MI0_MXPA2 XI0_p1A B1 VDD VDD pm1p2_svt_lp L=6e-08 W=5.3e-07
MI1_MXPA1 Y ny VDD VDD pm1p2_svt_lp L=6e-08 W=5.85e-07
MI1_MXPA1_2 Y ny VDD VDD pm1p2_svt_lp L=6e-08 W=5.85e-07
MI1_MXPA1_3 Y ny VDD VDD pm1p2_svt_lp L=6e-08 W=5.85e-07
MI1_MXPA1_4 Y ny VDD VDD pm1p2_svt_lp L=6e-08 W=5.85e-07
MI1_MXPA1_5 Y ny VDD VDD pm1p2_svt_lp L=6e-08 W=5.85e-07
MI1_MXPA1_6 Y ny VDD VDD pm1p2_svt_lp L=6e-08 W=5.85e-07
.ENDS

.SUBCKT OA22X8H9R Y VDD VSS A0 A1 B0 B1
MI0_MXNB2 XI0_n1 A1 VSS VSS nm1p2_svt_lp L=6e-08 W=4.8e-07
MI0_MXNB1 XI0_n1 A0 VSS VSS nm1p2_svt_lp L=6e-08 W=4.8e-07
MI0_MXNB1_2 XI0_n1 A0 VSS VSS nm1p2_svt_lp L=6e-08 W=4.8e-07
MI0_MXNB2_2 XI0_n1 A1 VSS VSS nm1p2_svt_lp L=6e-08 W=4.8e-07
MI0_MXNB2_3 XI0_n1 A1 VSS VSS nm1p2_svt_lp L=6e-08 W=4.8e-07
MI0_MXNB1_3 XI0_n1 A0 VSS VSS nm1p2_svt_lp L=6e-08 W=4.8e-07
MI0_MXNB1_4 XI0_n1 A0 VSS VSS nm1p2_svt_lp L=6e-08 W=4.8e-07
MI0_MXNB2_4 XI0_n1 A1 VSS VSS nm1p2_svt_lp L=6e-08 W=4.8e-07
MI0_MXNB2_5 XI0_n1 A1 VSS VSS nm1p2_svt_lp L=6e-08 W=4.8e-07
MI0_MXNB1_5 XI0_n1 A0 VSS VSS nm1p2_svt_lp L=6e-08 W=4.8e-07
MI0_MXNB1_6 XI0_n1 A0 VSS VSS nm1p2_svt_lp L=6e-08 W=4.8e-07
MI0_MXNB2_6 XI0_n1 A1 VSS VSS nm1p2_svt_lp L=6e-08 W=4.8e-07
MI0_MXNA1 ny B0 XI0_n1 VSS nm1p2_svt_lp L=6e-08 W=4.8e-07
MI0_MXNA2 ny B1 XI0_n1 VSS nm1p2_svt_lp L=6e-08 W=4.8e-07
MI0_MXNA2_2 ny B1 XI0_n1 VSS nm1p2_svt_lp L=6e-08 W=4.8e-07
MI0_MXNA1_2 ny B0 XI0_n1 VSS nm1p2_svt_lp L=6e-08 W=4.8e-07
MI0_MXNA1_3 ny B0 XI0_n1 VSS nm1p2_svt_lp L=6e-08 W=4.8e-07
MI0_MXNA2_3 ny B1 XI0_n1 VSS nm1p2_svt_lp L=6e-08 W=4.8e-07
MI0_MXNA2_4 ny B1 XI0_n1 VSS nm1p2_svt_lp L=6e-08 W=4.8e-07
MI0_MXNA1_4 ny B0 XI0_n1 VSS nm1p2_svt_lp L=6e-08 W=4.8e-07
MI0_MXNA1_5 ny B0 XI0_n1 VSS nm1p2_svt_lp L=6e-08 W=4.8e-07
MI0_MXNA2_5 ny B1 XI0_n1 VSS nm1p2_svt_lp L=6e-08 W=4.8e-07
MI0_MXNA2_6 ny B1 XI0_n1 VSS nm1p2_svt_lp L=6e-08 W=4.8e-07
MI0_MXNA1_6 ny B0 XI0_n1 VSS nm1p2_svt_lp L=6e-08 W=4.8e-07
MI1_MXNA1 Y ny VSS VSS nm1p2_svt_lp L=6e-08 W=4.8e-07
MI1_MXNA1_2 Y ny VSS VSS nm1p2_svt_lp L=6e-08 W=4.8e-07
MI1_MXNA1_3 Y ny VSS VSS nm1p2_svt_lp L=6e-08 W=4.8e-07
MI1_MXNA1_4 Y ny VSS VSS nm1p2_svt_lp L=6e-08 W=4.8e-07
MI1_MXNA1_5 Y ny VSS VSS nm1p2_svt_lp L=6e-08 W=4.8e-07
MI1_MXNA1_6 Y ny VSS VSS nm1p2_svt_lp L=6e-08 W=4.8e-07
MI1_MXNA1_7 Y ny VSS VSS nm1p2_svt_lp L=6e-08 W=4.8e-07
MI0_MXPB2_2 XI0_p1B__2 A1 VDD VDD pm1p2_svt_lp L=6e-08 W=5.85e-07
MI0_MXPB1_2 ny A0 XI0_p1B__2 VDD pm1p2_svt_lp L=6e-08 W=5.85e-07
MI0_MXPB1_3 ny A0 XI0_p1B__3 VDD pm1p2_svt_lp L=6e-08 W=5.85e-07
MI0_MXPB2_3 XI0_p1B__3 A1 VDD VDD pm1p2_svt_lp L=6e-08 W=5.85e-07
MI0_MXPB2_4 XI0_p1B__4 A1 VDD VDD pm1p2_svt_lp L=6e-08 W=5.85e-07
MI0_MXPB1_4 ny A0 XI0_p1B__4 VDD pm1p2_svt_lp L=6e-08 W=5.85e-07
MI0_MXPB1_5 ny A0 XI0_p1B__5 VDD pm1p2_svt_lp L=6e-08 W=5.85e-07
MI0_MXPB2_5 XI0_p1B__5 A1 VDD VDD pm1p2_svt_lp L=6e-08 W=5.85e-07
MI0_MXPB2_6 XI0_p1B__6 A1 VDD VDD pm1p2_svt_lp L=6e-08 W=5.85e-07
MI0_MXPB1_6 ny A0 XI0_p1B__6 VDD pm1p2_svt_lp L=6e-08 W=5.85e-07
MI0_MXPB1_7 ny A0 XI0_p1B__7 VDD pm1p2_svt_lp L=6e-08 W=5.85e-07
MI0_MXPB2_7 XI0_p1B__7 A1 VDD VDD pm1p2_svt_lp L=6e-08 W=5.85e-07
MI0_MXPB2 XI0_p1B A1 VDD VDD pm1p2_svt_lp L=6e-08 W=5.85e-07
MI0_MXPB1 ny A0 XI0_p1B VDD pm1p2_svt_lp L=6e-08 W=5.85e-07
MI0_MXPA1_2 ny B0 XI0_p1A__2 VDD pm1p2_svt_lp L=6e-08 W=5.85e-07
MI0_MXPA2_2 XI0_p1A__2 B1 VDD VDD pm1p2_svt_lp L=6e-08 W=5.85e-07
MI0_MXPA2_3 XI0_p1A__3 B1 VDD VDD pm1p2_svt_lp L=6e-08 W=5.85e-07
MI0_MXPA1_3 ny B0 XI0_p1A__3 VDD pm1p2_svt_lp L=6e-08 W=5.85e-07
MI0_MXPA1_4 ny B0 XI0_p1A__4 VDD pm1p2_svt_lp L=6e-08 W=5.85e-07
MI0_MXPA2_4 XI0_p1A__4 B1 VDD VDD pm1p2_svt_lp L=6e-08 W=5.85e-07
MI0_MXPA2_5 XI0_p1A__5 B1 VDD VDD pm1p2_svt_lp L=6e-08 W=5.85e-07
MI0_MXPA1_5 ny B0 XI0_p1A__5 VDD pm1p2_svt_lp L=6e-08 W=5.85e-07
MI0_MXPA1_6 ny B0 XI0_p1A__6 VDD pm1p2_svt_lp L=6e-08 W=5.85e-07
MI0_MXPA2_6 XI0_p1A__6 B1 VDD VDD pm1p2_svt_lp L=6e-08 W=5.85e-07
MI0_MXPA2_7 XI0_p1A__7 B1 VDD VDD pm1p2_svt_lp L=6e-08 W=5.85e-07
MI0_MXPA1_7 ny B0 XI0_p1A__7 VDD pm1p2_svt_lp L=6e-08 W=5.85e-07
MI0_MXPA1 ny B0 XI0_p1A VDD pm1p2_svt_lp L=6e-08 W=5.85e-07
MI0_MXPA2 XI0_p1A B1 VDD VDD pm1p2_svt_lp L=6e-08 W=5.85e-07
MI1_MXPA1 Y ny VDD VDD pm1p2_svt_lp L=6e-08 W=5.85e-07
MI1_MXPA1_2 Y ny VDD VDD pm1p2_svt_lp L=6e-08 W=5.85e-07
MI1_MXPA1_3 Y ny VDD VDD pm1p2_svt_lp L=6e-08 W=5.85e-07
MI1_MXPA1_4 Y ny VDD VDD pm1p2_svt_lp L=6e-08 W=5.85e-07
MI1_MXPA1_5 Y ny VDD VDD pm1p2_svt_lp L=6e-08 W=5.85e-07
MI1_MXPA1_6 Y ny VDD VDD pm1p2_svt_lp L=6e-08 W=5.85e-07
MI1_MXPA1_7 Y ny VDD VDD pm1p2_svt_lp L=6e-08 W=5.85e-07
MI1_MXPA1_8 Y ny VDD VDD pm1p2_svt_lp L=6e-08 W=5.85e-07
.ENDS

.SUBCKT OAI22X0P5H9R Y VDD VSS A0 A1 B0 B1
MI0_MXNB2 XI0_n1 A1 VSS VSS nm1p2_svt_lp L=6e-08 W=2.1e-07
MI0_MXNB1 XI0_n1 A0 VSS VSS nm1p2_svt_lp L=6e-08 W=2.1e-07
MI0_MXNA1 Y B0 XI0_n1 VSS nm1p2_svt_lp L=6e-08 W=2.1e-07
MI0_MXNA2 Y B1 XI0_n1 VSS nm1p2_svt_lp L=6e-08 W=2.1e-07
MI0_MXPB2 XI0_p1B A1 VDD VDD pm1p2_svt_lp L=6e-08 W=2.95e-07
MI0_MXPB1 Y A0 XI0_p1B VDD pm1p2_svt_lp L=6e-08 W=2.95e-07
MI0_MXPA1 Y B0 XI0_p1A VDD pm1p2_svt_lp L=6e-08 W=2.95e-07
MI0_MXPA2 XI0_p1A B1 VDD VDD pm1p2_svt_lp L=6e-08 W=2.95e-07
.ENDS

.SUBCKT OAI22X0P7H9R Y VDD VSS A0 A1 B0 B1
MI0_MXNB2 XI0_n1 A1 VSS VSS nm1p2_svt_lp L=6e-08 W=2.9e-07
MI0_MXNB1 XI0_n1 A0 VSS VSS nm1p2_svt_lp L=6e-08 W=2.9e-07
MI0_MXNA1 Y B0 XI0_n1 VSS nm1p2_svt_lp L=6e-08 W=2.9e-07
MI0_MXNA2 Y B1 XI0_n1 VSS nm1p2_svt_lp L=6e-08 W=2.9e-07
MI0_MXPB2 XI0_p1B A1 VDD VDD pm1p2_svt_lp L=6e-08 W=4.15e-07
MI0_MXPB1 Y A0 XI0_p1B VDD pm1p2_svt_lp L=6e-08 W=4.15e-07
MI0_MXPA1 Y B0 XI0_p1A VDD pm1p2_svt_lp L=6e-08 W=4.15e-07
MI0_MXPA2 XI0_p1A B1 VDD VDD pm1p2_svt_lp L=6e-08 W=4.15e-07
.ENDS

.SUBCKT OAI22X1H9R Y VDD VSS A0 A1 B0 B1
MI0_MXNB2 XI0_n1 A1 VSS VSS nm1p2_svt_lp L=6e-08 W=4.1e-07
MI0_MXNB1 XI0_n1 A0 VSS VSS nm1p2_svt_lp L=6e-08 W=4.1e-07
MI0_MXNA1 Y B0 XI0_n1 VSS nm1p2_svt_lp L=6e-08 W=4.1e-07
MI0_MXNA2 Y B1 XI0_n1 VSS nm1p2_svt_lp L=6e-08 W=4.1e-07
MI0_MXPB2 XI0_p1B A1 VDD VDD pm1p2_svt_lp L=6e-08 W=5.85e-07
MI0_MXPB1 Y A0 XI0_p1B VDD pm1p2_svt_lp L=6e-08 W=5.85e-07
MI0_MXPA1 Y B0 XI0_p1A VDD pm1p2_svt_lp L=6e-08 W=5.85e-07
MI0_MXPA2 XI0_p1A B1 VDD VDD pm1p2_svt_lp L=6e-08 W=5.85e-07
.ENDS

.SUBCKT OAI22X1P4H9R Y VDD VSS A0 A1 B0 B1
MI0_MXNB2 XI0_n1 A1 VSS VSS nm1p2_svt_lp L=6e-08 W=2.9e-07
MI0_MXNB1 XI0_n1 A0 VSS VSS nm1p2_svt_lp L=6e-08 W=2.9e-07
MI0_MXNB1_2 XI0_n1 A0 VSS VSS nm1p2_svt_lp L=6e-08 W=2.9e-07
MI0_MXNB2_2 XI0_n1 A1 VSS VSS nm1p2_svt_lp L=6e-08 W=2.9e-07
MI0_MXNA2 Y B1 XI0_n1 VSS nm1p2_svt_lp L=6e-08 W=5.8e-07
MI0_MXNA1 Y B0 XI0_n1 VSS nm1p2_svt_lp L=6e-08 W=5.8e-07
MI0_MXPB2_2 XI0_p1B__2 A1 VDD VDD pm1p2_svt_lp L=6e-08 W=4.15e-07
MI0_MXPB1_2 Y A0 XI0_p1B__2 VDD pm1p2_svt_lp L=6e-08 W=4.15e-07
MI0_MXPB1 Y A0 XI0_p1B VDD pm1p2_svt_lp L=6e-08 W=4.15e-07
MI0_MXPB2 XI0_p1B A1 VDD VDD pm1p2_svt_lp L=6e-08 W=4.15e-07
MI0_MXPA2_2 XI0_p1A__2 B1 VDD VDD pm1p2_svt_lp L=6e-08 W=4.15e-07
MI0_MXPA1_2 Y B0 XI0_p1A__2 VDD pm1p2_svt_lp L=6e-08 W=4.15e-07
MI0_MXPA1 Y B0 XI0_p1A VDD pm1p2_svt_lp L=6e-08 W=4.15e-07
MI0_MXPA2 XI0_p1A B1 VDD VDD pm1p2_svt_lp L=6e-08 W=4.15e-07
.ENDS

.SUBCKT OAI22X2H9R Y VDD VSS A0 A1 B0 B1
MI0_MXNB2 XI0_n1 A1 VSS VSS nm1p2_svt_lp L=6e-08 W=4.1e-07
MI0_MXNB1 XI0_n1 A0 VSS VSS nm1p2_svt_lp L=6e-08 W=4.1e-07
MI0_MXNB1_2 XI0_n1 A0 VSS VSS nm1p2_svt_lp L=6e-08 W=4.1e-07
MI0_MXNB2_2 XI0_n1 A1 VSS VSS nm1p2_svt_lp L=6e-08 W=4.1e-07
MI0_MXNA2 Y B1 XI0_n1 VSS nm1p2_svt_lp L=6e-08 W=4.1e-07
MI0_MXNA1 Y B0 XI0_n1 VSS nm1p2_svt_lp L=6e-08 W=4.1e-07
MI0_MXNA1_2 Y B0 XI0_n1 VSS nm1p2_svt_lp L=6e-08 W=4.1e-07
MI0_MXNA2_2 Y B1 XI0_n1 VSS nm1p2_svt_lp L=6e-08 W=4.1e-07
MI0_MXPB2_2 XI0_p1B__2 A1 VDD VDD pm1p2_svt_lp L=6e-08 W=5.85e-07
MI0_MXPB1_2 Y A0 XI0_p1B__2 VDD pm1p2_svt_lp L=6e-08 W=5.85e-07
MI0_MXPB1 Y A0 XI0_p1B VDD pm1p2_svt_lp L=6e-08 W=5.85e-07
MI0_MXPB2 XI0_p1B A1 VDD VDD pm1p2_svt_lp L=6e-08 W=5.85e-07
MI0_MXPA2_2 XI0_p1A__2 B1 VDD VDD pm1p2_svt_lp L=6e-08 W=5.85e-07
MI0_MXPA1_2 Y B0 XI0_p1A__2 VDD pm1p2_svt_lp L=6e-08 W=5.85e-07
MI0_MXPA1 Y B0 XI0_p1A VDD pm1p2_svt_lp L=6e-08 W=5.85e-07
MI0_MXPA2 XI0_p1A B1 VDD VDD pm1p2_svt_lp L=6e-08 W=5.85e-07
.ENDS

.SUBCKT OAI22X3H9R Y VDD VSS A0 A1 B0 B1
MI0_MXNB2 XI0_n1 A1 VSS VSS nm1p2_svt_lp L=6e-08 W=4.1e-07
MI0_MXNB2_2 XI0_n1 A1 VSS VSS nm1p2_svt_lp L=6e-08 W=4.1e-07
MI0_MXNB2_3 XI0_n1 A1 VSS VSS nm1p2_svt_lp L=6e-08 W=4.1e-07
MI0_MXNB1 XI0_n1 A0 VSS VSS nm1p2_svt_lp L=6e-08 W=4.1e-07
MI0_MXNB1_2 XI0_n1 A0 VSS VSS nm1p2_svt_lp L=6e-08 W=4.1e-07
MI0_MXNB1_3 XI0_n1 A0 VSS VSS nm1p2_svt_lp L=6e-08 W=4.1e-07
MI0_MXNA1 Y B0 XI0_n1 VSS nm1p2_svt_lp L=6e-08 W=4.1e-07
MI0_MXNA1_2 Y B0 XI0_n1 VSS nm1p2_svt_lp L=6e-08 W=4.1e-07
MI0_MXNA1_3 Y B0 XI0_n1 VSS nm1p2_svt_lp L=6e-08 W=4.1e-07
MI0_MXNA2 Y B1 XI0_n1 VSS nm1p2_svt_lp L=6e-08 W=4.1e-07
MI0_MXNA2_2 Y B1 XI0_n1 VSS nm1p2_svt_lp L=6e-08 W=4.1e-07
MI0_MXNA2_3 Y B1 XI0_n1 VSS nm1p2_svt_lp L=6e-08 W=4.1e-07
MI0_MXPB2 XI0_p1B A1 VDD VDD pm1p2_svt_lp L=6e-08 W=5.85e-07
MI0_MXPB2_2 XI0_p1B A1 VDD VDD pm1p2_svt_lp L=6e-08 W=5.85e-07
MI0_MXPB2_3 XI0_p1B A1 VDD VDD pm1p2_svt_lp L=6e-08 W=5.85e-07
MI0_MXPB1 Y A0 XI0_p1B VDD pm1p2_svt_lp L=6e-08 W=5.85e-07
MI0_MXPB1_2 Y A0 XI0_p1B VDD pm1p2_svt_lp L=6e-08 W=5.85e-07
MI0_MXPB1_3 Y A0 XI0_p1B VDD pm1p2_svt_lp L=6e-08 W=5.85e-07
MI0_MXPA1 Y B0 XI0_p1A VDD pm1p2_svt_lp L=6e-08 W=5.85e-07
MI0_MXPA1_2 Y B0 XI0_p1A VDD pm1p2_svt_lp L=6e-08 W=5.85e-07
MI0_MXPA1_3 Y B0 XI0_p1A VDD pm1p2_svt_lp L=6e-08 W=5.85e-07
MI0_MXPA2 XI0_p1A B1 VDD VDD pm1p2_svt_lp L=6e-08 W=5.85e-07
MI0_MXPA2_2 XI0_p1A B1 VDD VDD pm1p2_svt_lp L=6e-08 W=5.85e-07
MI0_MXPA2_3 XI0_p1A B1 VDD VDD pm1p2_svt_lp L=6e-08 W=5.85e-07
.ENDS

.SUBCKT OAI22X4H9R Y VDD VSS A0 A1 B0 B1
MI0_MXNB2 XI0_n1 A1 VSS VSS nm1p2_svt_lp L=6e-08 W=4.1e-07
MI0_MXNB1 XI0_n1 A0 VSS VSS nm1p2_svt_lp L=6e-08 W=4.1e-07
MI0_MXNB1_2 XI0_n1 A0 VSS VSS nm1p2_svt_lp L=6e-08 W=4.1e-07
MI0_MXNB2_2 XI0_n1 A1 VSS VSS nm1p2_svt_lp L=6e-08 W=4.1e-07
MI0_MXNB2_3 XI0_n1 A1 VSS VSS nm1p2_svt_lp L=6e-08 W=4.1e-07
MI0_MXNB1_3 XI0_n1 A0 VSS VSS nm1p2_svt_lp L=6e-08 W=4.1e-07
MI0_MXNB1_4 XI0_n1 A0 VSS VSS nm1p2_svt_lp L=6e-08 W=4.1e-07
MI0_MXNB2_4 XI0_n1 A1 VSS VSS nm1p2_svt_lp L=6e-08 W=4.1e-07
MI0_MXNA2 Y B1 XI0_n1 VSS nm1p2_svt_lp L=6e-08 W=4.1e-07
MI0_MXNA1 Y B0 XI0_n1 VSS nm1p2_svt_lp L=6e-08 W=4.1e-07
MI0_MXNA1_2 Y B0 XI0_n1 VSS nm1p2_svt_lp L=6e-08 W=4.1e-07
MI0_MXNA2_2 Y B1 XI0_n1 VSS nm1p2_svt_lp L=6e-08 W=4.1e-07
MI0_MXNA2_3 Y B1 XI0_n1 VSS nm1p2_svt_lp L=6e-08 W=4.1e-07
MI0_MXNA1_3 Y B0 XI0_n1 VSS nm1p2_svt_lp L=6e-08 W=4.1e-07
MI0_MXNA1_4 Y B0 XI0_n1 VSS nm1p2_svt_lp L=6e-08 W=4.1e-07
MI0_MXNA2_4 Y B1 XI0_n1 VSS nm1p2_svt_lp L=6e-08 W=4.1e-07
MI0_MXPB2_2 XI0_p1B__2 A1 VDD VDD pm1p2_svt_lp L=6e-08 W=5.85e-07
MI0_MXPB1_2 Y A0 XI0_p1B__2 VDD pm1p2_svt_lp L=6e-08 W=5.85e-07
MI0_MXPB1_3 Y A0 XI0_p1B__3 VDD pm1p2_svt_lp L=6e-08 W=5.85e-07
MI0_MXPB2_3 XI0_p1B__3 A1 VDD VDD pm1p2_svt_lp L=6e-08 W=5.85e-07
MI0_MXPB2_4 XI0_p1B__4 A1 VDD VDD pm1p2_svt_lp L=6e-08 W=5.85e-07
MI0_MXPB1_4 Y A0 XI0_p1B__4 VDD pm1p2_svt_lp L=6e-08 W=5.85e-07
MI0_MXPB1 Y A0 XI0_p1B VDD pm1p2_svt_lp L=6e-08 W=5.85e-07
MI0_MXPB2 XI0_p1B A1 VDD VDD pm1p2_svt_lp L=6e-08 W=5.85e-07
MI0_MXPA2_2 XI0_p1A__2 B1 VDD VDD pm1p2_svt_lp L=6e-08 W=5.85e-07
MI0_MXPA1_2 Y B0 XI0_p1A__2 VDD pm1p2_svt_lp L=6e-08 W=5.85e-07
MI0_MXPA1_3 Y B0 XI0_p1A__3 VDD pm1p2_svt_lp L=6e-08 W=5.85e-07
MI0_MXPA2_3 XI0_p1A__3 B1 VDD VDD pm1p2_svt_lp L=6e-08 W=5.85e-07
MI0_MXPA2_4 XI0_p1A__4 B1 VDD VDD pm1p2_svt_lp L=6e-08 W=5.85e-07
MI0_MXPA1_4 Y B0 XI0_p1A__4 VDD pm1p2_svt_lp L=6e-08 W=5.85e-07
MI0_MXPA1 Y B0 XI0_p1A VDD pm1p2_svt_lp L=6e-08 W=5.85e-07
MI0_MXPA2 XI0_p1A B1 VDD VDD pm1p2_svt_lp L=6e-08 W=5.85e-07
.ENDS

.SUBCKT OAI22X6H9R Y VDD VSS A0 A1 B0 B1
MI0_MXNB2 XI0_n1 A1 VSS VSS nm1p2_svt_lp L=6e-08 W=4.9e-07
MI0_MXNB1 XI0_n1 A0 VSS VSS nm1p2_svt_lp L=6e-08 W=4.9e-07
MI0_MXNB1_2 XI0_n1 A0 VSS VSS nm1p2_svt_lp L=6e-08 W=4.9e-07
MI0_MXNB2_2 XI0_n1 A1 VSS VSS nm1p2_svt_lp L=6e-08 W=4.9e-07
MI0_MXNB2_3 XI0_n1 A1 VSS VSS nm1p2_svt_lp L=6e-08 W=4.9e-07
MI0_MXNB1_3 XI0_n1 A0 VSS VSS nm1p2_svt_lp L=6e-08 W=4.9e-07
MI0_MXNB1_4 XI0_n1 A0 VSS VSS nm1p2_svt_lp L=6e-08 W=4.9e-07
MI0_MXNB2_4 XI0_n1 A1 VSS VSS nm1p2_svt_lp L=6e-08 W=4.9e-07
MI0_MXNB2_5 XI0_n1 A1 VSS VSS nm1p2_svt_lp L=6e-08 W=4.9e-07
MI0_MXNB1_5 XI0_n1 A0 VSS VSS nm1p2_svt_lp L=6e-08 W=4.9e-07
MI0_MXNA2 Y B1 XI0_n1 VSS nm1p2_svt_lp L=6e-08 W=4.9e-07
MI0_MXNA1 Y B0 XI0_n1 VSS nm1p2_svt_lp L=6e-08 W=4.9e-07
MI0_MXNA1_2 Y B0 XI0_n1 VSS nm1p2_svt_lp L=6e-08 W=4.9e-07
MI0_MXNA2_2 Y B1 XI0_n1 VSS nm1p2_svt_lp L=6e-08 W=4.9e-07
MI0_MXNA2_3 Y B1 XI0_n1 VSS nm1p2_svt_lp L=6e-08 W=4.9e-07
MI0_MXNA1_3 Y B0 XI0_n1 VSS nm1p2_svt_lp L=6e-08 W=4.9e-07
MI0_MXNA1_4 Y B0 XI0_n1 VSS nm1p2_svt_lp L=6e-08 W=4.9e-07
MI0_MXNA2_4 Y B1 XI0_n1 VSS nm1p2_svt_lp L=6e-08 W=4.9e-07
MI0_MXNA2_5 Y B1 XI0_n1 VSS nm1p2_svt_lp L=6e-08 W=4.9e-07
MI0_MXNA1_5 Y B0 XI0_n1 VSS nm1p2_svt_lp L=6e-08 W=4.9e-07
MI0_MXPB2_2 XI0_p1B__2 A1 VDD VDD pm1p2_svt_lp L=6e-08 W=5.85e-07
MI0_MXPB1_2 Y A0 XI0_p1B__2 VDD pm1p2_svt_lp L=6e-08 W=5.85e-07
MI0_MXPB1_3 Y A0 XI0_p1B__3 VDD pm1p2_svt_lp L=6e-08 W=5.85e-07
MI0_MXPB2_3 XI0_p1B__3 A1 VDD VDD pm1p2_svt_lp L=6e-08 W=5.85e-07
MI0_MXPB2_4 XI0_p1B__4 A1 VDD VDD pm1p2_svt_lp L=6e-08 W=5.85e-07
MI0_MXPB1_4 Y A0 XI0_p1B__4 VDD pm1p2_svt_lp L=6e-08 W=5.85e-07
MI0_MXPB1_5 Y A0 XI0_p1B__5 VDD pm1p2_svt_lp L=6e-08 W=5.85e-07
MI0_MXPB2_5 XI0_p1B__5 A1 VDD VDD pm1p2_svt_lp L=6e-08 W=5.85e-07
MI0_MXPB2_6 XI0_p1B__6 A1 VDD VDD pm1p2_svt_lp L=6e-08 W=5.85e-07
MI0_MXPB1_6 Y A0 XI0_p1B__6 VDD pm1p2_svt_lp L=6e-08 W=5.85e-07
MI0_MXPB1 Y A0 XI0_p1B VDD pm1p2_svt_lp L=6e-08 W=5.85e-07
MI0_MXPB2 XI0_p1B A1 VDD VDD pm1p2_svt_lp L=6e-08 W=5.85e-07
MI0_MXPA2_2 XI0_p1A__2 B1 VDD VDD pm1p2_svt_lp L=6e-08 W=5.85e-07
MI0_MXPA1_2 Y B0 XI0_p1A__2 VDD pm1p2_svt_lp L=6e-08 W=5.85e-07
MI0_MXPA1_3 Y B0 XI0_p1A__3 VDD pm1p2_svt_lp L=6e-08 W=5.85e-07
MI0_MXPA2_3 XI0_p1A__3 B1 VDD VDD pm1p2_svt_lp L=6e-08 W=5.85e-07
MI0_MXPA2_4 XI0_p1A__4 B1 VDD VDD pm1p2_svt_lp L=6e-08 W=5.85e-07
MI0_MXPA1_4 Y B0 XI0_p1A__4 VDD pm1p2_svt_lp L=6e-08 W=5.85e-07
MI0_MXPA1_5 Y B0 XI0_p1A__5 VDD pm1p2_svt_lp L=6e-08 W=5.85e-07
MI0_MXPA2_5 XI0_p1A__5 B1 VDD VDD pm1p2_svt_lp L=6e-08 W=5.85e-07
MI0_MXPA2_6 XI0_p1A__6 B1 VDD VDD pm1p2_svt_lp L=6e-08 W=5.85e-07
MI0_MXPA1_6 Y B0 XI0_p1A__6 VDD pm1p2_svt_lp L=6e-08 W=5.85e-07
MI0_MXPA1 Y B0 XI0_p1A VDD pm1p2_svt_lp L=6e-08 W=5.85e-07
MI0_MXPA2 XI0_p1A B1 VDD VDD pm1p2_svt_lp L=6e-08 W=5.85e-07
.ENDS

.SUBCKT OAI22X8H9R Y VDD VSS A0 A1 B0 B1
MI0_MXNB2 XI0_n1 A1 VSS VSS nm1p2_svt_lp L=6e-08 W=4.7e-07
MI0_MXNB1 XI0_n1 A0 VSS VSS nm1p2_svt_lp L=6e-08 W=4.7e-07
MI0_MXNB1_2 XI0_n1 A0 VSS VSS nm1p2_svt_lp L=6e-08 W=4.7e-07
MI0_MXNB2_2 XI0_n1 A1 VSS VSS nm1p2_svt_lp L=6e-08 W=4.7e-07
MI0_MXNB2_3 XI0_n1 A1 VSS VSS nm1p2_svt_lp L=6e-08 W=4.7e-07
MI0_MXNB1_3 XI0_n1 A0 VSS VSS nm1p2_svt_lp L=6e-08 W=4.7e-07
MI0_MXNB1_4 XI0_n1 A0 VSS VSS nm1p2_svt_lp L=6e-08 W=4.7e-07
MI0_MXNB2_4 XI0_n1 A1 VSS VSS nm1p2_svt_lp L=6e-08 W=4.7e-07
MI0_MXNB2_5 XI0_n1 A1 VSS VSS nm1p2_svt_lp L=6e-08 W=4.7e-07
MI0_MXNB1_5 XI0_n1 A0 VSS VSS nm1p2_svt_lp L=6e-08 W=4.7e-07
MI0_MXNB1_6 XI0_n1 A0 VSS VSS nm1p2_svt_lp L=6e-08 W=4.7e-07
MI0_MXNB2_6 XI0_n1 A1 VSS VSS nm1p2_svt_lp L=6e-08 W=4.7e-07
MI0_MXNB2_7 XI0_n1 A1 VSS VSS nm1p2_svt_lp L=6e-08 W=4.7e-07
MI0_MXNB1_7 XI0_n1 A0 VSS VSS nm1p2_svt_lp L=6e-08 W=4.7e-07
MI0_MXNA2 Y B1 XI0_n1 VSS nm1p2_svt_lp L=6e-08 W=4.7e-07
MI0_MXNA1 Y B0 XI0_n1 VSS nm1p2_svt_lp L=6e-08 W=4.7e-07
MI0_MXNA1_2 Y B0 XI0_n1 VSS nm1p2_svt_lp L=6e-08 W=4.7e-07
MI0_MXNA2_2 Y B1 XI0_n1 VSS nm1p2_svt_lp L=6e-08 W=4.7e-07
MI0_MXNA2_3 Y B1 XI0_n1 VSS nm1p2_svt_lp L=6e-08 W=4.7e-07
MI0_MXNA1_3 Y B0 XI0_n1 VSS nm1p2_svt_lp L=6e-08 W=4.7e-07
MI0_MXNA1_4 Y B0 XI0_n1 VSS nm1p2_svt_lp L=6e-08 W=4.7e-07
MI0_MXNA2_4 Y B1 XI0_n1 VSS nm1p2_svt_lp L=6e-08 W=4.7e-07
MI0_MXNA2_5 Y B1 XI0_n1 VSS nm1p2_svt_lp L=6e-08 W=4.7e-07
MI0_MXNA1_5 Y B0 XI0_n1 VSS nm1p2_svt_lp L=6e-08 W=4.7e-07
MI0_MXNA1_6 Y B0 XI0_n1 VSS nm1p2_svt_lp L=6e-08 W=4.7e-07
MI0_MXNA2_6 Y B1 XI0_n1 VSS nm1p2_svt_lp L=6e-08 W=4.7e-07
MI0_MXNA2_7 Y B1 XI0_n1 VSS nm1p2_svt_lp L=6e-08 W=4.7e-07
MI0_MXNA1_7 Y B0 XI0_n1 VSS nm1p2_svt_lp L=6e-08 W=4.7e-07
MI0_MXPB2_2 XI0_p1B__2 A1 VDD VDD pm1p2_svt_lp L=6e-08 W=5.85e-07
MI0_MXPB1_2 Y A0 XI0_p1B__2 VDD pm1p2_svt_lp L=6e-08 W=5.85e-07
MI0_MXPB1_3 Y A0 XI0_p1B__3 VDD pm1p2_svt_lp L=6e-08 W=5.85e-07
MI0_MXPB2_3 XI0_p1B__3 A1 VDD VDD pm1p2_svt_lp L=6e-08 W=5.85e-07
MI0_MXPB2_4 XI0_p1B__4 A1 VDD VDD pm1p2_svt_lp L=6e-08 W=5.85e-07
MI0_MXPB1_4 Y A0 XI0_p1B__4 VDD pm1p2_svt_lp L=6e-08 W=5.85e-07
MI0_MXPB1_5 Y A0 XI0_p1B__5 VDD pm1p2_svt_lp L=6e-08 W=5.85e-07
MI0_MXPB2_5 XI0_p1B__5 A1 VDD VDD pm1p2_svt_lp L=6e-08 W=5.85e-07
MI0_MXPB2_6 XI0_p1B__6 A1 VDD VDD pm1p2_svt_lp L=6e-08 W=5.85e-07
MI0_MXPB1_6 Y A0 XI0_p1B__6 VDD pm1p2_svt_lp L=6e-08 W=5.85e-07
MI0_MXPB1_7 Y A0 XI0_p1B__7 VDD pm1p2_svt_lp L=6e-08 W=5.85e-07
MI0_MXPB2_7 XI0_p1B__7 A1 VDD VDD pm1p2_svt_lp L=6e-08 W=5.85e-07
MI0_MXPB2_8 XI0_p1B__8 A1 VDD VDD pm1p2_svt_lp L=6e-08 W=5.85e-07
MI0_MXPB1_8 Y A0 XI0_p1B__8 VDD pm1p2_svt_lp L=6e-08 W=5.85e-07
MI0_MXPB1 Y A0 XI0_p1B VDD pm1p2_svt_lp L=6e-08 W=5.85e-07
MI0_MXPB2 XI0_p1B A1 VDD VDD pm1p2_svt_lp L=6e-08 W=5.85e-07
MI0_MXPA2_2 XI0_p1A__2 B1 VDD VDD pm1p2_svt_lp L=6e-08 W=5.85e-07
MI0_MXPA1_2 Y B0 XI0_p1A__2 VDD pm1p2_svt_lp L=6e-08 W=5.85e-07
MI0_MXPA1_3 Y B0 XI0_p1A__3 VDD pm1p2_svt_lp L=6e-08 W=5.85e-07
MI0_MXPA2_3 XI0_p1A__3 B1 VDD VDD pm1p2_svt_lp L=6e-08 W=5.85e-07
MI0_MXPA2_4 XI0_p1A__4 B1 VDD VDD pm1p2_svt_lp L=6e-08 W=5.85e-07
MI0_MXPA1_4 Y B0 XI0_p1A__4 VDD pm1p2_svt_lp L=6e-08 W=5.85e-07
MI0_MXPA1_5 Y B0 XI0_p1A__5 VDD pm1p2_svt_lp L=6e-08 W=5.85e-07
MI0_MXPA2_5 XI0_p1A__5 B1 VDD VDD pm1p2_svt_lp L=6e-08 W=5.85e-07
MI0_MXPA2_6 XI0_p1A__6 B1 VDD VDD pm1p2_svt_lp L=6e-08 W=5.85e-07
MI0_MXPA1_6 Y B0 XI0_p1A__6 VDD pm1p2_svt_lp L=6e-08 W=5.85e-07
MI0_MXPA1_7 Y B0 XI0_p1A__7 VDD pm1p2_svt_lp L=6e-08 W=5.85e-07
MI0_MXPA2_7 XI0_p1A__7 B1 VDD VDD pm1p2_svt_lp L=6e-08 W=5.85e-07
MI0_MXPA2_8 XI0_p1A__8 B1 VDD VDD pm1p2_svt_lp L=6e-08 W=5.85e-07
MI0_MXPA1_8 Y B0 XI0_p1A__8 VDD pm1p2_svt_lp L=6e-08 W=5.85e-07
MI0_MXPA1 Y B0 XI0_p1A VDD pm1p2_svt_lp L=6e-08 W=5.85e-07
MI0_MXPA2 XI0_p1A B1 VDD VDD pm1p2_svt_lp L=6e-08 W=5.85e-07
.ENDS

.SUBCKT OA211X0P5H9R Y VDD VSS A0 A1 B0 C0
MI0_MXNC2 XI0_n1 A1 VSS VSS nm1p2_svt_lp L=6e-08 W=3.7e-07
MI0_MXNC1 XI0_n1 A0 VSS VSS nm1p2_svt_lp L=6e-08 W=3.7e-07
MI0_MXNB1 XI0_n2 B0 XI0_n1 VSS nm1p2_svt_lp L=6e-08 W=3.7e-07
MI0_MXNA1 ny C0 XI0_n2 VSS nm1p2_svt_lp L=6e-08 W=3.7e-07
MI1_MXNA1 Y ny VSS VSS nm1p2_svt_lp L=6e-08 W=2.1e-07
MI0_MXPC2 XI0_p1 A1 VDD VDD pm1p2_svt_lp L=6e-08 W=4.05e-07
MI0_MXPC1 ny A0 XI0_p1 VDD pm1p2_svt_lp L=6e-08 W=4.05e-07
MI0_MXPB1 ny B0 VDD VDD pm1p2_svt_lp L=6e-08 W=2.3e-07
MI0_MXPA1 ny C0 VDD VDD pm1p2_svt_lp L=6e-08 W=2.3e-07
MI1_MXPA1 Y ny VDD VDD pm1p2_svt_lp L=6e-08 W=2.95e-07
.ENDS

.SUBCKT OA211X0P7H9R Y VDD VSS A0 A1 B0 C0
MI0_MXNC2 XI0_n1 A1 VSS VSS nm1p2_svt_lp L=6e-08 W=4.4e-07
MI0_MXNC1 XI0_n1 A0 VSS VSS nm1p2_svt_lp L=6e-08 W=4.4e-07
MI0_MXNB1 XI0_n2 B0 XI0_n1 VSS nm1p2_svt_lp L=6e-08 W=4.4e-07
MI0_MXNA1 ny C0 XI0_n2 VSS nm1p2_svt_lp L=6e-08 W=4.4e-07
MI1_MXNA1 Y ny VSS VSS nm1p2_svt_lp L=6e-08 W=2.95e-07
MI0_MXPC2 XI0_p1 A1 VDD VDD pm1p2_svt_lp L=6e-08 W=4.8e-07
MI0_MXPC1 ny A0 XI0_p1 VDD pm1p2_svt_lp L=6e-08 W=4.8e-07
MI0_MXPB1 ny B0 VDD VDD pm1p2_svt_lp L=6e-08 W=2.7e-07
MI0_MXPA1 ny C0 VDD VDD pm1p2_svt_lp L=6e-08 W=2.7e-07
MI1_MXPA1 Y ny VDD VDD pm1p2_svt_lp L=6e-08 W=4.15e-07
.ENDS

.SUBCKT OA211X1H9R Y VDD VSS A0 A1 B0 C0
MI0_MXNC2 XI0_n1 A1 VSS VSS nm1p2_svt_lp L=6e-08 W=3.15e-07
MI0_MXNC2_2 XI0_n1 A1 VSS VSS nm1p2_svt_lp L=6e-08 W=3.15e-07
MI0_MXNC1 XI0_n1 A0 VSS VSS nm1p2_svt_lp L=6e-08 W=6.3e-07
MI0_MXNB1 XI0_n2 B0 XI0_n1 VSS nm1p2_svt_lp L=6e-08 W=6.3e-07
MI0_MXNA1 ny C0 XI0_n2 VSS nm1p2_svt_lp L=6e-08 W=3.15e-07
MI0_MXNA1_2 ny C0 XI0_n2 VSS nm1p2_svt_lp L=6e-08 W=3.15e-07
MI1_MXNA1 Y ny VSS VSS nm1p2_svt_lp L=6e-08 W=4.2e-07
MI0_MXPC2 XI0_p1 A1 VDD VDD pm1p2_svt_lp L=6e-08 W=3.45e-07
MI0_MXPC2_2 XI0_p1 A1 VDD VDD pm1p2_svt_lp L=6e-08 W=3.45e-07
MI0_MXPC1 ny A0 XI0_p1 VDD pm1p2_svt_lp L=6e-08 W=3.45e-07
MI0_MXPC1_2 ny A0 XI0_p1 VDD pm1p2_svt_lp L=6e-08 W=3.45e-07
MI0_MXPB1 ny B0 VDD VDD pm1p2_svt_lp L=6e-08 W=3.9e-07
MI0_MXPA1 ny C0 VDD VDD pm1p2_svt_lp L=6e-08 W=3.9e-07
MI1_MXPA1 Y ny VDD VDD pm1p2_svt_lp L=6e-08 W=5.85e-07
.ENDS

.SUBCKT OA211X1P4H9R Y VDD VSS A0 A1 B0 C0
MI0_MXNA1 ny C0 XI0_n2 VSS nm1p2_svt_lp L=6e-08 W=4.05e-07
MI0_MXNA1_2 ny C0 XI0_n2 VSS nm1p2_svt_lp L=6e-08 W=4.05e-07
MI0_MXNB1 XI0_n2 B0 XI0_n1 VSS nm1p2_svt_lp L=6e-08 W=4.05e-07
MI0_MXNB1_2 XI0_n2 B0 XI0_n1 VSS nm1p2_svt_lp L=6e-08 W=4.05e-07
MI0_MXNC2 XI0_n1 A1 VSS VSS nm1p2_svt_lp L=6e-08 W=4.05e-07
MI0_MXNC1 XI0_n1 A0 VSS VSS nm1p2_svt_lp L=6e-08 W=4.05e-07
MI0_MXNC1_2 XI0_n1 A0 VSS VSS nm1p2_svt_lp L=6e-08 W=4.05e-07
MI0_MXNC2_2 XI0_n1 A1 VSS VSS nm1p2_svt_lp L=6e-08 W=4.05e-07
MI1_MXNA1 Y ny VSS VSS nm1p2_svt_lp L=6e-08 W=2.95e-07
MI1_MXNA1_2 Y ny VSS VSS nm1p2_svt_lp L=6e-08 W=2.95e-07
MI0_MXPA1 ny C0 VDD VDD pm1p2_svt_lp L=6e-08 W=4.9e-07
MI0_MXPB1 ny B0 VDD VDD pm1p2_svt_lp L=6e-08 W=4.9e-07
MI0_MXPC2_2 XI0_p1__2 A1 VDD VDD pm1p2_svt_lp L=6e-08 W=4.35e-07
MI0_MXPC1_2 ny A0 XI0_p1__2 VDD pm1p2_svt_lp L=6e-08 W=4.35e-07
MI0_MXPC1 ny A0 XI0_p1 VDD pm1p2_svt_lp L=6e-08 W=4.35e-07
MI0_MXPC2 XI0_p1 A1 VDD VDD pm1p2_svt_lp L=6e-08 W=4.35e-07
MI1_MXPA1 Y ny VDD VDD pm1p2_svt_lp L=6e-08 W=4.15e-07
MI1_MXPA1_2 Y ny VDD VDD pm1p2_svt_lp L=6e-08 W=4.15e-07
.ENDS

.SUBCKT OA211X2H9R Y VDD VSS A0 A1 B0 C0
MI0_MXNA1 ny C0 XI0_n2 VSS nm1p2_svt_lp L=6e-08 W=4.95e-07
MI0_MXNA1_2 ny C0 XI0_n2 VSS nm1p2_svt_lp L=6e-08 W=4.95e-07
MI0_MXNB1 XI0_n2 B0 XI0_n1 VSS nm1p2_svt_lp L=6e-08 W=4.95e-07
MI0_MXNB1_2 XI0_n2 B0 XI0_n1 VSS nm1p2_svt_lp L=6e-08 W=4.95e-07
MI0_MXNC2 XI0_n1 A1 VSS VSS nm1p2_svt_lp L=6e-08 W=4.95e-07
MI0_MXNC1 XI0_n1 A0 VSS VSS nm1p2_svt_lp L=6e-08 W=4.95e-07
MI0_MXNC1_2 XI0_n1 A0 VSS VSS nm1p2_svt_lp L=6e-08 W=4.95e-07
MI0_MXNC2_2 XI0_n1 A1 VSS VSS nm1p2_svt_lp L=6e-08 W=4.95e-07
MI1_MXNA1 Y ny VSS VSS nm1p2_svt_lp L=6e-08 W=4.2e-07
MI1_MXNA1_2 Y ny VSS VSS nm1p2_svt_lp L=6e-08 W=4.2e-07
MI0_MXPA1 ny C0 VDD VDD pm1p2_svt_lp L=6e-08 W=3.05e-07
MI0_MXPA1_2 ny C0 VDD VDD pm1p2_svt_lp L=6e-08 W=3.05e-07
MI0_MXPB1 ny B0 VDD VDD pm1p2_svt_lp L=6e-08 W=3.05e-07
MI0_MXPB1_2 ny B0 VDD VDD pm1p2_svt_lp L=6e-08 W=3.05e-07
MI0_MXPC2_2 XI0_p1__2 A1 VDD VDD pm1p2_svt_lp L=6e-08 W=5.4e-07
MI0_MXPC1_2 ny A0 XI0_p1__2 VDD pm1p2_svt_lp L=6e-08 W=5.4e-07
MI0_MXPC1 ny A0 XI0_p1 VDD pm1p2_svt_lp L=6e-08 W=5.4e-07
MI0_MXPC2 XI0_p1 A1 VDD VDD pm1p2_svt_lp L=6e-08 W=5.4e-07
MI1_MXPA1 Y ny VDD VDD pm1p2_svt_lp L=6e-08 W=5.85e-07
MI1_MXPA1_2 Y ny VDD VDD pm1p2_svt_lp L=6e-08 W=5.85e-07
.ENDS

.SUBCKT OA211X3H9R Y VDD VSS A0 A1 B0 C0
MI0_MXNC2 XI0_n1 A1 VSS VSS nm1p2_svt_lp L=6e-08 W=4.95e-07
MI0_MXNC1 XI0_n1 A0 VSS VSS nm1p2_svt_lp L=6e-08 W=4.95e-07
MI0_MXNC1_2 XI0_n1 A0 VSS VSS nm1p2_svt_lp L=6e-08 W=4.95e-07
MI0_MXNC2_2 XI0_n1 A1 VSS VSS nm1p2_svt_lp L=6e-08 W=4.95e-07
MI0_MXNC2_3 XI0_n1 A1 VSS VSS nm1p2_svt_lp L=6e-08 W=4.95e-07
MI0_MXNC1_3 XI0_n1 A0 VSS VSS nm1p2_svt_lp L=6e-08 W=4.95e-07
MI0_MXNB1_2 XI0_n2__2 B0 XI0_n1 VSS nm1p2_svt_lp L=6e-08 W=4.95e-07
MI0_MXNA1_2 ny C0 XI0_n2__2 VSS nm1p2_svt_lp L=6e-08 W=4.95e-07
MI0_MXNA1_3 ny C0 XI0_n2__3 VSS nm1p2_svt_lp L=6e-08 W=4.95e-07
MI0_MXNB1_3 XI0_n2__3 B0 XI0_n1 VSS nm1p2_svt_lp L=6e-08 W=4.95e-07
MI0_MXNB1 XI0_n2 B0 XI0_n1 VSS nm1p2_svt_lp L=6e-08 W=4.95e-07
MI0_MXNA1 ny C0 XI0_n2 VSS nm1p2_svt_lp L=6e-08 W=4.95e-07
MI1_MXNA1 Y ny VSS VSS nm1p2_svt_lp L=6e-08 W=4.2e-07
MI1_MXNA1_2 Y ny VSS VSS nm1p2_svt_lp L=6e-08 W=4.2e-07
MI1_MXNA1_3 Y ny VSS VSS nm1p2_svt_lp L=6e-08 W=4.2e-07
MI0_MXPC2_2 XI0_p1__2 A1 VDD VDD pm1p2_svt_lp L=6e-08 W=5.4e-07
MI0_MXPC1_2 ny A0 XI0_p1__2 VDD pm1p2_svt_lp L=6e-08 W=5.4e-07
MI0_MXPC1_3 ny A0 XI0_p1__3 VDD pm1p2_svt_lp L=6e-08 W=5.4e-07
MI0_MXPC2_3 XI0_p1__3 A1 VDD VDD pm1p2_svt_lp L=6e-08 W=5.4e-07
MI0_MXPC2 XI0_p1 A1 VDD VDD pm1p2_svt_lp L=6e-08 W=5.4e-07
MI0_MXPC1 ny A0 XI0_p1 VDD pm1p2_svt_lp L=6e-08 W=5.4e-07
MI0_MXPB1 ny B0 VDD VDD pm1p2_svt_lp L=6e-08 W=4.6e-07
MI0_MXPA1 ny C0 VDD VDD pm1p2_svt_lp L=6e-08 W=4.6e-07
MI0_MXPA1_2 ny C0 VDD VDD pm1p2_svt_lp L=6e-08 W=4.6e-07
MI0_MXPB1_2 ny B0 VDD VDD pm1p2_svt_lp L=6e-08 W=4.6e-07
MI1_MXPA1 Y ny VDD VDD pm1p2_svt_lp L=6e-08 W=5.85e-07
MI1_MXPA1_2 Y ny VDD VDD pm1p2_svt_lp L=6e-08 W=5.85e-07
MI1_MXPA1_3 Y ny VDD VDD pm1p2_svt_lp L=6e-08 W=5.85e-07
.ENDS

.SUBCKT OA211X4H9R Y VDD VSS A0 A1 B0 C0
MI0_MXNA1 ny C0 XI0_n2 VSS nm1p2_svt_lp L=6e-08 W=4.95e-07
MI0_MXNA1_2 ny C0 XI0_n2 VSS nm1p2_svt_lp L=6e-08 W=4.95e-07
MI0_MXNA1_3 ny C0 XI0_n2 VSS nm1p2_svt_lp L=6e-08 W=4.95e-07
MI0_MXNA1_4 ny C0 XI0_n2 VSS nm1p2_svt_lp L=6e-08 W=4.95e-07
MI0_MXNB1 XI0_n2 B0 XI0_n1 VSS nm1p2_svt_lp L=6e-08 W=4.95e-07
MI0_MXNB1_2 XI0_n2 B0 XI0_n1 VSS nm1p2_svt_lp L=6e-08 W=4.95e-07
MI0_MXNB1_3 XI0_n2 B0 XI0_n1 VSS nm1p2_svt_lp L=6e-08 W=4.95e-07
MI0_MXNB1_4 XI0_n2 B0 XI0_n1 VSS nm1p2_svt_lp L=6e-08 W=4.95e-07
MI0_MXNC2 XI0_n1 A1 VSS VSS nm1p2_svt_lp L=6e-08 W=4.95e-07
MI0_MXNC1 XI0_n1 A0 VSS VSS nm1p2_svt_lp L=6e-08 W=4.95e-07
MI0_MXNC1_2 XI0_n1 A0 VSS VSS nm1p2_svt_lp L=6e-08 W=4.95e-07
MI0_MXNC2_2 XI0_n1 A1 VSS VSS nm1p2_svt_lp L=6e-08 W=4.95e-07
MI0_MXNC2_3 XI0_n1 A1 VSS VSS nm1p2_svt_lp L=6e-08 W=4.95e-07
MI0_MXNC1_3 XI0_n1 A0 VSS VSS nm1p2_svt_lp L=6e-08 W=4.95e-07
MI0_MXNC1_4 XI0_n1 A0 VSS VSS nm1p2_svt_lp L=6e-08 W=4.95e-07
MI0_MXNC2_4 XI0_n1 A1 VSS VSS nm1p2_svt_lp L=6e-08 W=4.95e-07
MI1_MXNA1 Y ny VSS VSS nm1p2_svt_lp L=6e-08 W=4.2e-07
MI1_MXNA1_2 Y ny VSS VSS nm1p2_svt_lp L=6e-08 W=4.2e-07
MI1_MXNA1_3 Y ny VSS VSS nm1p2_svt_lp L=6e-08 W=4.2e-07
MI1_MXNA1_4 Y ny VSS VSS nm1p2_svt_lp L=6e-08 W=4.2e-07
MI0_MXPA1 ny C0 VDD VDD pm1p2_svt_lp L=6e-08 W=4.1e-07
MI0_MXPA1_2 ny C0 VDD VDD pm1p2_svt_lp L=6e-08 W=4.1e-07
MI0_MXPA1_3 ny C0 VDD VDD pm1p2_svt_lp L=6e-08 W=4.1e-07
MI0_MXPB1 ny B0 VDD VDD pm1p2_svt_lp L=6e-08 W=4.1e-07
MI0_MXPB1_2 ny B0 VDD VDD pm1p2_svt_lp L=6e-08 W=4.1e-07
MI0_MXPB1_3 ny B0 VDD VDD pm1p2_svt_lp L=6e-08 W=4.1e-07
MI0_MXPC2_2 XI0_p1__2 A1 VDD VDD pm1p2_svt_lp L=6e-08 W=5.4e-07
MI0_MXPC1_2 ny A0 XI0_p1__2 VDD pm1p2_svt_lp L=6e-08 W=5.4e-07
MI0_MXPC1_3 ny A0 XI0_p1__3 VDD pm1p2_svt_lp L=6e-08 W=5.4e-07
MI0_MXPC2_3 XI0_p1__3 A1 VDD VDD pm1p2_svt_lp L=6e-08 W=5.4e-07
MI0_MXPC2_4 XI0_p1__4 A1 VDD VDD pm1p2_svt_lp L=6e-08 W=5.4e-07
MI0_MXPC1_4 ny A0 XI0_p1__4 VDD pm1p2_svt_lp L=6e-08 W=5.4e-07
MI0_MXPC1 ny A0 XI0_p1 VDD pm1p2_svt_lp L=6e-08 W=5.4e-07
MI0_MXPC2 XI0_p1 A1 VDD VDD pm1p2_svt_lp L=6e-08 W=5.4e-07
MI1_MXPA1 Y ny VDD VDD pm1p2_svt_lp L=6e-08 W=5.85e-07
MI1_MXPA1_2 Y ny VDD VDD pm1p2_svt_lp L=6e-08 W=5.85e-07
MI1_MXPA1_3 Y ny VDD VDD pm1p2_svt_lp L=6e-08 W=5.85e-07
MI1_MXPA1_4 Y ny VDD VDD pm1p2_svt_lp L=6e-08 W=5.85e-07
.ENDS

.SUBCKT OA211X6H9R Y VDD VSS A0 A1 B0 C0
MI0_MXNC1 XI0_n1 A0 VSS VSS nm1p2_svt_lp L=6e-08 W=4.95e-07
MI0_MXNC2 XI0_n1 A1 VSS VSS nm1p2_svt_lp L=6e-08 W=4.95e-07
MI0_MXNC2_2 XI0_n1 A1 VSS VSS nm1p2_svt_lp L=6e-08 W=4.95e-07
MI0_MXNC1_2 XI0_n1 A0 VSS VSS nm1p2_svt_lp L=6e-08 W=4.95e-07
MI0_MXNC1_3 XI0_n1 A0 VSS VSS nm1p2_svt_lp L=6e-08 W=4.95e-07
MI0_MXNC2_3 XI0_n1 A1 VSS VSS nm1p2_svt_lp L=6e-08 W=4.95e-07
MI0_MXNC2_4 XI0_n1 A1 VSS VSS nm1p2_svt_lp L=6e-08 W=4.95e-07
MI0_MXNC1_4 XI0_n1 A0 VSS VSS nm1p2_svt_lp L=6e-08 W=4.95e-07
MI0_MXNC1_5 XI0_n1 A0 VSS VSS nm1p2_svt_lp L=6e-08 W=4.95e-07
MI0_MXNC2_5 XI0_n1 A1 VSS VSS nm1p2_svt_lp L=6e-08 W=4.95e-07
MI0_MXNC2_6 XI0_n1 A1 VSS VSS nm1p2_svt_lp L=6e-08 W=4.95e-07
MI0_MXNC1_6 XI0_n1 A0 VSS VSS nm1p2_svt_lp L=6e-08 W=4.95e-07
MI0_MXNB1_2 XI0_n2__2 B0 XI0_n1 VSS nm1p2_svt_lp L=6e-08 W=4.95e-07
MI0_MXNA1_2 ny C0 XI0_n2__2 VSS nm1p2_svt_lp L=6e-08 W=4.95e-07
MI0_MXNA1_3 ny C0 XI0_n2__3 VSS nm1p2_svt_lp L=6e-08 W=4.95e-07
MI0_MXNB1_3 XI0_n2__3 B0 XI0_n1 VSS nm1p2_svt_lp L=6e-08 W=4.95e-07
MI0_MXNB1_4 XI0_n2__4 B0 XI0_n1 VSS nm1p2_svt_lp L=6e-08 W=4.95e-07
MI0_MXNA1_4 ny C0 XI0_n2__4 VSS nm1p2_svt_lp L=6e-08 W=4.95e-07
MI0_MXNA1_5 ny C0 XI0_n2__5 VSS nm1p2_svt_lp L=6e-08 W=4.95e-07
MI0_MXNB1_5 XI0_n2__5 B0 XI0_n1 VSS nm1p2_svt_lp L=6e-08 W=4.95e-07
MI0_MXNB1_6 XI0_n2__6 B0 XI0_n1 VSS nm1p2_svt_lp L=6e-08 W=4.95e-07
MI0_MXNA1_6 ny C0 XI0_n2__6 VSS nm1p2_svt_lp L=6e-08 W=4.95e-07
MI0_MXNA1 ny C0 XI0_n2 VSS nm1p2_svt_lp L=6e-08 W=4.95e-07
MI0_MXNB1 XI0_n2 B0 XI0_n1 VSS nm1p2_svt_lp L=6e-08 W=4.95e-07
MI1_MXNA1 Y ny VSS VSS nm1p2_svt_lp L=6e-08 W=4.2e-07
MI1_MXNA1_2 Y ny VSS VSS nm1p2_svt_lp L=6e-08 W=4.2e-07
MI1_MXNA1_3 Y ny VSS VSS nm1p2_svt_lp L=6e-08 W=4.2e-07
MI1_MXNA1_4 Y ny VSS VSS nm1p2_svt_lp L=6e-08 W=4.2e-07
MI1_MXNA1_5 Y ny VSS VSS nm1p2_svt_lp L=6e-08 W=4.2e-07
MI1_MXNA1_6 Y ny VSS VSS nm1p2_svt_lp L=6e-08 W=4.2e-07
MI0_MXPC1_2 ny A0 XI0_p1__2 VDD pm1p2_svt_lp L=6e-08 W=5.4e-07
MI0_MXPC2_2 XI0_p1__2 A1 VDD VDD pm1p2_svt_lp L=6e-08 W=5.4e-07
MI0_MXPC2_3 XI0_p1__3 A1 VDD VDD pm1p2_svt_lp L=6e-08 W=5.4e-07
MI0_MXPC1_3 ny A0 XI0_p1__3 VDD pm1p2_svt_lp L=6e-08 W=5.4e-07
MI0_MXPC1_4 ny A0 XI0_p1__4 VDD pm1p2_svt_lp L=6e-08 W=5.4e-07
MI0_MXPC2_4 XI0_p1__4 A1 VDD VDD pm1p2_svt_lp L=6e-08 W=5.4e-07
MI0_MXPC2_5 XI0_p1__5 A1 VDD VDD pm1p2_svt_lp L=6e-08 W=5.4e-07
MI0_MXPC1_5 ny A0 XI0_p1__5 VDD pm1p2_svt_lp L=6e-08 W=5.4e-07
MI0_MXPC1_6 ny A0 XI0_p1__6 VDD pm1p2_svt_lp L=6e-08 W=5.4e-07
MI0_MXPC2_6 XI0_p1__6 A1 VDD VDD pm1p2_svt_lp L=6e-08 W=5.4e-07
MI0_MXPC2 XI0_p1 A1 VDD VDD pm1p2_svt_lp L=6e-08 W=5.4e-07
MI0_MXPC1 ny A0 XI0_p1 VDD pm1p2_svt_lp L=6e-08 W=5.4e-07
MI0_MXPB1 ny B0 VDD VDD pm1p2_svt_lp L=6e-08 W=4.6e-07
MI0_MXPA1 ny C0 VDD VDD pm1p2_svt_lp L=6e-08 W=4.6e-07
MI0_MXPA1_2 ny C0 VDD VDD pm1p2_svt_lp L=6e-08 W=4.6e-07
MI0_MXPB1_2 ny B0 VDD VDD pm1p2_svt_lp L=6e-08 W=4.6e-07
MI0_MXPB1_3 ny B0 VDD VDD pm1p2_svt_lp L=6e-08 W=4.6e-07
MI0_MXPA1_3 ny C0 VDD VDD pm1p2_svt_lp L=6e-08 W=4.6e-07
MI0_MXPA1_4 ny C0 VDD VDD pm1p2_svt_lp L=6e-08 W=4.6e-07
MI0_MXPB1_4 ny B0 VDD VDD pm1p2_svt_lp L=6e-08 W=4.6e-07
MI1_MXPA1 Y ny VDD VDD pm1p2_svt_lp L=6e-08 W=5.85e-07
MI1_MXPA1_2 Y ny VDD VDD pm1p2_svt_lp L=6e-08 W=5.85e-07
MI1_MXPA1_3 Y ny VDD VDD pm1p2_svt_lp L=6e-08 W=5.85e-07
MI1_MXPA1_4 Y ny VDD VDD pm1p2_svt_lp L=6e-08 W=5.85e-07
MI1_MXPA1_5 Y ny VDD VDD pm1p2_svt_lp L=6e-08 W=5.85e-07
MI1_MXPA1_6 Y ny VDD VDD pm1p2_svt_lp L=6e-08 W=5.85e-07
.ENDS

.SUBCKT OAI211X0P5H9R Y VDD VSS A0 A1 B0 C0
MI0_MXNC2 XI0_n1 A1 VSS VSS nm1p2_svt_lp L=6e-08 W=2.5e-07
MI0_MXNC1 XI0_n1 A0 VSS VSS nm1p2_svt_lp L=6e-08 W=2.5e-07
MI0_MXNB1 XI0_n2 B0 XI0_n1 VSS nm1p2_svt_lp L=6e-08 W=2.5e-07
MI0_MXNA1 Y C0 XI0_n2 VSS nm1p2_svt_lp L=6e-08 W=2.5e-07
MI0_MXPC2 XI0_p1 A1 VDD VDD pm1p2_svt_lp L=6e-08 W=2.7e-07
MI0_MXPC1 Y A0 XI0_p1 VDD pm1p2_svt_lp L=6e-08 W=2.7e-07
MI0_MXPB1 Y B0 VDD VDD pm1p2_svt_lp L=6e-08 W=1.5e-07
MI0_MXPA1 Y C0 VDD VDD pm1p2_svt_lp L=6e-08 W=1.5e-07
.ENDS

.SUBCKT OAI211X0P7H9R Y VDD VSS A0 A1 B0 C0
MI0_MXNC2 XI0_n1 A1 VSS VSS nm1p2_svt_lp L=6e-08 W=3.5e-07
MI0_MXNC1 XI0_n1 A0 VSS VSS nm1p2_svt_lp L=6e-08 W=3.5e-07
MI0_MXNB1 XI0_n2 B0 XI0_n1 VSS nm1p2_svt_lp L=6e-08 W=3.5e-07
MI0_MXNA1 Y C0 XI0_n2 VSS nm1p2_svt_lp L=6e-08 W=3.5e-07
MI0_MXPC2 XI0_p1 A1 VDD VDD pm1p2_svt_lp L=6e-08 W=3.8e-07
MI0_MXPC1 Y A0 XI0_p1 VDD pm1p2_svt_lp L=6e-08 W=3.8e-07
MI0_MXPB1 Y B0 VDD VDD pm1p2_svt_lp L=6e-08 W=2.15e-07
MI0_MXPA1 Y C0 VDD VDD pm1p2_svt_lp L=6e-08 W=2.15e-07
.ENDS

.SUBCKT OAI211X1H9R Y VDD VSS A0 A1 B0 C0
MI0_MXNC2 XI0_n1 A1 VSS VSS nm1p2_svt_lp L=6e-08 W=4.95e-07
MI0_MXNC1 XI0_n1 A0 VSS VSS nm1p2_svt_lp L=6e-08 W=4.95e-07
MI0_MXNB1 XI0_n2 B0 XI0_n1 VSS nm1p2_svt_lp L=6e-08 W=4.95e-07
MI0_MXNA1 Y C0 XI0_n2 VSS nm1p2_svt_lp L=6e-08 W=4.95e-07
MI0_MXPC2 XI0_p1 A1 VDD VDD pm1p2_svt_lp L=6e-08 W=5.4e-07
MI0_MXPC1 Y A0 XI0_p1 VDD pm1p2_svt_lp L=6e-08 W=5.4e-07
MI0_MXPB1 Y B0 VDD VDD pm1p2_svt_lp L=6e-08 W=3.05e-07
MI0_MXPA1 Y C0 VDD VDD pm1p2_svt_lp L=6e-08 W=3.05e-07
.ENDS

.SUBCKT OAI211X1P4H9R Y VDD VSS A0 A1 B0 C0
MI0_MXNB1_2 XI0_n2__2 B0 XI0_n1 VSS nm1p2_svt_lp L=6e-08 W=3.5e-07
MI0_MXNA1_2 Y C0 XI0_n2__2 VSS nm1p2_svt_lp L=6e-08 W=3.5e-07
MI0_MXNA1 Y C0 XI0_n2 VSS nm1p2_svt_lp L=6e-08 W=3.5e-07
MI0_MXNB1 XI0_n2 B0 XI0_n1 VSS nm1p2_svt_lp L=6e-08 W=3.5e-07
MI0_MXNC1 XI0_n1 A0 VSS VSS nm1p2_svt_lp L=6e-08 W=3.5e-07
MI0_MXNC2 XI0_n1 A1 VSS VSS nm1p2_svt_lp L=6e-08 W=3.5e-07
MI0_MXNC2_2 XI0_n1 A1 VSS VSS nm1p2_svt_lp L=6e-08 W=3.5e-07
MI0_MXNC1_2 XI0_n1 A0 VSS VSS nm1p2_svt_lp L=6e-08 W=3.5e-07
MI0_MXPA1 Y C0 VDD VDD pm1p2_svt_lp L=6e-08 W=4.3e-07
MI0_MXPB1 Y B0 VDD VDD pm1p2_svt_lp L=6e-08 W=4.3e-07
MI0_MXPC1_2 Y A0 XI0_p1__2 VDD pm1p2_svt_lp L=6e-08 W=3.8e-07
MI0_MXPC2_2 XI0_p1__2 A1 VDD VDD pm1p2_svt_lp L=6e-08 W=3.8e-07
MI0_MXPC2 XI0_p1 A1 VDD VDD pm1p2_svt_lp L=6e-08 W=3.8e-07
MI0_MXPC1 Y A0 XI0_p1 VDD pm1p2_svt_lp L=6e-08 W=3.8e-07
.ENDS

.SUBCKT OAI211X2H9R Y VDD VSS A0 A1 B0 C0
MI0_MXNC1 XI0_n1 A0 VSS VSS nm1p2_svt_lp L=6e-08 W=4.95e-07
MI0_MXNC2 XI0_n1 A1 VSS VSS nm1p2_svt_lp L=6e-08 W=4.95e-07
MI0_MXNC2_2 XI0_n1 A1 VSS VSS nm1p2_svt_lp L=6e-08 W=4.95e-07
MI0_MXNC1_2 XI0_n1 A0 VSS VSS nm1p2_svt_lp L=6e-08 W=4.95e-07
MI0_MXNB1_2 XI0_n2__2 B0 XI0_n1 VSS nm1p2_svt_lp L=6e-08 W=4.95e-07
MI0_MXNA1_2 Y C0 XI0_n2__2 VSS nm1p2_svt_lp L=6e-08 W=4.95e-07
MI0_MXNA1 Y C0 XI0_n2 VSS nm1p2_svt_lp L=6e-08 W=4.95e-07
MI0_MXNB1 XI0_n2 B0 XI0_n1 VSS nm1p2_svt_lp L=6e-08 W=4.95e-07
MI0_MXPC1_2 Y A0 XI0_p1__2 VDD pm1p2_svt_lp L=6e-08 W=5.4e-07
MI0_MXPC2_2 XI0_p1__2 A1 VDD VDD pm1p2_svt_lp L=6e-08 W=5.4e-07
MI0_MXPC2 XI0_p1 A1 VDD VDD pm1p2_svt_lp L=6e-08 W=5.4e-07
MI0_MXPC1 Y A0 XI0_p1 VDD pm1p2_svt_lp L=6e-08 W=5.4e-07
MI0_MXPB1 Y B0 VDD VDD pm1p2_svt_lp L=6e-08 W=3.05e-07
MI0_MXPA1 Y C0 VDD VDD pm1p2_svt_lp L=6e-08 W=3.05e-07
MI0_MXPA1_2 Y C0 VDD VDD pm1p2_svt_lp L=6e-08 W=3.05e-07
MI0_MXPB1_2 Y B0 VDD VDD pm1p2_svt_lp L=6e-08 W=3.05e-07
.ENDS

.SUBCKT OAI211X3H9R Y VDD VSS A0 A1 B0 C0
MI0_MXNC2 XI0_n1 A1 VSS VSS nm1p2_svt_lp L=6e-08 W=4.95e-07
MI0_MXNC2_2 XI0_n1 A1 VSS VSS nm1p2_svt_lp L=6e-08 W=4.95e-07
MI0_MXNC2_3 XI0_n1 A1 VSS VSS nm1p2_svt_lp L=6e-08 W=4.95e-07
MI0_MXNC1 XI0_n1 A0 VSS VSS nm1p2_svt_lp L=6e-08 W=4.95e-07
MI0_MXNC1_2 XI0_n1 A0 VSS VSS nm1p2_svt_lp L=6e-08 W=4.95e-07
MI0_MXNC1_3 XI0_n1 A0 VSS VSS nm1p2_svt_lp L=6e-08 W=4.95e-07
MI0_MXNB1 XI0_n2 B0 XI0_n1 VSS nm1p2_svt_lp L=6e-08 W=4.95e-07
MI0_MXNB1_2 XI0_n2 B0 XI0_n1 VSS nm1p2_svt_lp L=6e-08 W=4.95e-07
MI0_MXNB1_3 XI0_n2 B0 XI0_n1 VSS nm1p2_svt_lp L=6e-08 W=4.95e-07
MI0_MXNA1 Y C0 XI0_n2 VSS nm1p2_svt_lp L=6e-08 W=4.95e-07
MI0_MXNA1_2 Y C0 XI0_n2 VSS nm1p2_svt_lp L=6e-08 W=4.95e-07
MI0_MXNA1_3 Y C0 XI0_n2 VSS nm1p2_svt_lp L=6e-08 W=4.95e-07
MI0_MXPC2 XI0_p1 A1 VDD VDD pm1p2_svt_lp L=6e-08 W=5.4e-07
MI0_MXPC2_2 XI0_p1 A1 VDD VDD pm1p2_svt_lp L=6e-08 W=5.4e-07
MI0_MXPC2_3 XI0_p1 A1 VDD VDD pm1p2_svt_lp L=6e-08 W=5.4e-07
MI0_MXPC1 Y A0 XI0_p1 VDD pm1p2_svt_lp L=6e-08 W=5.4e-07
MI0_MXPC1_2 Y A0 XI0_p1 VDD pm1p2_svt_lp L=6e-08 W=5.4e-07
MI0_MXPC1_3 Y A0 XI0_p1 VDD pm1p2_svt_lp L=6e-08 W=5.4e-07
MI0_MXPB1 Y B0 VDD VDD pm1p2_svt_lp L=6e-08 W=4.6e-07
MI0_MXPB1_2 Y B0 VDD VDD pm1p2_svt_lp L=6e-08 W=4.6e-07
MI0_MXPA1 Y C0 VDD VDD pm1p2_svt_lp L=6e-08 W=4.6e-07
MI0_MXPA1_2 Y C0 VDD VDD pm1p2_svt_lp L=6e-08 W=4.6e-07
.ENDS

.SUBCKT OAI211X4H9R Y VDD VSS A0 A1 B0 C0
MI0_MXNC1 XI0_n1 A0 VSS VSS nm1p2_svt_lp L=6e-08 W=4.95e-07
MI0_MXNC2 XI0_n1 A1 VSS VSS nm1p2_svt_lp L=6e-08 W=4.95e-07
MI0_MXNC2_2 XI0_n1 A1 VSS VSS nm1p2_svt_lp L=6e-08 W=4.95e-07
MI0_MXNC1_2 XI0_n1 A0 VSS VSS nm1p2_svt_lp L=6e-08 W=4.95e-07
MI0_MXNC1_3 XI0_n1 A0 VSS VSS nm1p2_svt_lp L=6e-08 W=4.95e-07
MI0_MXNC2_3 XI0_n1 A1 VSS VSS nm1p2_svt_lp L=6e-08 W=4.95e-07
MI0_MXNC2_4 XI0_n1 A1 VSS VSS nm1p2_svt_lp L=6e-08 W=4.95e-07
MI0_MXNC1_4 XI0_n1 A0 VSS VSS nm1p2_svt_lp L=6e-08 W=4.95e-07
MI0_MXNB1_2 XI0_n2__2 B0 XI0_n1 VSS nm1p2_svt_lp L=6e-08 W=4.95e-07
MI0_MXNA1_2 Y C0 XI0_n2__2 VSS nm1p2_svt_lp L=6e-08 W=4.95e-07
MI0_MXNA1_3 Y C0 XI0_n2__3 VSS nm1p2_svt_lp L=6e-08 W=4.95e-07
MI0_MXNB1_3 XI0_n2__3 B0 XI0_n1 VSS nm1p2_svt_lp L=6e-08 W=4.95e-07
MI0_MXNB1_4 XI0_n2__4 B0 XI0_n1 VSS nm1p2_svt_lp L=6e-08 W=4.95e-07
MI0_MXNA1_4 Y C0 XI0_n2__4 VSS nm1p2_svt_lp L=6e-08 W=4.95e-07
MI0_MXNA1 Y C0 XI0_n2 VSS nm1p2_svt_lp L=6e-08 W=4.95e-07
MI0_MXNB1 XI0_n2 B0 XI0_n1 VSS nm1p2_svt_lp L=6e-08 W=4.95e-07
MI0_MXPC1_2 Y A0 XI0_p1__2 VDD pm1p2_svt_lp L=6e-08 W=5.4e-07
MI0_MXPC2_2 XI0_p1__2 A1 VDD VDD pm1p2_svt_lp L=6e-08 W=5.4e-07
MI0_MXPC2_3 XI0_p1__3 A1 VDD VDD pm1p2_svt_lp L=6e-08 W=5.4e-07
MI0_MXPC1_3 Y A0 XI0_p1__3 VDD pm1p2_svt_lp L=6e-08 W=5.4e-07
MI0_MXPC1_4 Y A0 XI0_p1__4 VDD pm1p2_svt_lp L=6e-08 W=5.4e-07
MI0_MXPC2_4 XI0_p1__4 A1 VDD VDD pm1p2_svt_lp L=6e-08 W=5.4e-07
MI0_MXPC2 XI0_p1 A1 VDD VDD pm1p2_svt_lp L=6e-08 W=5.4e-07
MI0_MXPC1 Y A0 XI0_p1 VDD pm1p2_svt_lp L=6e-08 W=5.4e-07
MI0_MXPB1 Y B0 VDD VDD pm1p2_svt_lp L=6e-08 W=4.1e-07
MI0_MXPA1 Y C0 VDD VDD pm1p2_svt_lp L=6e-08 W=4.1e-07
MI0_MXPA1_2 Y C0 VDD VDD pm1p2_svt_lp L=6e-08 W=4.1e-07
MI0_MXPB1_2 Y B0 VDD VDD pm1p2_svt_lp L=6e-08 W=4.1e-07
MI0_MXPB1_3 Y B0 VDD VDD pm1p2_svt_lp L=6e-08 W=4.1e-07
MI0_MXPA1_3 Y C0 VDD VDD pm1p2_svt_lp L=6e-08 W=4.1e-07
.ENDS

.SUBCKT OAI221X0P5H9R Y VDD VSS A0 A1 B0 B1 C0
MI0_MXNC2 XI0_n1 A1 VSS VSS nm1p2_svt_lp L=6e-08 W=2.5e-07
MI0_MXNC1 XI0_n1 A0 VSS VSS nm1p2_svt_lp L=6e-08 W=2.5e-07
MI0_MXNB1 XI0_n2 B0 XI0_n1 VSS nm1p2_svt_lp L=6e-08 W=2.5e-07
MI0_MXNB2 XI0_n2 B1 XI0_n1 VSS nm1p2_svt_lp L=6e-08 W=2.5e-07
MI0_MXNA1 Y C0 XI0_n2 VSS nm1p2_svt_lp L=6e-08 W=2.5e-07
MI0_MXPC2 XI0_p1C A1 VDD VDD pm1p2_svt_lp L=6e-08 W=2.7e-07
MI0_MXPC1 Y A0 XI0_p1C VDD pm1p2_svt_lp L=6e-08 W=2.7e-07
MI0_MXPB1 Y B0 XI0_p1B VDD pm1p2_svt_lp L=6e-08 W=2.7e-07
MI0_MXPB2 XI0_p1B B1 VDD VDD pm1p2_svt_lp L=6e-08 W=2.7e-07
MI0_MXPA1 Y C0 VDD VDD pm1p2_svt_lp L=6e-08 W=1.5e-07
.ENDS

.SUBCKT OAI221X0P7H9R Y VDD VSS A0 A1 B0 B1 C0
MI0_MXNC2 XI0_n1 A1 VSS VSS nm1p2_svt_lp L=6e-08 W=3.5e-07
MI0_MXNC1 XI0_n1 A0 VSS VSS nm1p2_svt_lp L=6e-08 W=3.5e-07
MI0_MXNB1 XI0_n2 B0 XI0_n1 VSS nm1p2_svt_lp L=6e-08 W=3.5e-07
MI0_MXNB2 XI0_n2 B1 XI0_n1 VSS nm1p2_svt_lp L=6e-08 W=3.5e-07
MI0_MXNA1 Y C0 XI0_n2 VSS nm1p2_svt_lp L=6e-08 W=3.5e-07
MI0_MXPC2 XI0_p1C A1 VDD VDD pm1p2_svt_lp L=6e-08 W=3.8e-07
MI0_MXPC1 Y A0 XI0_p1C VDD pm1p2_svt_lp L=6e-08 W=3.8e-07
MI0_MXPB1 Y B0 XI0_p1B VDD pm1p2_svt_lp L=6e-08 W=3.8e-07
MI0_MXPB2 XI0_p1B B1 VDD VDD pm1p2_svt_lp L=6e-08 W=3.8e-07
MI0_MXPA1 Y C0 VDD VDD pm1p2_svt_lp L=6e-08 W=2.15e-07
.ENDS

.SUBCKT OAI221X1H9R Y VDD VSS A0 A1 B0 B1 C0
MI0_MXNC2 XI0_n1 A1 VSS VSS nm1p2_svt_lp L=6e-08 W=4.95e-07
MI0_MXNC1 XI0_n1 A0 VSS VSS nm1p2_svt_lp L=6e-08 W=4.95e-07
MI0_MXNB1 XI0_n2 B0 XI0_n1 VSS nm1p2_svt_lp L=6e-08 W=4.95e-07
MI0_MXNB2 XI0_n2 B1 XI0_n1 VSS nm1p2_svt_lp L=6e-08 W=4.95e-07
MI0_MXNA1 Y C0 XI0_n2 VSS nm1p2_svt_lp L=6e-08 W=4.95e-07
MI0_MXPC2 XI0_p1C A1 VDD VDD pm1p2_svt_lp L=6e-08 W=5.4e-07
MI0_MXPC1 Y A0 XI0_p1C VDD pm1p2_svt_lp L=6e-08 W=5.4e-07
MI0_MXPB1 Y B0 XI0_p1B VDD pm1p2_svt_lp L=6e-08 W=5.4e-07
MI0_MXPB2 XI0_p1B B1 VDD VDD pm1p2_svt_lp L=6e-08 W=5.4e-07
MI0_MXPA1 Y C0 VDD VDD pm1p2_svt_lp L=6e-08 W=3.05e-07
.ENDS

.SUBCKT OAI221X1P4H9R Y VDD VSS A0 A1 B0 B1 C0
MI0_MXNC2 XI0_n1 A1 VSS VSS nm1p2_svt_lp L=6e-08 W=3.5e-07
MI0_MXNC2_2 XI0_n1 A1 VSS VSS nm1p2_svt_lp L=6e-08 W=3.5e-07
MI0_MXNC1 XI0_n1 A0 VSS VSS nm1p2_svt_lp L=6e-08 W=7e-07
MI0_MXNB2 XI0_n2 B1 XI0_n1 VSS nm1p2_svt_lp L=6e-08 W=7e-07
MI0_MXNB1 XI0_n2 B0 XI0_n1 VSS nm1p2_svt_lp L=6e-08 W=7e-07
MI0_MXNA1 Y C0 XI0_n2 VSS nm1p2_svt_lp L=6e-08 W=3.5e-07
MI0_MXNA1_2 Y C0 XI0_n2 VSS nm1p2_svt_lp L=6e-08 W=3.5e-07
MI0_MXPC2_2 XI0_p1C__2 A1 VDD VDD pm1p2_svt_lp L=6e-08 W=3.8e-07
MI0_MXPC1_2 Y A0 XI0_p1C__2 VDD pm1p2_svt_lp L=6e-08 W=3.8e-07
MI0_MXPC1 Y A0 XI0_p1C VDD pm1p2_svt_lp L=6e-08 W=3.8e-07
MI0_MXPC2 XI0_p1C A1 VDD VDD pm1p2_svt_lp L=6e-08 W=3.8e-07
MI0_MXPB2_2 XI0_p1B__2 B1 VDD VDD pm1p2_svt_lp L=6e-08 W=3.8e-07
MI0_MXPB1_2 Y B0 XI0_p1B__2 VDD pm1p2_svt_lp L=6e-08 W=3.8e-07
MI0_MXPB1 Y B0 XI0_p1B VDD pm1p2_svt_lp L=6e-08 W=3.8e-07
MI0_MXPB2 XI0_p1B B1 VDD VDD pm1p2_svt_lp L=6e-08 W=3.8e-07
MI0_MXPA1 Y C0 VDD VDD pm1p2_svt_lp L=6e-08 W=2.15e-07
MI0_MXPA1_2 Y C0 VDD VDD pm1p2_svt_lp L=6e-08 W=2.15e-07
.ENDS

.SUBCKT OAI221X2H9R Y VDD VSS A0 A1 B0 B1 C0
MI0_MXNC2 XI0_n1 A1 VSS VSS nm1p2_svt_lp L=6e-08 W=4.95e-07
MI0_MXNC1 XI0_n1 A0 VSS VSS nm1p2_svt_lp L=6e-08 W=4.95e-07
MI0_MXNC1_2 XI0_n1 A0 VSS VSS nm1p2_svt_lp L=6e-08 W=4.95e-07
MI0_MXNC2_2 XI0_n1 A1 VSS VSS nm1p2_svt_lp L=6e-08 W=4.95e-07
MI0_MXNB2 XI0_n2 B1 XI0_n1 VSS nm1p2_svt_lp L=6e-08 W=4.95e-07
MI0_MXNB1 XI0_n2 B0 XI0_n1 VSS nm1p2_svt_lp L=6e-08 W=4.95e-07
MI0_MXNB1_2 XI0_n2 B0 XI0_n1 VSS nm1p2_svt_lp L=6e-08 W=4.95e-07
MI0_MXNB2_2 XI0_n2 B1 XI0_n1 VSS nm1p2_svt_lp L=6e-08 W=4.95e-07
MI0_MXNA1 Y C0 XI0_n2 VSS nm1p2_svt_lp L=6e-08 W=4.95e-07
MI0_MXNA1_2 Y C0 XI0_n2 VSS nm1p2_svt_lp L=6e-08 W=4.95e-07
MI0_MXPC2_2 XI0_p1C__2 A1 VDD VDD pm1p2_svt_lp L=6e-08 W=5.4e-07
MI0_MXPC1_2 Y A0 XI0_p1C__2 VDD pm1p2_svt_lp L=6e-08 W=5.4e-07
MI0_MXPC1 Y A0 XI0_p1C VDD pm1p2_svt_lp L=6e-08 W=5.4e-07
MI0_MXPC2 XI0_p1C A1 VDD VDD pm1p2_svt_lp L=6e-08 W=5.4e-07
MI0_MXPB2_2 XI0_p1B__2 B1 VDD VDD pm1p2_svt_lp L=6e-08 W=5.4e-07
MI0_MXPB1_2 Y B0 XI0_p1B__2 VDD pm1p2_svt_lp L=6e-08 W=5.4e-07
MI0_MXPB1 Y B0 XI0_p1B VDD pm1p2_svt_lp L=6e-08 W=5.4e-07
MI0_MXPB2 XI0_p1B B1 VDD VDD pm1p2_svt_lp L=6e-08 W=5.4e-07
MI0_MXPA1 Y C0 VDD VDD pm1p2_svt_lp L=6e-08 W=3.05e-07
MI0_MXPA1_2 Y C0 VDD VDD pm1p2_svt_lp L=6e-08 W=3.05e-07
.ENDS

.SUBCKT OAI221X3H9R Y VDD VSS A0 A1 B0 B1 C0
MI0_MXNC2 XI0_n1 A1 VSS VSS nm1p2_svt_lp L=6e-08 W=4.95e-07
MI0_MXNC2_2 XI0_n1 A1 VSS VSS nm1p2_svt_lp L=6e-08 W=4.95e-07
MI0_MXNC2_3 XI0_n1 A1 VSS VSS nm1p2_svt_lp L=6e-08 W=4.95e-07
MI0_MXNC1 XI0_n1 A0 VSS VSS nm1p2_svt_lp L=6e-08 W=4.95e-07
MI0_MXNC1_2 XI0_n1 A0 VSS VSS nm1p2_svt_lp L=6e-08 W=4.95e-07
MI0_MXNC1_3 XI0_n1 A0 VSS VSS nm1p2_svt_lp L=6e-08 W=4.95e-07
MI0_MXNB1 XI0_n2 B0 XI0_n1 VSS nm1p2_svt_lp L=6e-08 W=4.95e-07
MI0_MXNB1_2 XI0_n2 B0 XI0_n1 VSS nm1p2_svt_lp L=6e-08 W=4.95e-07
MI0_MXNB1_3 XI0_n2 B0 XI0_n1 VSS nm1p2_svt_lp L=6e-08 W=4.95e-07
MI0_MXNB2 XI0_n2 B1 XI0_n1 VSS nm1p2_svt_lp L=6e-08 W=4.95e-07
MI0_MXNB2_2 XI0_n2 B1 XI0_n1 VSS nm1p2_svt_lp L=6e-08 W=4.95e-07
MI0_MXNB2_3 XI0_n2 B1 XI0_n1 VSS nm1p2_svt_lp L=6e-08 W=4.95e-07
MI0_MXNA1 Y C0 XI0_n2 VSS nm1p2_svt_lp L=6e-08 W=4.95e-07
MI0_MXNA1_2 Y C0 XI0_n2 VSS nm1p2_svt_lp L=6e-08 W=4.95e-07
MI0_MXNA1_3 Y C0 XI0_n2 VSS nm1p2_svt_lp L=6e-08 W=4.95e-07
MI0_MXPC2 XI0_p1C A1 VDD VDD pm1p2_svt_lp L=6e-08 W=5.4e-07
MI0_MXPC2_2 XI0_p1C A1 VDD VDD pm1p2_svt_lp L=6e-08 W=5.4e-07
MI0_MXPC2_3 XI0_p1C A1 VDD VDD pm1p2_svt_lp L=6e-08 W=5.4e-07
MI0_MXPC1 Y A0 XI0_p1C VDD pm1p2_svt_lp L=6e-08 W=5.4e-07
MI0_MXPC1_2 Y A0 XI0_p1C VDD pm1p2_svt_lp L=6e-08 W=5.4e-07
MI0_MXPC1_3 Y A0 XI0_p1C VDD pm1p2_svt_lp L=6e-08 W=5.4e-07
MI0_MXPB1 Y B0 XI0_p1B VDD pm1p2_svt_lp L=6e-08 W=5.4e-07
MI0_MXPB1_2 Y B0 XI0_p1B VDD pm1p2_svt_lp L=6e-08 W=5.4e-07
MI0_MXPB1_3 Y B0 XI0_p1B VDD pm1p2_svt_lp L=6e-08 W=5.4e-07
MI0_MXPB2 XI0_p1B B1 VDD VDD pm1p2_svt_lp L=6e-08 W=5.4e-07
MI0_MXPB2_2 XI0_p1B B1 VDD VDD pm1p2_svt_lp L=6e-08 W=5.4e-07
MI0_MXPB2_3 XI0_p1B B1 VDD VDD pm1p2_svt_lp L=6e-08 W=5.4e-07
MI0_MXPA1 Y C0 VDD VDD pm1p2_svt_lp L=6e-08 W=4.6e-07
MI0_MXPA1_2 Y C0 VDD VDD pm1p2_svt_lp L=6e-08 W=4.6e-07
.ENDS

.SUBCKT OAI221X4H9R Y VDD VSS A0 A1 B0 B1 C0
MI0_MXNC2 XI0_n1 A1 VSS VSS nm1p2_svt_lp L=6e-08 W=4.95e-07
MI0_MXNC2_2 XI0_n1 A1 VSS VSS nm1p2_svt_lp L=6e-08 W=4.95e-07
MI0_MXNC2_3 XI0_n1 A1 VSS VSS nm1p2_svt_lp L=6e-08 W=4.95e-07
MI0_MXNC2_4 XI0_n1 A1 VSS VSS nm1p2_svt_lp L=6e-08 W=4.95e-07
MI0_MXNC1 XI0_n1 A0 VSS VSS nm1p2_svt_lp L=6e-08 W=4.95e-07
MI0_MXNC1_2 XI0_n1 A0 VSS VSS nm1p2_svt_lp L=6e-08 W=4.95e-07
MI0_MXNC1_3 XI0_n1 A0 VSS VSS nm1p2_svt_lp L=6e-08 W=4.95e-07
MI0_MXNC1_4 XI0_n1 A0 VSS VSS nm1p2_svt_lp L=6e-08 W=4.95e-07
MI0_MXNB1 XI0_n2 B0 XI0_n1 VSS nm1p2_svt_lp L=6e-08 W=4.95e-07
MI0_MXNB1_2 XI0_n2 B0 XI0_n1 VSS nm1p2_svt_lp L=6e-08 W=4.95e-07
MI0_MXNB1_3 XI0_n2 B0 XI0_n1 VSS nm1p2_svt_lp L=6e-08 W=4.95e-07
MI0_MXNB1_4 XI0_n2 B0 XI0_n1 VSS nm1p2_svt_lp L=6e-08 W=4.95e-07
MI0_MXNB2 XI0_n2 B1 XI0_n1 VSS nm1p2_svt_lp L=6e-08 W=4.95e-07
MI0_MXNB2_2 XI0_n2 B1 XI0_n1 VSS nm1p2_svt_lp L=6e-08 W=4.95e-07
MI0_MXNB2_3 XI0_n2 B1 XI0_n1 VSS nm1p2_svt_lp L=6e-08 W=4.95e-07
MI0_MXNB2_4 XI0_n2 B1 XI0_n1 VSS nm1p2_svt_lp L=6e-08 W=4.95e-07
MI0_MXNA1 Y C0 XI0_n2 VSS nm1p2_svt_lp L=6e-08 W=4.95e-07
MI0_MXNA1_2 Y C0 XI0_n2 VSS nm1p2_svt_lp L=6e-08 W=4.95e-07
MI0_MXNA1_3 Y C0 XI0_n2 VSS nm1p2_svt_lp L=6e-08 W=4.95e-07
MI0_MXNA1_4 Y C0 XI0_n2 VSS nm1p2_svt_lp L=6e-08 W=4.95e-07
MI0_MXPC2 XI0_p1C A1 VDD VDD pm1p2_svt_lp L=6e-08 W=5.4e-07
MI0_MXPC2_2 XI0_p1C A1 VDD VDD pm1p2_svt_lp L=6e-08 W=5.4e-07
MI0_MXPC2_3 XI0_p1C A1 VDD VDD pm1p2_svt_lp L=6e-08 W=5.4e-07
MI0_MXPC2_4 XI0_p1C A1 VDD VDD pm1p2_svt_lp L=6e-08 W=5.4e-07
MI0_MXPC1 Y A0 XI0_p1C VDD pm1p2_svt_lp L=6e-08 W=5.4e-07
MI0_MXPC1_2 Y A0 XI0_p1C VDD pm1p2_svt_lp L=6e-08 W=5.4e-07
MI0_MXPC1_3 Y A0 XI0_p1C VDD pm1p2_svt_lp L=6e-08 W=5.4e-07
MI0_MXPC1_4 Y A0 XI0_p1C VDD pm1p2_svt_lp L=6e-08 W=5.4e-07
MI0_MXPB1 Y B0 XI0_p1B VDD pm1p2_svt_lp L=6e-08 W=5.4e-07
MI0_MXPB1_2 Y B0 XI0_p1B VDD pm1p2_svt_lp L=6e-08 W=5.4e-07
MI0_MXPB1_3 Y B0 XI0_p1B VDD pm1p2_svt_lp L=6e-08 W=5.4e-07
MI0_MXPB1_4 Y B0 XI0_p1B VDD pm1p2_svt_lp L=6e-08 W=5.4e-07
MI0_MXPB2 XI0_p1B B1 VDD VDD pm1p2_svt_lp L=6e-08 W=5.4e-07
MI0_MXPB2_2 XI0_p1B B1 VDD VDD pm1p2_svt_lp L=6e-08 W=5.4e-07
MI0_MXPB2_3 XI0_p1B B1 VDD VDD pm1p2_svt_lp L=6e-08 W=5.4e-07
MI0_MXPB2_4 XI0_p1B B1 VDD VDD pm1p2_svt_lp L=6e-08 W=5.4e-07
MI0_MXPA1 Y C0 VDD VDD pm1p2_svt_lp L=6e-08 W=4.1e-07
MI0_MXPA1_2 Y C0 VDD VDD pm1p2_svt_lp L=6e-08 W=4.1e-07
MI0_MXPA1_3 Y C0 VDD VDD pm1p2_svt_lp L=6e-08 W=4.1e-07
.ENDS

.SUBCKT OAI222X0P5H9R Y VDD VSS A0 A1 B0 B1 C0 C1
MI0_MXNC2 XI0_n1 A1 VSS VSS nm1p2_svt_lp L=6e-08 W=2.5e-07
MI0_MXNC1 XI0_n1 A0 VSS VSS nm1p2_svt_lp L=6e-08 W=2.5e-07
MI0_MXNB1 XI0_n2 B0 XI0_n1 VSS nm1p2_svt_lp L=6e-08 W=2.5e-07
MI0_MXNB2 XI0_n2 B1 XI0_n1 VSS nm1p2_svt_lp L=6e-08 W=2.5e-07
MI0_MXNA2 Y C1 XI0_n2 VSS nm1p2_svt_lp L=6e-08 W=2.5e-07
MI0_MXNA1 Y C0 XI0_n2 VSS nm1p2_svt_lp L=6e-08 W=2.5e-07
MI0_MXPC2 XI0_p1C A1 VDD VDD pm1p2_svt_lp L=6e-08 W=2.7e-07
MI0_MXPC1 Y A0 XI0_p1C VDD pm1p2_svt_lp L=6e-08 W=2.7e-07
MI0_MXPB1 Y B0 XI0_p1B VDD pm1p2_svt_lp L=6e-08 W=2.7e-07
MI0_MXPB2 XI0_p1B B1 VDD VDD pm1p2_svt_lp L=6e-08 W=2.7e-07
MI0_MXPA2 XI0_p1A C1 VDD VDD pm1p2_svt_lp L=6e-08 W=2.7e-07
MI0_MXPA1 Y C0 XI0_p1A VDD pm1p2_svt_lp L=6e-08 W=2.7e-07
.ENDS

.SUBCKT OAI222X0P7H9R Y VDD VSS A0 A1 B0 B1 C0 C1
MI0_MXNC2 XI0_n1 A1 VSS VSS nm1p2_svt_lp L=6e-08 W=3.5e-07
MI0_MXNC1 XI0_n1 A0 VSS VSS nm1p2_svt_lp L=6e-08 W=3.5e-07
MI0_MXNB1 XI0_n2 B0 XI0_n1 VSS nm1p2_svt_lp L=6e-08 W=3.5e-07
MI0_MXNB2 XI0_n2 B1 XI0_n1 VSS nm1p2_svt_lp L=6e-08 W=3.5e-07
MI0_MXNA2 Y C1 XI0_n2 VSS nm1p2_svt_lp L=6e-08 W=3.5e-07
MI0_MXNA1 Y C0 XI0_n2 VSS nm1p2_svt_lp L=6e-08 W=3.5e-07
MI0_MXPC2 XI0_p1C A1 VDD VDD pm1p2_svt_lp L=6e-08 W=3.8e-07
MI0_MXPC1 Y A0 XI0_p1C VDD pm1p2_svt_lp L=6e-08 W=3.8e-07
MI0_MXPB1 Y B0 XI0_p1B VDD pm1p2_svt_lp L=6e-08 W=3.8e-07
MI0_MXPB2 XI0_p1B B1 VDD VDD pm1p2_svt_lp L=6e-08 W=3.8e-07
MI0_MXPA2 XI0_p1A C1 VDD VDD pm1p2_svt_lp L=6e-08 W=3.8e-07
MI0_MXPA1 Y C0 XI0_p1A VDD pm1p2_svt_lp L=6e-08 W=3.8e-07
.ENDS

.SUBCKT OAI222X1H9R Y VDD VSS A0 A1 B0 B1 C0 C1
MI0_MXNC2 XI0_n1 A1 VSS VSS nm1p2_svt_lp L=6e-08 W=4.95e-07
MI0_MXNC1 XI0_n1 A0 VSS VSS nm1p2_svt_lp L=6e-08 W=4.95e-07
MI0_MXNB1 XI0_n2 B0 XI0_n1 VSS nm1p2_svt_lp L=6e-08 W=4.95e-07
MI0_MXNB2 XI0_n2 B1 XI0_n1 VSS nm1p2_svt_lp L=6e-08 W=4.95e-07
MI0_MXNA2 Y C1 XI0_n2 VSS nm1p2_svt_lp L=6e-08 W=4.95e-07
MI0_MXNA1 Y C0 XI0_n2 VSS nm1p2_svt_lp L=6e-08 W=4.95e-07
MI0_MXPC2 XI0_p1C A1 VDD VDD pm1p2_svt_lp L=6e-08 W=5.4e-07
MI0_MXPC1 Y A0 XI0_p1C VDD pm1p2_svt_lp L=6e-08 W=5.4e-07
MI0_MXPB1 Y B0 XI0_p1B VDD pm1p2_svt_lp L=6e-08 W=5.4e-07
MI0_MXPB2 XI0_p1B B1 VDD VDD pm1p2_svt_lp L=6e-08 W=5.4e-07
MI0_MXPA2 XI0_p1A C1 VDD VDD pm1p2_svt_lp L=6e-08 W=5.4e-07
MI0_MXPA1 Y C0 XI0_p1A VDD pm1p2_svt_lp L=6e-08 W=5.4e-07
.ENDS

.SUBCKT OAI222X1P4H9R Y VDD VSS A0 A1 B0 B1 C0 C1
MI0_MXNC2 XI0_n1 A1 VSS VSS nm1p2_svt_lp L=6e-08 W=3.5e-07
MI0_MXNC2_2 XI0_n1 A1 VSS VSS nm1p2_svt_lp L=6e-08 W=3.5e-07
MI0_MXNC1 XI0_n1 A0 VSS VSS nm1p2_svt_lp L=6e-08 W=7e-07
MI0_MXNB2 XI0_n2 B1 XI0_n1 VSS nm1p2_svt_lp L=6e-08 W=7e-07
MI0_MXNB1 XI0_n2 B0 XI0_n1 VSS nm1p2_svt_lp L=6e-08 W=7e-07
MI0_MXNA2 Y C1 XI0_n2 VSS nm1p2_svt_lp L=6e-08 W=7e-07
MI0_MXNA1 Y C0 XI0_n2 VSS nm1p2_svt_lp L=6e-08 W=7e-07
MI0_MXPC2_2 XI0_p1C__2 A1 VDD VDD pm1p2_svt_lp L=6e-08 W=3.8e-07
MI0_MXPC1_2 Y A0 XI0_p1C__2 VDD pm1p2_svt_lp L=6e-08 W=3.8e-07
MI0_MXPC1 Y A0 XI0_p1C VDD pm1p2_svt_lp L=6e-08 W=3.8e-07
MI0_MXPC2 XI0_p1C A1 VDD VDD pm1p2_svt_lp L=6e-08 W=3.8e-07
MI0_MXPB2_2 XI0_p1B__2 B1 VDD VDD pm1p2_svt_lp L=6e-08 W=3.8e-07
MI0_MXPB1_2 Y B0 XI0_p1B__2 VDD pm1p2_svt_lp L=6e-08 W=3.8e-07
MI0_MXPB1 Y B0 XI0_p1B VDD pm1p2_svt_lp L=6e-08 W=3.8e-07
MI0_MXPB2 XI0_p1B B1 VDD VDD pm1p2_svt_lp L=6e-08 W=3.8e-07
MI0_MXPA2_2 XI0_p1A__2 C1 VDD VDD pm1p2_svt_lp L=6e-08 W=3.8e-07
MI0_MXPA1_2 Y C0 XI0_p1A__2 VDD pm1p2_svt_lp L=6e-08 W=3.8e-07
MI0_MXPA1 Y C0 XI0_p1A VDD pm1p2_svt_lp L=6e-08 W=3.8e-07
MI0_MXPA2 XI0_p1A C1 VDD VDD pm1p2_svt_lp L=6e-08 W=3.8e-07
.ENDS

.SUBCKT OAI222X2H9R Y VDD VSS A0 A1 B0 B1 C0 C1
MI0_MXNC2 XI0_n1 A1 VSS VSS nm1p2_svt_lp L=6e-08 W=4.95e-07
MI0_MXNC1 XI0_n1 A0 VSS VSS nm1p2_svt_lp L=6e-08 W=4.95e-07
MI0_MXNC1_2 XI0_n1 A0 VSS VSS nm1p2_svt_lp L=6e-08 W=4.95e-07
MI0_MXNC2_2 XI0_n1 A1 VSS VSS nm1p2_svt_lp L=6e-08 W=4.95e-07
MI0_MXNB2 XI0_n2 B1 XI0_n1 VSS nm1p2_svt_lp L=6e-08 W=4.95e-07
MI0_MXNB1 XI0_n2 B0 XI0_n1 VSS nm1p2_svt_lp L=6e-08 W=4.95e-07
MI0_MXNB1_2 XI0_n2 B0 XI0_n1 VSS nm1p2_svt_lp L=6e-08 W=4.95e-07
MI0_MXNB2_2 XI0_n2 B1 XI0_n1 VSS nm1p2_svt_lp L=6e-08 W=4.95e-07
MI0_MXNA2 Y C1 XI0_n2 VSS nm1p2_svt_lp L=6e-08 W=4.95e-07
MI0_MXNA1 Y C0 XI0_n2 VSS nm1p2_svt_lp L=6e-08 W=4.95e-07
MI0_MXNA1_2 Y C0 XI0_n2 VSS nm1p2_svt_lp L=6e-08 W=4.95e-07
MI0_MXNA2_2 Y C1 XI0_n2 VSS nm1p2_svt_lp L=6e-08 W=4.95e-07
MI0_MXPC2_2 XI0_p1C__2 A1 VDD VDD pm1p2_svt_lp L=6e-08 W=5.4e-07
MI0_MXPC1_2 Y A0 XI0_p1C__2 VDD pm1p2_svt_lp L=6e-08 W=5.4e-07
MI0_MXPC1 Y A0 XI0_p1C VDD pm1p2_svt_lp L=6e-08 W=5.4e-07
MI0_MXPC2 XI0_p1C A1 VDD VDD pm1p2_svt_lp L=6e-08 W=5.4e-07
MI0_MXPB2_2 XI0_p1B__2 B1 VDD VDD pm1p2_svt_lp L=6e-08 W=5.4e-07
MI0_MXPB1_2 Y B0 XI0_p1B__2 VDD pm1p2_svt_lp L=6e-08 W=5.4e-07
MI0_MXPB1 Y B0 XI0_p1B VDD pm1p2_svt_lp L=6e-08 W=5.4e-07
MI0_MXPB2 XI0_p1B B1 VDD VDD pm1p2_svt_lp L=6e-08 W=5.4e-07
MI0_MXPA2_2 XI0_p1A__2 C1 VDD VDD pm1p2_svt_lp L=6e-08 W=5.4e-07
MI0_MXPA1_2 Y C0 XI0_p1A__2 VDD pm1p2_svt_lp L=6e-08 W=5.4e-07
MI0_MXPA1 Y C0 XI0_p1A VDD pm1p2_svt_lp L=6e-08 W=5.4e-07
MI0_MXPA2 XI0_p1A C1 VDD VDD pm1p2_svt_lp L=6e-08 W=5.4e-07
.ENDS

.SUBCKT OAI222X3H9R Y VDD VSS A0 A1 B0 B1 C0 C1
MI0_MXNC2 XI0_n1 A1 VSS VSS nm1p2_svt_lp L=6e-08 W=4.95e-07
MI0_MXNC2_2 XI0_n1 A1 VSS VSS nm1p2_svt_lp L=6e-08 W=4.95e-07
MI0_MXNC2_3 XI0_n1 A1 VSS VSS nm1p2_svt_lp L=6e-08 W=4.95e-07
MI0_MXNC1 XI0_n1 A0 VSS VSS nm1p2_svt_lp L=6e-08 W=4.95e-07
MI0_MXNC1_2 XI0_n1 A0 VSS VSS nm1p2_svt_lp L=6e-08 W=4.95e-07
MI0_MXNC1_3 XI0_n1 A0 VSS VSS nm1p2_svt_lp L=6e-08 W=4.95e-07
MI0_MXNB1 XI0_n2 B0 XI0_n1 VSS nm1p2_svt_lp L=6e-08 W=4.95e-07
MI0_MXNB1_2 XI0_n2 B0 XI0_n1 VSS nm1p2_svt_lp L=6e-08 W=4.95e-07
MI0_MXNB1_3 XI0_n2 B0 XI0_n1 VSS nm1p2_svt_lp L=6e-08 W=4.95e-07
MI0_MXNB2 XI0_n2 B1 XI0_n1 VSS nm1p2_svt_lp L=6e-08 W=4.95e-07
MI0_MXNB2_2 XI0_n2 B1 XI0_n1 VSS nm1p2_svt_lp L=6e-08 W=4.95e-07
MI0_MXNB2_3 XI0_n2 B1 XI0_n1 VSS nm1p2_svt_lp L=6e-08 W=4.95e-07
MI0_MXNA2 Y C1 XI0_n2 VSS nm1p2_svt_lp L=6e-08 W=4.95e-07
MI0_MXNA2_2 Y C1 XI0_n2 VSS nm1p2_svt_lp L=6e-08 W=4.95e-07
MI0_MXNA2_3 Y C1 XI0_n2 VSS nm1p2_svt_lp L=6e-08 W=4.95e-07
MI0_MXNA1 Y C0 XI0_n2 VSS nm1p2_svt_lp L=6e-08 W=4.95e-07
MI0_MXNA1_2 Y C0 XI0_n2 VSS nm1p2_svt_lp L=6e-08 W=4.95e-07
MI0_MXNA1_3 Y C0 XI0_n2 VSS nm1p2_svt_lp L=6e-08 W=4.95e-07
MI0_MXPC2 XI0_p1C A1 VDD VDD pm1p2_svt_lp L=6e-08 W=5.4e-07
MI0_MXPC2_2 XI0_p1C A1 VDD VDD pm1p2_svt_lp L=6e-08 W=5.4e-07
MI0_MXPC2_3 XI0_p1C A1 VDD VDD pm1p2_svt_lp L=6e-08 W=5.4e-07
MI0_MXPC1 Y A0 XI0_p1C VDD pm1p2_svt_lp L=6e-08 W=5.4e-07
MI0_MXPC1_2 Y A0 XI0_p1C VDD pm1p2_svt_lp L=6e-08 W=5.4e-07
MI0_MXPC1_3 Y A0 XI0_p1C VDD pm1p2_svt_lp L=6e-08 W=5.4e-07
MI0_MXPB1 Y B0 XI0_p1B VDD pm1p2_svt_lp L=6e-08 W=5.4e-07
MI0_MXPB1_2 Y B0 XI0_p1B VDD pm1p2_svt_lp L=6e-08 W=5.4e-07
MI0_MXPB1_3 Y B0 XI0_p1B VDD pm1p2_svt_lp L=6e-08 W=5.4e-07
MI0_MXPB2 XI0_p1B B1 VDD VDD pm1p2_svt_lp L=6e-08 W=5.4e-07
MI0_MXPB2_2 XI0_p1B B1 VDD VDD pm1p2_svt_lp L=6e-08 W=5.4e-07
MI0_MXPB2_3 XI0_p1B B1 VDD VDD pm1p2_svt_lp L=6e-08 W=5.4e-07
MI0_MXPA2 XI0_p1A C1 VDD VDD pm1p2_svt_lp L=6e-08 W=5.4e-07
MI0_MXPA2_2 XI0_p1A C1 VDD VDD pm1p2_svt_lp L=6e-08 W=5.4e-07
MI0_MXPA2_3 XI0_p1A C1 VDD VDD pm1p2_svt_lp L=6e-08 W=5.4e-07
MI0_MXPA1 Y C0 XI0_p1A VDD pm1p2_svt_lp L=6e-08 W=5.4e-07
MI0_MXPA1_2 Y C0 XI0_p1A VDD pm1p2_svt_lp L=6e-08 W=5.4e-07
MI0_MXPA1_3 Y C0 XI0_p1A VDD pm1p2_svt_lp L=6e-08 W=5.4e-07
.ENDS

.SUBCKT OAI222X4H9R Y VDD VSS A0 A1 B0 B1 C0 C1
MI0_MXNC2 XI0_n1 A1 VSS VSS nm1p2_svt_lp L=6e-08 W=4.95e-07
MI0_MXNC1 XI0_n1 A0 VSS VSS nm1p2_svt_lp L=6e-08 W=4.95e-07
MI0_MXNC1_2 XI0_n1 A0 VSS VSS nm1p2_svt_lp L=6e-08 W=4.95e-07
MI0_MXNC2_2 XI0_n1 A1 VSS VSS nm1p2_svt_lp L=6e-08 W=4.95e-07
MI0_MXNC2_3 XI0_n1 A1 VSS VSS nm1p2_svt_lp L=6e-08 W=4.95e-07
MI0_MXNC1_3 XI0_n1 A0 VSS VSS nm1p2_svt_lp L=6e-08 W=4.95e-07
MI0_MXNC1_4 XI0_n1 A0 VSS VSS nm1p2_svt_lp L=6e-08 W=4.95e-07
MI0_MXNC2_4 XI0_n1 A1 VSS VSS nm1p2_svt_lp L=6e-08 W=4.95e-07
MI0_MXNB2 XI0_n2 B1 XI0_n1 VSS nm1p2_svt_lp L=6e-08 W=4.95e-07
MI0_MXNB1 XI0_n2 B0 XI0_n1 VSS nm1p2_svt_lp L=6e-08 W=4.95e-07
MI0_MXNB1_2 XI0_n2 B0 XI0_n1 VSS nm1p2_svt_lp L=6e-08 W=4.95e-07
MI0_MXNB2_2 XI0_n2 B1 XI0_n1 VSS nm1p2_svt_lp L=6e-08 W=4.95e-07
MI0_MXNB2_3 XI0_n2 B1 XI0_n1 VSS nm1p2_svt_lp L=6e-08 W=4.95e-07
MI0_MXNB1_3 XI0_n2 B0 XI0_n1 VSS nm1p2_svt_lp L=6e-08 W=4.95e-07
MI0_MXNB1_4 XI0_n2 B0 XI0_n1 VSS nm1p2_svt_lp L=6e-08 W=4.95e-07
MI0_MXNB2_4 XI0_n2 B1 XI0_n1 VSS nm1p2_svt_lp L=6e-08 W=4.95e-07
MI0_MXNA2 Y C1 XI0_n2 VSS nm1p2_svt_lp L=6e-08 W=4.95e-07
MI0_MXNA1 Y C0 XI0_n2 VSS nm1p2_svt_lp L=6e-08 W=4.95e-07
MI0_MXNA1_2 Y C0 XI0_n2 VSS nm1p2_svt_lp L=6e-08 W=4.95e-07
MI0_MXNA2_2 Y C1 XI0_n2 VSS nm1p2_svt_lp L=6e-08 W=4.95e-07
MI0_MXNA2_3 Y C1 XI0_n2 VSS nm1p2_svt_lp L=6e-08 W=4.95e-07
MI0_MXNA1_3 Y C0 XI0_n2 VSS nm1p2_svt_lp L=6e-08 W=4.95e-07
MI0_MXNA1_4 Y C0 XI0_n2 VSS nm1p2_svt_lp L=6e-08 W=4.95e-07
MI0_MXNA2_4 Y C1 XI0_n2 VSS nm1p2_svt_lp L=6e-08 W=4.95e-07
MI0_MXPC2_2 XI0_p1C__2 A1 VDD VDD pm1p2_svt_lp L=6e-08 W=5.4e-07
MI0_MXPC1_2 Y A0 XI0_p1C__2 VDD pm1p2_svt_lp L=6e-08 W=5.4e-07
MI0_MXPC1_3 Y A0 XI0_p1C__3 VDD pm1p2_svt_lp L=6e-08 W=5.4e-07
MI0_MXPC2_3 XI0_p1C__3 A1 VDD VDD pm1p2_svt_lp L=6e-08 W=5.4e-07
MI0_MXPC2_4 XI0_p1C__4 A1 VDD VDD pm1p2_svt_lp L=6e-08 W=5.4e-07
MI0_MXPC1_4 Y A0 XI0_p1C__4 VDD pm1p2_svt_lp L=6e-08 W=5.4e-07
MI0_MXPC1 Y A0 XI0_p1C VDD pm1p2_svt_lp L=6e-08 W=5.4e-07
MI0_MXPC2 XI0_p1C A1 VDD VDD pm1p2_svt_lp L=6e-08 W=5.4e-07
MI0_MXPB2_2 XI0_p1B__2 B1 VDD VDD pm1p2_svt_lp L=6e-08 W=5.4e-07
MI0_MXPB1_2 Y B0 XI0_p1B__2 VDD pm1p2_svt_lp L=6e-08 W=5.4e-07
MI0_MXPB1_3 Y B0 XI0_p1B__3 VDD pm1p2_svt_lp L=6e-08 W=5.4e-07
MI0_MXPB2_3 XI0_p1B__3 B1 VDD VDD pm1p2_svt_lp L=6e-08 W=5.4e-07
MI0_MXPB2_4 XI0_p1B__4 B1 VDD VDD pm1p2_svt_lp L=6e-08 W=5.4e-07
MI0_MXPB1_4 Y B0 XI0_p1B__4 VDD pm1p2_svt_lp L=6e-08 W=5.4e-07
MI0_MXPB1 Y B0 XI0_p1B VDD pm1p2_svt_lp L=6e-08 W=5.4e-07
MI0_MXPB2 XI0_p1B B1 VDD VDD pm1p2_svt_lp L=6e-08 W=5.4e-07
MI0_MXPA2_2 XI0_p1A__2 C1 VDD VDD pm1p2_svt_lp L=6e-08 W=5.4e-07
MI0_MXPA1_2 Y C0 XI0_p1A__2 VDD pm1p2_svt_lp L=6e-08 W=5.4e-07
MI0_MXPA1_3 Y C0 XI0_p1A__3 VDD pm1p2_svt_lp L=6e-08 W=5.4e-07
MI0_MXPA2_3 XI0_p1A__3 C1 VDD VDD pm1p2_svt_lp L=6e-08 W=5.4e-07
MI0_MXPA2_4 XI0_p1A__4 C1 VDD VDD pm1p2_svt_lp L=6e-08 W=5.4e-07
MI0_MXPA1_4 Y C0 XI0_p1A__4 VDD pm1p2_svt_lp L=6e-08 W=5.4e-07
MI0_MXPA1 Y C0 XI0_p1A VDD pm1p2_svt_lp L=6e-08 W=5.4e-07
MI0_MXPA2 XI0_p1A C1 VDD VDD pm1p2_svt_lp L=6e-08 W=5.4e-07
.ENDS

.SUBCKT OAI31X0P5H9R Y VDD VSS A0 A1 A2 B0
MXNA2 n1 A2 VSS VSS nm1p2_svt_lp L=6e-08 W=1.5e-07
MXNA1 n1 A1 VSS VSS nm1p2_svt_lp L=6e-08 W=1.5e-07
MXNA0 n1 A0 VSS VSS nm1p2_svt_lp L=6e-08 W=1.5e-07
MXNB0 Y B0 n1 VSS nm1p2_svt_lp L=6e-08 W=1.5e-07
MXPA2 net46 A2 VDD VDD pm1p2_svt_lp L=6e-08 W=2.95e-07
MXPA1 net38 A1 net46 VDD pm1p2_svt_lp L=6e-08 W=2.95e-07
MXPA0 Y A0 net38 VDD pm1p2_svt_lp L=6e-08 W=2.95e-07
MXPB0 Y B0 VDD VDD pm1p2_svt_lp L=6e-08 W=1.5e-07
.ENDS

.SUBCKT OAI31X0P7H9R Y VDD VSS A0 A1 A2 B0
MXNA2 n1 A2 VSS VSS nm1p2_svt_lp L=6e-08 W=2.1e-07
MXNA1 n1 A1 VSS VSS nm1p2_svt_lp L=6e-08 W=2.1e-07
MXNA0 n1 A0 VSS VSS nm1p2_svt_lp L=6e-08 W=2.1e-07
MXNB0 Y B0 n1 VSS nm1p2_svt_lp L=6e-08 W=2.1e-07
MXPA2 net42 A2 VDD VDD pm1p2_svt_lp L=6e-08 W=4.15e-07
MXPA1 net039 A1 net42 VDD pm1p2_svt_lp L=6e-08 W=4.15e-07
MXPA0 Y A0 net039 VDD pm1p2_svt_lp L=6e-08 W=4.15e-07
MXPB0 Y B0 VDD VDD pm1p2_svt_lp L=6e-08 W=1.65e-07
.ENDS

.SUBCKT OAI31X1H9R Y VDD VSS A0 A1 A2 B0
MXNA2 n1 A2 VSS VSS nm1p2_svt_lp L=6e-08 W=2.95e-07
MXNA1 n1 A1 VSS VSS nm1p2_svt_lp L=6e-08 W=2.95e-07
MXNA0 n1 A0 VSS VSS nm1p2_svt_lp L=6e-08 W=2.95e-07
MXNB0 Y B0 n1 VSS nm1p2_svt_lp L=6e-08 W=2.95e-07
MXPA2 net42 A2 VDD VDD pm1p2_svt_lp L=6e-08 W=5.85e-07
MXPA1 net039 A1 net42 VDD pm1p2_svt_lp L=6e-08 W=5.85e-07
MXPA0 Y A0 net039 VDD pm1p2_svt_lp L=6e-08 W=5.85e-07
MXPB0 Y B0 VDD VDD pm1p2_svt_lp L=6e-08 W=2.35e-07
.ENDS

.SUBCKT OAI31X1P4H9R Y VDD VSS A0 A1 A2 B0
MXNA0 n1 A0 VSS VSS nm1p2_svt_lp L=6e-08 W=4.1e-07
MXNA1 n1 A1 VSS VSS nm1p2_svt_lp L=6e-08 W=4.1e-07
MXNA2 n1 A2 VSS VSS nm1p2_svt_lp L=6e-08 W=4.1e-07
MXNB0 Y B0 n1 VSS nm1p2_svt_lp L=6e-08 W=4.1e-07
MXPA2_2 net42__2 A2 VDD VDD pm1p2_svt_lp L=6e-08 W=4.15e-07
MXPA1_2 net039__2 A1 net42__2 VDD pm1p2_svt_lp L=6e-08 W=4.15e-07
MXPA0_2 Y A0 net039__2 VDD pm1p2_svt_lp L=6e-08 W=4.15e-07
MXPA0 Y A0 net039 VDD pm1p2_svt_lp L=6e-08 W=4.15e-07
MXPA1 net039 A1 net42 VDD pm1p2_svt_lp L=6e-08 W=4.15e-07
MXPA2 net42 A2 VDD VDD pm1p2_svt_lp L=6e-08 W=4.15e-07
MXPB0 Y B0 VDD VDD pm1p2_svt_lp L=6e-08 W=3.35e-07
.ENDS

.SUBCKT OAI31X2H9R Y VDD VSS A0 A1 A2 B0
MXNA2 n1 A2 VSS VSS nm1p2_svt_lp L=6e-08 W=2.95e-07
MXNA2_2 n1 A2 VSS VSS nm1p2_svt_lp L=6e-08 W=2.95e-07
MXNA1 n1 A1 VSS VSS nm1p2_svt_lp L=6e-08 W=2.95e-07
MXNA0 n1 A0 VSS VSS nm1p2_svt_lp L=6e-08 W=2.95e-07
MXNA0_2 n1 A0 VSS VSS nm1p2_svt_lp L=6e-08 W=2.95e-07
MXNA1_2 n1 A1 VSS VSS nm1p2_svt_lp L=6e-08 W=2.95e-07
MXNB0 Y B0 n1 VSS nm1p2_svt_lp L=6e-08 W=2.95e-07
MXNB0_2 Y B0 n1 VSS nm1p2_svt_lp L=6e-08 W=2.95e-07
MXPA2 net42 A2 VDD VDD pm1p2_svt_lp L=6e-08 W=5.85e-07
MXPA2_2 net42 A2 VDD VDD pm1p2_svt_lp L=6e-08 W=5.85e-07
MXPA1_2 net039__2 A1 net42 VDD pm1p2_svt_lp L=6e-08 W=5.85e-07
MXPA0_2 Y A0 net039__2 VDD pm1p2_svt_lp L=6e-08 W=5.85e-07
MXPA0 Y A0 net039 VDD pm1p2_svt_lp L=6e-08 W=5.85e-07
MXPA1 net039 A1 net42 VDD pm1p2_svt_lp L=6e-08 W=5.85e-07
MXPB0 Y B0 VDD VDD pm1p2_svt_lp L=6e-08 W=4.7e-07
.ENDS

.SUBCKT OAI31X3H9R Y VDD VSS A0 A1 A2 B0
MXNA2 n1 A2 VSS VSS nm1p2_svt_lp L=6e-08 W=2.95e-07
MXNA2_2 n1 A2 VSS VSS nm1p2_svt_lp L=6e-08 W=2.95e-07
MXNA2_3 n1 A2 VSS VSS nm1p2_svt_lp L=6e-08 W=2.95e-07
MXNA1 n1 A1 VSS VSS nm1p2_svt_lp L=6e-08 W=2.95e-07
MXNA1_2 n1 A1 VSS VSS nm1p2_svt_lp L=6e-08 W=2.95e-07
MXNA1_3 n1 A1 VSS VSS nm1p2_svt_lp L=6e-08 W=2.95e-07
MXNA0 n1 A0 VSS VSS nm1p2_svt_lp L=6e-08 W=2.95e-07
MXNA0_2 n1 A0 VSS VSS nm1p2_svt_lp L=6e-08 W=2.95e-07
MXNA0_3 n1 A0 VSS VSS nm1p2_svt_lp L=6e-08 W=2.95e-07
MXNB0 Y B0 n1 VSS nm1p2_svt_lp L=6e-08 W=2.95e-07
MXNB0_2 Y B0 n1 VSS nm1p2_svt_lp L=6e-08 W=2.95e-07
MXNB0_3 Y B0 n1 VSS nm1p2_svt_lp L=6e-08 W=2.95e-07
MXPA2 net42 A2 VDD VDD pm1p2_svt_lp L=6e-08 W=5.85e-07
MXPA2_2 net42 A2 VDD VDD pm1p2_svt_lp L=6e-08 W=5.85e-07
MXPA2_3 net42 A2 VDD VDD pm1p2_svt_lp L=6e-08 W=5.85e-07
MXPA1 net039 A1 net42 VDD pm1p2_svt_lp L=6e-08 W=5.85e-07
MXPA1_2 net039 A1 net42 VDD pm1p2_svt_lp L=6e-08 W=5.85e-07
MXPA1_3 net039 A1 net42 VDD pm1p2_svt_lp L=6e-08 W=5.85e-07
MXPA0 Y A0 net039 VDD pm1p2_svt_lp L=6e-08 W=5.85e-07
MXPA0_2 Y A0 net039 VDD pm1p2_svt_lp L=6e-08 W=5.85e-07
MXPA0_3 Y A0 net039 VDD pm1p2_svt_lp L=6e-08 W=5.85e-07
MXPB0 Y B0 VDD VDD pm1p2_svt_lp L=6e-08 W=2.35e-07
MXPB0_2 Y B0 VDD VDD pm1p2_svt_lp L=6e-08 W=2.35e-07
MXPB0_3 Y B0 VDD VDD pm1p2_svt_lp L=6e-08 W=2.35e-07
.ENDS

.SUBCKT OAI31X4H9R Y VDD VSS A0 A1 A2 B0
MXNA2 n1 A2 VSS VSS nm1p2_svt_lp L=6e-08 W=2.95e-07
MXNA2_2 n1 A2 VSS VSS nm1p2_svt_lp L=6e-08 W=2.95e-07
MXNA2_3 n1 A2 VSS VSS nm1p2_svt_lp L=6e-08 W=2.95e-07
MXNA2_4 n1 A2 VSS VSS nm1p2_svt_lp L=6e-08 W=2.95e-07
MXNA1 n1 A1 VSS VSS nm1p2_svt_lp L=6e-08 W=2.95e-07
MXNA1_2 n1 A1 VSS VSS nm1p2_svt_lp L=6e-08 W=2.95e-07
MXNA1_3 n1 A1 VSS VSS nm1p2_svt_lp L=6e-08 W=2.95e-07
MXNA1_4 n1 A1 VSS VSS nm1p2_svt_lp L=6e-08 W=2.95e-07
MXNA0 n1 A0 VSS VSS nm1p2_svt_lp L=6e-08 W=2.95e-07
MXNA0_2 n1 A0 VSS VSS nm1p2_svt_lp L=6e-08 W=2.95e-07
MXNA0_3 n1 A0 VSS VSS nm1p2_svt_lp L=6e-08 W=2.95e-07
MXNA0_4 n1 A0 VSS VSS nm1p2_svt_lp L=6e-08 W=2.95e-07
MXNB0 Y B0 n1 VSS nm1p2_svt_lp L=6e-08 W=3.95e-07
MXNB0_2 Y B0 n1 VSS nm1p2_svt_lp L=6e-08 W=3.95e-07
MXNB0_3 Y B0 n1 VSS nm1p2_svt_lp L=6e-08 W=3.95e-07
MXPA2 net42 A2 VDD VDD pm1p2_svt_lp L=6e-08 W=5.85e-07
MXPA2_2 net42 A2 VDD VDD pm1p2_svt_lp L=6e-08 W=5.85e-07
MXPA2_3 net42 A2 VDD VDD pm1p2_svt_lp L=6e-08 W=5.85e-07
MXPA2_4 net42 A2 VDD VDD pm1p2_svt_lp L=6e-08 W=5.85e-07
MXPA1 net039 A1 net42 VDD pm1p2_svt_lp L=6e-08 W=5.85e-07
MXPA1_2 net039 A1 net42 VDD pm1p2_svt_lp L=6e-08 W=5.85e-07
MXPA1_3 net039 A1 net42 VDD pm1p2_svt_lp L=6e-08 W=5.85e-07
MXPA1_4 net039 A1 net42 VDD pm1p2_svt_lp L=6e-08 W=5.85e-07
MXPA0 Y A0 net039 VDD pm1p2_svt_lp L=6e-08 W=5.85e-07
MXPA0_2 Y A0 net039 VDD pm1p2_svt_lp L=6e-08 W=5.85e-07
MXPA0_3 Y A0 net039 VDD pm1p2_svt_lp L=6e-08 W=5.85e-07
MXPA0_4 Y A0 net039 VDD pm1p2_svt_lp L=6e-08 W=5.85e-07
MXPB0 Y B0 VDD VDD pm1p2_svt_lp L=6e-08 W=4.75e-07
MXPB0_2 Y B0 VDD VDD pm1p2_svt_lp L=6e-08 W=4.75e-07
.ENDS

.SUBCKT OAI31X6H9R Y VDD VSS A0 A1 A2 B0
MXNA2 n1 A2 VSS VSS nm1p2_svt_lp L=6e-08 W=4.45e-07
MXNA2_2 n1 A2 VSS VSS nm1p2_svt_lp L=6e-08 W=4.45e-07
MXNA2_3 n1 A2 VSS VSS nm1p2_svt_lp L=6e-08 W=4.45e-07
MXNA2_4 n1 A2 VSS VSS nm1p2_svt_lp L=6e-08 W=4.45e-07
MXNA0 n1 A0 VSS VSS nm1p2_svt_lp L=6e-08 W=4.45e-07
MXNA0_2 n1 A0 VSS VSS nm1p2_svt_lp L=6e-08 W=4.45e-07
MXNA1 n1 A1 VSS VSS nm1p2_svt_lp L=6e-08 W=4.45e-07
MXNA1_2 n1 A1 VSS VSS nm1p2_svt_lp L=6e-08 W=4.45e-07
MXNA0_3 n1 A0 VSS VSS nm1p2_svt_lp L=6e-08 W=4.45e-07
MXNA0_4 n1 A0 VSS VSS nm1p2_svt_lp L=6e-08 W=4.45e-07
MXNA1_3 n1 A1 VSS VSS nm1p2_svt_lp L=6e-08 W=4.45e-07
MXNA1_4 n1 A1 VSS VSS nm1p2_svt_lp L=6e-08 W=4.45e-07
MXNB0 Y B0 n1 VSS nm1p2_svt_lp L=6e-08 W=4.45e-07
MXNB0_2 Y B0 n1 VSS nm1p2_svt_lp L=6e-08 W=4.45e-07
MXNB0_3 Y B0 n1 VSS nm1p2_svt_lp L=6e-08 W=4.45e-07
MXNB0_4 Y B0 n1 VSS nm1p2_svt_lp L=6e-08 W=4.45e-07
MXPA2 net42 A2 VDD VDD pm1p2_svt_lp L=6e-08 W=5.85e-07
MXPA2_2 net42 A2 VDD VDD pm1p2_svt_lp L=6e-08 W=5.85e-07
MXPA2_3 net42 A2 VDD VDD pm1p2_svt_lp L=6e-08 W=5.85e-07
MXPA2_4 net42 A2 VDD VDD pm1p2_svt_lp L=6e-08 W=5.85e-07
MXPA2_5 net42 A2 VDD VDD pm1p2_svt_lp L=6e-08 W=5.85e-07
MXPA2_6 net42 A2 VDD VDD pm1p2_svt_lp L=6e-08 W=5.85e-07
MXPA1_2 net039__2 A1 net42 VDD pm1p2_svt_lp L=6e-08 W=5.85e-07
MXPA0_2 Y A0 net039__2 VDD pm1p2_svt_lp L=6e-08 W=5.85e-07
MXPA0_3 Y A0 net039__3 VDD pm1p2_svt_lp L=6e-08 W=5.85e-07
MXPA1_3 net039__3 A1 net42 VDD pm1p2_svt_lp L=6e-08 W=5.85e-07
MXPA1_4 net039__4 A1 net42 VDD pm1p2_svt_lp L=6e-08 W=5.85e-07
MXPA0_4 Y A0 net039__4 VDD pm1p2_svt_lp L=6e-08 W=5.85e-07
MXPA0_5 Y A0 net039__5 VDD pm1p2_svt_lp L=6e-08 W=5.85e-07
MXPA1_5 net039__5 A1 net42 VDD pm1p2_svt_lp L=6e-08 W=5.85e-07
MXPA1_6 net039__6 A1 net42 VDD pm1p2_svt_lp L=6e-08 W=5.85e-07
MXPA0_6 Y A0 net039__6 VDD pm1p2_svt_lp L=6e-08 W=5.85e-07
MXPA0 Y A0 net039 VDD pm1p2_svt_lp L=6e-08 W=5.85e-07
MXPA1 net039 A1 net42 VDD pm1p2_svt_lp L=6e-08 W=5.85e-07
MXPB0 Y B0 VDD VDD pm1p2_svt_lp L=6e-08 W=4.7e-07
MXPB0_2 Y B0 VDD VDD pm1p2_svt_lp L=6e-08 W=4.7e-07
MXPB0_3 Y B0 VDD VDD pm1p2_svt_lp L=6e-08 W=4.7e-07
.ENDS

.SUBCKT ADDHX1H9R CO S VDD VSS A B
MI3_MXNA1 CO nco VSS VSS nm1p2_svt_lp L=6e-08 W=4.2e-07
MI0_MXNA2 XI0_n1 B VSS VSS nm1p2_svt_lp L=6e-08 W=4.6e-07
MI0_MXNA1 nco A XI0_n1 VSS nm1p2_svt_lp L=6e-08 W=4.6e-07
MI1_MXNB2 XI1_n1 B VSS VSS nm1p2_svt_lp L=6e-08 W=3.6e-07
MI1_MXNB1 XI1_n1 A VSS VSS nm1p2_svt_lp L=6e-08 W=3.6e-07
MI1_MXNA1 ns nco XI1_n1 VSS nm1p2_svt_lp L=6e-08 W=3.6e-07
MI2_MXNA1 S ns VSS VSS nm1p2_svt_lp L=6e-08 W=4.2e-07
MI3_MXPA1 CO nco VDD VDD pm1p2_svt_lp L=6e-08 W=5.85e-07
MI0_MXPA2 nco B VDD VDD pm1p2_svt_lp L=6e-08 W=4.9e-07
MI0_MXPA1 nco A VDD VDD pm1p2_svt_lp L=6e-08 W=4.9e-07
MI1_MXPB2 XI1_p1 B VDD VDD pm1p2_svt_lp L=6e-08 W=5.2e-07
MI1_MXPB1 ns A XI1_p1 VDD pm1p2_svt_lp L=6e-08 W=5.2e-07
MI1_MXPA1 ns nco VDD VDD pm1p2_svt_lp L=6e-08 W=3.5e-07
MI2_MXPA1 S ns VDD VDD pm1p2_svt_lp L=6e-08 W=5.85e-07
.ENDS

.SUBCKT ADDHX1P4H9R CO S VDD VSS A B
MI3_MXNA1 CO nco VSS VSS nm1p2_svt_lp L=6e-08 W=2.95e-07
MI3_MXNA1_2 CO nco VSS VSS nm1p2_svt_lp L=6e-08 W=2.95e-07
MI0_MXNA2 XI0_n1 B VSS VSS nm1p2_svt_lp L=6e-08 W=4.95e-07
MI0_MXNA1 nco A XI0_n1 VSS nm1p2_svt_lp L=6e-08 W=4.95e-07
MI1_MXNB2 XI1_n1 B VSS VSS nm1p2_svt_lp L=6e-08 W=4e-07
MI1_MXNB1 XI1_n1 A VSS VSS nm1p2_svt_lp L=6e-08 W=4e-07
MI1_MXNA1 ns nco XI1_n1 VSS nm1p2_svt_lp L=6e-08 W=4e-07
MI2_MXNA1 S ns VSS VSS nm1p2_svt_lp L=6e-08 W=2.95e-07
MI2_MXNA1_2 S ns VSS VSS nm1p2_svt_lp L=6e-08 W=2.95e-07
MI3_MXPA1 CO nco VDD VDD pm1p2_svt_lp L=6e-08 W=4.15e-07
MI3_MXPA1_2 CO nco VDD VDD pm1p2_svt_lp L=6e-08 W=4.15e-07
MI0_MXPA2 nco B VDD VDD pm1p2_svt_lp L=6e-08 W=5.85e-07
MI0_MXPA1 nco A VDD VDD pm1p2_svt_lp L=6e-08 W=5.85e-07
MI1_MXPB2 XI1_p1 B VDD VDD pm1p2_svt_lp L=6e-08 W=5.85e-07
MI1_MXPB1 ns A XI1_p1 VDD pm1p2_svt_lp L=6e-08 W=5.85e-07
MI1_MXPA1 ns nco VDD VDD pm1p2_svt_lp L=6e-08 W=3.9e-07
MI2_MXPA1 S ns VDD VDD pm1p2_svt_lp L=6e-08 W=4.15e-07
MI2_MXPA1_2 S ns VDD VDD pm1p2_svt_lp L=6e-08 W=4.15e-07
.ENDS

.SUBCKT ADDHX2H9R CO S VDD VSS A B
MI3_MXNA1 CO nco VSS VSS nm1p2_svt_lp L=6e-08 W=4.2e-07
MI3_MXNA1_2 CO nco VSS VSS nm1p2_svt_lp L=6e-08 W=4.2e-07
MI0_MXNA2 XI0_n1 B VSS VSS nm1p2_svt_lp L=6e-08 W=4.95e-07
MI0_MXNA1 nco A XI0_n1 VSS nm1p2_svt_lp L=6e-08 W=4.95e-07
MI1_MXNB2 XI1_n1 B VSS VSS nm1p2_svt_lp L=6e-08 W=4e-07
MI1_MXNB1 XI1_n1 A VSS VSS nm1p2_svt_lp L=6e-08 W=4e-07
MI1_MXNA1 ns nco XI1_n1 VSS nm1p2_svt_lp L=6e-08 W=4e-07
MI2_MXNA1 S ns VSS VSS nm1p2_svt_lp L=6e-08 W=4.2e-07
MI2_MXNA1_2 S ns VSS VSS nm1p2_svt_lp L=6e-08 W=4.2e-07
MI3_MXPA1 CO nco VDD VDD pm1p2_svt_lp L=6e-08 W=5.85e-07
MI3_MXPA1_2 CO nco VDD VDD pm1p2_svt_lp L=6e-08 W=5.85e-07
MI0_MXPA2 nco B VDD VDD pm1p2_svt_lp L=6e-08 W=5.85e-07
MI0_MXPA1 nco A VDD VDD pm1p2_svt_lp L=6e-08 W=5.85e-07
MI1_MXPB2 XI1_p1 B VDD VDD pm1p2_svt_lp L=6e-08 W=5.85e-07
MI1_MXPB1 ns A XI1_p1 VDD pm1p2_svt_lp L=6e-08 W=5.85e-07
MI1_MXPA1 ns nco VDD VDD pm1p2_svt_lp L=6e-08 W=3.9e-07
MI2_MXPA1 S ns VDD VDD pm1p2_svt_lp L=6e-08 W=5.85e-07
MI2_MXPA1_2 S ns VDD VDD pm1p2_svt_lp L=6e-08 W=5.85e-07
.ENDS

.SUBCKT ADDFX1H9R CO S VDD VSS A B CI
MI0_MXNA1 CO nco VSS VSS nm1p2_svt_lp L=6e-08 W=4.2e-07
MXN1 n1 A VSS VSS nm1p2_svt_lp L=6e-08 W=3.6e-07
MXN2 n1 B VSS VSS nm1p2_svt_lp L=6e-08 W=3.6e-07
MXN4 net34 B VSS VSS nm1p2_svt_lp L=6e-08 W=3.6e-07
MXN3 nco A net34 VSS nm1p2_svt_lp L=6e-08 W=3.6e-07
MXN0 nco CI n1 VSS nm1p2_svt_lp L=6e-08 W=3.6e-07
MXN6 n2 CI VSS VSS nm1p2_svt_lp L=6e-08 W=2.7e-07
MXN7 n2 A VSS VSS nm1p2_svt_lp L=6e-08 W=2.7e-07
MXN8 n2 B VSS VSS nm1p2_svt_lp L=6e-08 W=2.7e-07
MXN5 ns nco n2 VSS nm1p2_svt_lp L=6e-08 W=2.7e-07
MXN9 ns CI net49 VSS nm1p2_svt_lp L=6e-08 W=3.2e-07
MXN10 net49 A net46 VSS nm1p2_svt_lp L=6e-08 W=3.2e-07
MXN11 net46 B VSS VSS nm1p2_svt_lp L=6e-08 W=3.2e-07
MI1_MXNA1 S ns VSS VSS nm1p2_svt_lp L=6e-08 W=4.2e-07
MI0_MXPA1 CO nco VDD VDD pm1p2_svt_lp L=6e-08 W=5.85e-07
MXP1 p1 A VDD VDD pm1p2_svt_lp L=6e-08 W=5e-07
MXP2 p1 B VDD VDD pm1p2_svt_lp L=6e-08 W=5e-07
MXP4 net69 B VDD VDD pm1p2_svt_lp L=6e-08 W=5e-07
MXP3 nco A net69 VDD pm1p2_svt_lp L=6e-08 W=5e-07
MXP0 nco CI p1 VDD pm1p2_svt_lp L=6e-08 W=5e-07
MXP6 p2 CI VDD VDD pm1p2_svt_lp L=6e-08 W=3.6e-07
MXP7 p2 A VDD VDD pm1p2_svt_lp L=6e-08 W=3.6e-07
MXP8 p2 B VDD VDD pm1p2_svt_lp L=6e-08 W=3.6e-07
MXP5 ns nco p2 VDD pm1p2_svt_lp L=6e-08 W=3.6e-07
MXP9 ns CI net87 VDD pm1p2_svt_lp L=6e-08 W=4.2e-07
MXP10 net87 A net84 VDD pm1p2_svt_lp L=6e-08 W=4.2e-07
MXP11 net84 B VDD VDD pm1p2_svt_lp L=6e-08 W=4.2e-07
MI1_MXPA1 S ns VDD VDD pm1p2_svt_lp L=6e-08 W=5.85e-07
.ENDS

.SUBCKT ADDFX1P4H9R CO S VDD VSS A B CI
MI0_MXNA1 CO nco VSS VSS nm1p2_svt_lp L=6e-08 W=2.95e-07
MI0_MXNA1_2 CO nco VSS VSS nm1p2_svt_lp L=6e-08 W=2.95e-07
MXN1 n1 A VSS VSS nm1p2_svt_lp L=6e-08 W=4.2e-07
MXN2 n1 B VSS VSS nm1p2_svt_lp L=6e-08 W=4.2e-07
MXN4 net34 B VSS VSS nm1p2_svt_lp L=6e-08 W=4.2e-07
MXN3 nco A net34 VSS nm1p2_svt_lp L=6e-08 W=4.2e-07
MXN0 nco CI n1 VSS nm1p2_svt_lp L=6e-08 W=4.2e-07
MXN6 n2 CI VSS VSS nm1p2_svt_lp L=6e-08 W=3.6e-07
MXN7 n2 A VSS VSS nm1p2_svt_lp L=6e-08 W=3.6e-07
MXN8 n2 B VSS VSS nm1p2_svt_lp L=6e-08 W=3.6e-07
MXN5 ns nco n2 VSS nm1p2_svt_lp L=6e-08 W=3.6e-07
MXN9 ns CI net49 VSS nm1p2_svt_lp L=6e-08 W=3.8e-07
MXN10 net49 A net46 VSS nm1p2_svt_lp L=6e-08 W=3.8e-07
MXN11 net46 B VSS VSS nm1p2_svt_lp L=6e-08 W=3.8e-07
MI1_MXNA1 S ns VSS VSS nm1p2_svt_lp L=6e-08 W=2.95e-07
MI1_MXNA1_2 S ns VSS VSS nm1p2_svt_lp L=6e-08 W=2.95e-07
MI0_MXPA1 CO nco VDD VDD pm1p2_svt_lp L=6e-08 W=4.1e-07
MI0_MXPA1_2 CO nco VDD VDD pm1p2_svt_lp L=6e-08 W=4.1e-07
MXP1 p1 A VDD VDD pm1p2_svt_lp L=6e-08 W=5.85e-07
MXP2 p1 B VDD VDD pm1p2_svt_lp L=6e-08 W=5.85e-07
MXP4 net69 B VDD VDD pm1p2_svt_lp L=6e-08 W=5.85e-07
MXP3 nco A net69 VDD pm1p2_svt_lp L=6e-08 W=5.85e-07
MXP0 nco CI p1 VDD pm1p2_svt_lp L=6e-08 W=5.85e-07
MXP6 p2 CI VDD VDD pm1p2_svt_lp L=6e-08 W=5e-07
MXP7 p2 A VDD VDD pm1p2_svt_lp L=6e-08 W=5e-07
MXP8 p2 B VDD VDD pm1p2_svt_lp L=6e-08 W=5e-07
MXP5 ns nco p2 VDD pm1p2_svt_lp L=6e-08 W=5e-07
MXP9 ns CI net87 VDD pm1p2_svt_lp L=6e-08 W=5.4e-07
MXP10 net87 A net84 VDD pm1p2_svt_lp L=6e-08 W=5.4e-07
MXP11 net84 B VDD VDD pm1p2_svt_lp L=6e-08 W=5.4e-07
MI1_MXPA1 S ns VDD VDD pm1p2_svt_lp L=6e-08 W=4.1e-07
MI1_MXPA1_2 S ns VDD VDD pm1p2_svt_lp L=6e-08 W=4.1e-07
.ENDS

.SUBCKT ADDFX2H9R CO S VDD VSS A B CI
MI0_MXNA1 CO nco VSS VSS nm1p2_svt_lp L=6e-08 W=4.2e-07
MI0_MXNA1_2 CO nco VSS VSS nm1p2_svt_lp L=6e-08 W=4.2e-07
MXN1 n1 A VSS VSS nm1p2_svt_lp L=6e-08 W=4.2e-07
MXN2 n1 B VSS VSS nm1p2_svt_lp L=6e-08 W=4.2e-07
MXN4 net34 B VSS VSS nm1p2_svt_lp L=6e-08 W=4.2e-07
MXN3 nco A net34 VSS nm1p2_svt_lp L=6e-08 W=4.2e-07
MXN0 nco CI n1 VSS nm1p2_svt_lp L=6e-08 W=4.2e-07
MXN6 n2 CI VSS VSS nm1p2_svt_lp L=6e-08 W=3.6e-07
MXN7 n2 A VSS VSS nm1p2_svt_lp L=6e-08 W=3.6e-07
MXN8 n2 B VSS VSS nm1p2_svt_lp L=6e-08 W=3.6e-07
MXN5 ns nco n2 VSS nm1p2_svt_lp L=6e-08 W=3.6e-07
MXN9 ns CI net49 VSS nm1p2_svt_lp L=6e-08 W=3.8e-07
MXN10 net49 A net46 VSS nm1p2_svt_lp L=6e-08 W=3.8e-07
MXN11 net46 B VSS VSS nm1p2_svt_lp L=6e-08 W=3.8e-07
MI1_MXNA1 S ns VSS VSS nm1p2_svt_lp L=6e-08 W=4.2e-07
MI1_MXNA1_2 S ns VSS VSS nm1p2_svt_lp L=6e-08 W=4.2e-07
MI0_MXPA1 CO nco VDD VDD pm1p2_svt_lp L=6e-08 W=5.85e-07
MI0_MXPA1_2 CO nco VDD VDD pm1p2_svt_lp L=6e-08 W=5.85e-07
MXP1 p1 A VDD VDD pm1p2_svt_lp L=6e-08 W=5.85e-07
MXP2 p1 B VDD VDD pm1p2_svt_lp L=6e-08 W=5.85e-07
MXP4 net69 B VDD VDD pm1p2_svt_lp L=6e-08 W=5.85e-07
MXP3 nco A net69 VDD pm1p2_svt_lp L=6e-08 W=5.85e-07
MXP0 nco CI p1 VDD pm1p2_svt_lp L=6e-08 W=5.85e-07
MXP6 p2 CI VDD VDD pm1p2_svt_lp L=6e-08 W=5e-07
MXP7 p2 A VDD VDD pm1p2_svt_lp L=6e-08 W=5e-07
MXP8 p2 B VDD VDD pm1p2_svt_lp L=6e-08 W=5e-07
MXP5 ns nco p2 VDD pm1p2_svt_lp L=6e-08 W=5e-07
MXP9 ns CI net87 VDD pm1p2_svt_lp L=6e-08 W=5.4e-07
MXP10 net87 A net84 VDD pm1p2_svt_lp L=6e-08 W=5.4e-07
MXP11 net84 B VDD VDD pm1p2_svt_lp L=6e-08 W=5.4e-07
MI1_MXPA1 S ns VDD VDD pm1p2_svt_lp L=6e-08 W=5.85e-07
MI1_MXPA1_2 S ns VDD VDD pm1p2_svt_lp L=6e-08 W=5.85e-07
.ENDS

.SUBCKT ADDFSX1H9R CO SUM VDD VSS A B CI
MI2_MXNA1 ba na VSS VSS nm1p2_svt_lp L=6e-08 W=4.55e-07
MI0_MXNA1 na A VSS VSS nm1p2_svt_lp L=6e-08 W=4.55e-07
MI4_MXNOE xorab B na VSS nm1p2_svt_lp L=6e-08 W=3.3e-07
MI5_MXNOE xorab nb ba VSS nm1p2_svt_lp L=6e-08 W=3.3e-07
MI3_MXNOE xnorab B ba VSS nm1p2_svt_lp L=6e-08 W=3.3e-07
MI1_MXNOE xnorab nb na VSS nm1p2_svt_lp L=6e-08 W=3.3e-07
MI6_MXNA1 nb B VSS VSS nm1p2_svt_lp L=6e-08 W=4.55e-07
MI11_MXNOE con xnorab nb VSS nm1p2_svt_lp L=6e-08 W=3.45e-07
MI12_MXNOE con xorab cin VSS nm1p2_svt_lp L=6e-08 W=3.45e-07
MI9_MXNOE sumn xnorab cin VSS nm1p2_svt_lp L=6e-08 W=3.45e-07
MI10_MXNOE sumn xorab cib VSS nm1p2_svt_lp L=6e-08 W=3.45e-07
MI8_MXNA1 cib cin VSS VSS nm1p2_svt_lp L=6e-08 W=3.5e-07
MI7_MXNA1 cin CI VSS VSS nm1p2_svt_lp L=6e-08 W=4.55e-07
MI14_MXNA1 CO con VSS VSS nm1p2_svt_lp L=6e-08 W=4.2e-07
MI13_MXNA1 SUM sumn VSS VSS nm1p2_svt_lp L=6e-08 W=4.2e-07
MI2_MXPA1 ba na VDD VDD pm1p2_svt_lp L=6e-08 W=5.4e-07
MI0_MXPA1 na A VDD VDD pm1p2_svt_lp L=6e-08 W=5.4e-07
MI4_MXPOEN xorab nb na VDD pm1p2_svt_lp L=6e-08 W=3.3e-07
MI5_MXPOEN xorab B ba VDD pm1p2_svt_lp L=6e-08 W=3.3e-07
MI3_MXPOEN xnorab nb ba VDD pm1p2_svt_lp L=6e-08 W=3.3e-07
MI1_MXPOEN xnorab B na VDD pm1p2_svt_lp L=6e-08 W=3.3e-07
MI6_MXPA1 nb B VDD VDD pm1p2_svt_lp L=6e-08 W=5.4e-07
MI11_MXPOEN con xorab nb VDD pm1p2_svt_lp L=6e-08 W=3.45e-07
MI12_MXPOEN con xnorab cin VDD pm1p2_svt_lp L=6e-08 W=3.45e-07
MI9_MXPOEN sumn xorab cin VDD pm1p2_svt_lp L=6e-08 W=3.45e-07
MI10_MXPOEN sumn xnorab cib VDD pm1p2_svt_lp L=6e-08 W=3.45e-07
MI8_MXPA1 cib cin VDD VDD pm1p2_svt_lp L=6e-08 W=5.55e-07
MI7_MXPA1 cin CI VDD VDD pm1p2_svt_lp L=6e-08 W=5.4e-07
MI14_MXPA1 CO con VDD VDD pm1p2_svt_lp L=6e-08 W=5.85e-07
MI13_MXPA1 SUM sumn VDD VDD pm1p2_svt_lp L=6e-08 W=5.85e-07
.ENDS

.SUBCKT ADDFSX1P4H9R CO SUM VDD VSS A B CI
MI2_MXNA1 ba na VSS VSS nm1p2_svt_lp L=6e-08 W=4.85e-07
MI0_MXNA1 na A VSS VSS nm1p2_svt_lp L=6e-08 W=4.85e-07
MI4_MXNOE xorab B na VSS nm1p2_svt_lp L=6e-08 W=3.3e-07
MI5_MXNOE xorab nb ba VSS nm1p2_svt_lp L=6e-08 W=3.3e-07
MI3_MXNOE xnorab B ba VSS nm1p2_svt_lp L=6e-08 W=3.3e-07
MI1_MXNOE xnorab nb na VSS nm1p2_svt_lp L=6e-08 W=3.3e-07
MI6_MXNA1 nb B VSS VSS nm1p2_svt_lp L=6e-08 W=4.85e-07
MI11_MXNOE con xnorab nb VSS nm1p2_svt_lp L=6e-08 W=3.45e-07
MI12_MXNOE con xorab cin VSS nm1p2_svt_lp L=6e-08 W=3.45e-07
MI9_MXNOE sumn xnorab cin VSS nm1p2_svt_lp L=6e-08 W=3.45e-07
MI10_MXNOE sumn xorab cib VSS nm1p2_svt_lp L=6e-08 W=3.45e-07
MI8_MXNA1 cib cin VSS VSS nm1p2_svt_lp L=6e-08 W=3.5e-07
MI7_MXNA1 cin CI VSS VSS nm1p2_svt_lp L=6e-08 W=4.85e-07
MI14_MXNA1 CO con VSS VSS nm1p2_svt_lp L=6e-08 W=2.95e-07
MI14_MXNA1_2 CO con VSS VSS nm1p2_svt_lp L=6e-08 W=2.95e-07
MI13_MXNA1 SUM sumn VSS VSS nm1p2_svt_lp L=6e-08 W=2.95e-07
MI13_MXNA1_2 SUM sumn VSS VSS nm1p2_svt_lp L=6e-08 W=2.95e-07
MI2_MXPA1 ba na VDD VDD pm1p2_svt_lp L=6e-08 W=5.6e-07
MI0_MXPA1 na A VDD VDD pm1p2_svt_lp L=6e-08 W=5.6e-07
MI4_MXPOEN xorab nb na VDD pm1p2_svt_lp L=6e-08 W=3.3e-07
MI5_MXPOEN xorab B ba VDD pm1p2_svt_lp L=6e-08 W=3.3e-07
MI3_MXPOEN xnorab nb ba VDD pm1p2_svt_lp L=6e-08 W=3.3e-07
MI1_MXPOEN xnorab B na VDD pm1p2_svt_lp L=6e-08 W=3.3e-07
MI6_MXPA1 nb B VDD VDD pm1p2_svt_lp L=6e-08 W=5.6e-07
MI11_MXPOEN con xorab nb VDD pm1p2_svt_lp L=6e-08 W=3.45e-07
MI12_MXPOEN con xnorab cin VDD pm1p2_svt_lp L=6e-08 W=3.45e-07
MI9_MXPOEN sumn xorab cin VDD pm1p2_svt_lp L=6e-08 W=3.45e-07
MI10_MXPOEN sumn xnorab cib VDD pm1p2_svt_lp L=6e-08 W=3.45e-07
MI8_MXPA1 cib cin VDD VDD pm1p2_svt_lp L=6e-08 W=5.55e-07
MI7_MXPA1 cin CI VDD VDD pm1p2_svt_lp L=6e-08 W=5.55e-07
MI14_MXPA1 CO con VDD VDD pm1p2_svt_lp L=6e-08 W=4.1e-07
MI14_MXPA1_2 CO con VDD VDD pm1p2_svt_lp L=6e-08 W=4.1e-07
MI13_MXPA1 SUM sumn VDD VDD pm1p2_svt_lp L=6e-08 W=4.1e-07
MI13_MXPA1_2 SUM sumn VDD VDD pm1p2_svt_lp L=6e-08 W=4.1e-07
.ENDS

.SUBCKT ADDFSX2H9R CO SUM VDD VSS A B CI
MI2_MXNA1 ba na VSS VSS nm1p2_svt_lp L=6e-08 W=4.95e-07
MI0_MXNA1 na A VSS VSS nm1p2_svt_lp L=6e-08 W=4.95e-07
MI4_MXNOE xorab B na VSS nm1p2_svt_lp L=6e-08 W=3.3e-07
MI5_MXNOE xorab nb ba VSS nm1p2_svt_lp L=6e-08 W=3.3e-07
MI3_MXNOE xnorab B ba VSS nm1p2_svt_lp L=6e-08 W=3.3e-07
MI1_MXNOE xnorab nb na VSS nm1p2_svt_lp L=6e-08 W=3.3e-07
MI6_MXNA1 nb B VSS VSS nm1p2_svt_lp L=6e-08 W=4.95e-07
MI11_MXNOE con xnorab nb VSS nm1p2_svt_lp L=6e-08 W=3.45e-07
MI12_MXNOE con xorab cin VSS nm1p2_svt_lp L=6e-08 W=3.45e-07
MI9_MXNOE sumn xnorab cin VSS nm1p2_svt_lp L=6e-08 W=3.45e-07
MI10_MXNOE sumn xorab cib VSS nm1p2_svt_lp L=6e-08 W=3.45e-07
MI8_MXNA1 cib cin VSS VSS nm1p2_svt_lp L=6e-08 W=3.5e-07
MI7_MXNA1 cin CI VSS VSS nm1p2_svt_lp L=6e-08 W=4.95e-07
MI14_MXNA1 CO con VSS VSS nm1p2_svt_lp L=6e-08 W=4.2e-07
MI14_MXNA1_2 CO con VSS VSS nm1p2_svt_lp L=6e-08 W=4.2e-07
MI13_MXNA1 SUM sumn VSS VSS nm1p2_svt_lp L=6e-08 W=4.2e-07
MI13_MXNA1_2 SUM sumn VSS VSS nm1p2_svt_lp L=6e-08 W=4.2e-07
MI2_MXPA1 ba na VDD VDD pm1p2_svt_lp L=6e-08 W=5.85e-07
MI0_MXPA1 na A VDD VDD pm1p2_svt_lp L=6e-08 W=5.85e-07
MI4_MXPOEN xorab nb na VDD pm1p2_svt_lp L=6e-08 W=3.3e-07
MI5_MXPOEN xorab B ba VDD pm1p2_svt_lp L=6e-08 W=3.3e-07
MI3_MXPOEN xnorab nb ba VDD pm1p2_svt_lp L=6e-08 W=3.3e-07
MI1_MXPOEN xnorab B na VDD pm1p2_svt_lp L=6e-08 W=3.3e-07
MI6_MXPA1 nb B VDD VDD pm1p2_svt_lp L=6e-08 W=5.7e-07
MI11_MXPOEN con xorab nb VDD pm1p2_svt_lp L=6e-08 W=3.45e-07
MI12_MXPOEN con xnorab cin VDD pm1p2_svt_lp L=6e-08 W=3.45e-07
MI9_MXPOEN sumn xorab cin VDD pm1p2_svt_lp L=6e-08 W=3.45e-07
MI10_MXPOEN sumn xnorab cib VDD pm1p2_svt_lp L=6e-08 W=3.45e-07
MI8_MXPA1 cib cin VDD VDD pm1p2_svt_lp L=6e-08 W=5.55e-07
MI7_MXPA1 cin CI VDD VDD pm1p2_svt_lp L=6e-08 W=5.85e-07
MI14_MXPA1 CO con VDD VDD pm1p2_svt_lp L=6e-08 W=5.85e-07
MI14_MXPA1_2 CO con VDD VDD pm1p2_svt_lp L=6e-08 W=5.85e-07
MI13_MXPA1 SUM sumn VDD VDD pm1p2_svt_lp L=6e-08 W=5.85e-07
MI13_MXPA1_2 SUM sumn VDD VDD pm1p2_svt_lp L=6e-08 W=5.85e-07
.ENDS

.SUBCKT ADDFCINX1H9R CO SUM VDD VSS A B CIN
MI2_MXNA1 ba na VSS VSS nm1p2_svt_lp L=6e-08 W=4.55e-07
MI0_MXNA1 na A VSS VSS nm1p2_svt_lp L=6e-08 W=4.55e-07
MI4_MXNOE xorab B na VSS nm1p2_svt_lp L=6e-08 W=3.3e-07
MI5_MXNOE xorab nb ba VSS nm1p2_svt_lp L=6e-08 W=3.3e-07
MI3_MXNOE xnorab B ba VSS nm1p2_svt_lp L=6e-08 W=3.3e-07
MI1_MXNOE xnorab nb na VSS nm1p2_svt_lp L=6e-08 W=3.3e-07
MI6_MXNA1 nb B VSS VSS nm1p2_svt_lp L=6e-08 W=4.55e-07
MI11_MXNOE con xnorab nb VSS nm1p2_svt_lp L=6e-08 W=3.45e-07
MI12_MXNOE con xorab cinb VSS nm1p2_svt_lp L=6e-08 W=3.45e-07
MI9_MXNOE sumn xnorab cinb VSS nm1p2_svt_lp L=6e-08 W=3.45e-07
MI10_MXNOE sumn xorab ci VSS nm1p2_svt_lp L=6e-08 W=3.45e-07
MI7_MXNA1 ci CIN VSS VSS nm1p2_svt_lp L=6e-08 W=4.35e-07
MI8_MXNA1 cinb ci VSS VSS nm1p2_svt_lp L=6e-08 W=3.8e-07
MI14_MXNA1 CO con VSS VSS nm1p2_svt_lp L=6e-08 W=4.2e-07
MI13_MXNA1 SUM sumn VSS VSS nm1p2_svt_lp L=6e-08 W=4.2e-07
MI2_MXPA1 ba na VDD VDD pm1p2_svt_lp L=6e-08 W=5.4e-07
MI0_MXPA1 na A VDD VDD pm1p2_svt_lp L=6e-08 W=5.4e-07
MI4_MXPOEN xorab nb na VDD pm1p2_svt_lp L=6e-08 W=3.3e-07
MI5_MXPOEN xorab B ba VDD pm1p2_svt_lp L=6e-08 W=3.3e-07
MI3_MXPOEN xnorab nb ba VDD pm1p2_svt_lp L=6e-08 W=3.3e-07
MI1_MXPOEN xnorab B na VDD pm1p2_svt_lp L=6e-08 W=3.3e-07
MI6_MXPA1 nb B VDD VDD pm1p2_svt_lp L=6e-08 W=5.4e-07
MI11_MXPOEN con xorab nb VDD pm1p2_svt_lp L=6e-08 W=3.45e-07
MI12_MXPOEN con xnorab cinb VDD pm1p2_svt_lp L=6e-08 W=3.45e-07
MI9_MXPOEN sumn xorab cinb VDD pm1p2_svt_lp L=6e-08 W=3.45e-07
MI10_MXPOEN sumn xnorab ci VDD pm1p2_svt_lp L=6e-08 W=3.45e-07
MI7_MXPA1 ci CIN VDD VDD pm1p2_svt_lp L=6e-08 W=5.15e-07
MI8_MXPA1 cinb ci VDD VDD pm1p2_svt_lp L=6e-08 W=5.35e-07
MI14_MXPA1 CO con VDD VDD pm1p2_svt_lp L=6e-08 W=5.85e-07
MI13_MXPA1 SUM sumn VDD VDD pm1p2_svt_lp L=6e-08 W=5.85e-07
.ENDS

.SUBCKT ADDFCINX1P4H9R CO SUM VDD VSS A B CIN
MI2_MXNA1 ba na VSS VSS nm1p2_svt_lp L=6e-08 W=4.85e-07
MI0_MXNA1 na A VSS VSS nm1p2_svt_lp L=6e-08 W=4.85e-07
MI4_MXNOE xorab B na VSS nm1p2_svt_lp L=6e-08 W=3.3e-07
MI5_MXNOE xorab nb ba VSS nm1p2_svt_lp L=6e-08 W=3.3e-07
MI3_MXNOE xnorab B ba VSS nm1p2_svt_lp L=6e-08 W=3.3e-07
MI1_MXNOE xnorab nb na VSS nm1p2_svt_lp L=6e-08 W=3.3e-07
MI6_MXNA1 nb B VSS VSS nm1p2_svt_lp L=6e-08 W=4.85e-07
MI11_MXNOE con xnorab nb VSS nm1p2_svt_lp L=6e-08 W=3.45e-07
MI12_MXNOE con xorab cinb VSS nm1p2_svt_lp L=6e-08 W=3.45e-07
MI9_MXNOE sumn xnorab cinb VSS nm1p2_svt_lp L=6e-08 W=3.45e-07
MI10_MXNOE sumn xorab ci VSS nm1p2_svt_lp L=6e-08 W=3.45e-07
MI7_MXNA1 ci CIN VSS VSS nm1p2_svt_lp L=6e-08 W=4.55e-07
MI8_MXNA1 cinb ci VSS VSS nm1p2_svt_lp L=6e-08 W=3.8e-07
MI14_MXNA1 CO con VSS VSS nm1p2_svt_lp L=6e-08 W=2.95e-07
MI14_MXNA1_2 CO con VSS VSS nm1p2_svt_lp L=6e-08 W=2.95e-07
MI13_MXNA1 SUM sumn VSS VSS nm1p2_svt_lp L=6e-08 W=2.95e-07
MI13_MXNA1_2 SUM sumn VSS VSS nm1p2_svt_lp L=6e-08 W=2.95e-07
MI2_MXPA1 ba na VDD VDD pm1p2_svt_lp L=6e-08 W=5.6e-07
MI0_MXPA1 na A VDD VDD pm1p2_svt_lp L=6e-08 W=5.6e-07
MI4_MXPOEN xorab nb na VDD pm1p2_svt_lp L=6e-08 W=3.3e-07
MI5_MXPOEN xorab B ba VDD pm1p2_svt_lp L=6e-08 W=3.3e-07
MI3_MXPOEN xnorab nb ba VDD pm1p2_svt_lp L=6e-08 W=3.3e-07
MI1_MXPOEN xnorab B na VDD pm1p2_svt_lp L=6e-08 W=3.3e-07
MI6_MXPA1 nb B VDD VDD pm1p2_svt_lp L=6e-08 W=5.6e-07
MI11_MXPOEN con xorab nb VDD pm1p2_svt_lp L=6e-08 W=3.45e-07
MI12_MXPOEN con xnorab cinb VDD pm1p2_svt_lp L=6e-08 W=3.45e-07
MI9_MXPOEN sumn xorab cinb VDD pm1p2_svt_lp L=6e-08 W=3.45e-07
MI10_MXPOEN sumn xnorab ci VDD pm1p2_svt_lp L=6e-08 W=3.45e-07
MI7_MXPA1 ci CIN VDD VDD pm1p2_svt_lp L=6e-08 W=5.35e-07
MI8_MXPA1 cinb ci VDD VDD pm1p2_svt_lp L=6e-08 W=5.35e-07
MI14_MXPA1 CO con VDD VDD pm1p2_svt_lp L=6e-08 W=4.1e-07
MI14_MXPA1_2 CO con VDD VDD pm1p2_svt_lp L=6e-08 W=4.1e-07
MI13_MXPA1 SUM sumn VDD VDD pm1p2_svt_lp L=6e-08 W=4.1e-07
MI13_MXPA1_2 SUM sumn VDD VDD pm1p2_svt_lp L=6e-08 W=4.1e-07
.ENDS

.SUBCKT ADDFCINX2H9R CO SUM VDD VSS A B CIN
MI2_MXNA1 ba na VSS VSS nm1p2_svt_lp L=6e-08 W=4.95e-07
MI0_MXNA1 na A VSS VSS nm1p2_svt_lp L=6e-08 W=4.95e-07
MI4_MXNOE xorab B na VSS nm1p2_svt_lp L=6e-08 W=3.3e-07
MI5_MXNOE xorab nb ba VSS nm1p2_svt_lp L=6e-08 W=3.3e-07
MI3_MXNOE xnorab B ba VSS nm1p2_svt_lp L=6e-08 W=3.3e-07
MI1_MXNOE xnorab nb na VSS nm1p2_svt_lp L=6e-08 W=3.3e-07
MI6_MXNA1 nb B VSS VSS nm1p2_svt_lp L=6e-08 W=4.95e-07
MI11_MXNOE con xnorab nb VSS nm1p2_svt_lp L=6e-08 W=3.45e-07
MI12_MXNOE con xorab cinb VSS nm1p2_svt_lp L=6e-08 W=3.45e-07
MI9_MXNOE sumn xnorab cinb VSS nm1p2_svt_lp L=6e-08 W=3.45e-07
MI10_MXNOE sumn xorab ci VSS nm1p2_svt_lp L=6e-08 W=3.45e-07
MI7_MXNA1 ci CIN VSS VSS nm1p2_svt_lp L=6e-08 W=4.75e-07
MI8_MXNA1 cinb ci VSS VSS nm1p2_svt_lp L=6e-08 W=4.95e-07
MI14_MXNA1 CO con VSS VSS nm1p2_svt_lp L=6e-08 W=4.2e-07
MI14_MXNA1_2 CO con VSS VSS nm1p2_svt_lp L=6e-08 W=4.2e-07
MI13_MXNA1 SUM sumn VSS VSS nm1p2_svt_lp L=6e-08 W=4.2e-07
MI13_MXNA1_2 SUM sumn VSS VSS nm1p2_svt_lp L=6e-08 W=4.2e-07
MI2_MXPA1 ba na VDD VDD pm1p2_svt_lp L=6e-08 W=5.85e-07
MI0_MXPA1 na A VDD VDD pm1p2_svt_lp L=6e-08 W=5.85e-07
MI4_MXPOEN xorab nb na VDD pm1p2_svt_lp L=6e-08 W=3.3e-07
MI5_MXPOEN xorab B ba VDD pm1p2_svt_lp L=6e-08 W=3.3e-07
MI3_MXPOEN xnorab nb ba VDD pm1p2_svt_lp L=6e-08 W=3.3e-07
MI1_MXPOEN xnorab B na VDD pm1p2_svt_lp L=6e-08 W=3.3e-07
MI6_MXPA1 nb B VDD VDD pm1p2_svt_lp L=6e-08 W=5.7e-07
MI11_MXPOEN con xorab nb VDD pm1p2_svt_lp L=6e-08 W=3.45e-07
MI12_MXPOEN con xnorab cinb VDD pm1p2_svt_lp L=6e-08 W=3.45e-07
MI9_MXPOEN sumn xorab cinb VDD pm1p2_svt_lp L=6e-08 W=3.45e-07
MI10_MXPOEN sumn xnorab ci VDD pm1p2_svt_lp L=6e-08 W=3.45e-07
MI7_MXPA1 ci CIN VDD VDD pm1p2_svt_lp L=6e-08 W=5.55e-07
MI8_MXPA1 cinb ci VDD VDD pm1p2_svt_lp L=6e-08 W=5.85e-07
MI14_MXPA1 CO con VDD VDD pm1p2_svt_lp L=6e-08 W=5.85e-07
MI14_MXPA1_2 CO con VDD VDD pm1p2_svt_lp L=6e-08 W=5.85e-07
MI13_MXPA1 SUM sumn VDD VDD pm1p2_svt_lp L=6e-08 W=5.85e-07
MI13_MXPA1_2 SUM sumn VDD VDD pm1p2_svt_lp L=6e-08 W=5.85e-07
.ENDS

.SUBCKT CGENX1H9R CO VDD VSS A B CI
MXN0 nco CI n1 VSS nm1p2_svt_lp L=6e-08 W=4e-07
MXN3 nco A n2 VSS nm1p2_svt_lp L=6e-08 W=4e-07
MXN4 n2 B VSS VSS nm1p2_svt_lp L=6e-08 W=4e-07
MXN2 n1 B VSS VSS nm1p2_svt_lp L=6e-08 W=4e-07
MXN1 n1 A VSS VSS nm1p2_svt_lp L=6e-08 W=4e-07
MI0_MXNA1 CO nco VSS VSS nm1p2_svt_lp L=6e-08 W=4.2e-07
MXP0 nco CI p1 VDD pm1p2_svt_lp L=6e-08 W=5.65e-07
MXP3 nco A p2 VDD pm1p2_svt_lp L=6e-08 W=5.65e-07
MXP4 p2 B VDD VDD pm1p2_svt_lp L=6e-08 W=5.65e-07
MXP2 p1 B VDD VDD pm1p2_svt_lp L=6e-08 W=5.65e-07
MXP1 p1 A VDD VDD pm1p2_svt_lp L=6e-08 W=5.65e-07
MI0_MXPA1 CO nco VDD VDD pm1p2_svt_lp L=6e-08 W=5.85e-07
.ENDS

.SUBCKT CGENX1P4H9R CO VDD VSS A B CI
MXN0 nco CI n1 VSS nm1p2_svt_lp L=6e-08 W=4e-07
MXN3 nco A n2 VSS nm1p2_svt_lp L=6e-08 W=4e-07
MXN4 n2 B VSS VSS nm1p2_svt_lp L=6e-08 W=4e-07
MXN2 n1 B VSS VSS nm1p2_svt_lp L=6e-08 W=4e-07
MXN1 n1 A VSS VSS nm1p2_svt_lp L=6e-08 W=4e-07
MI0_MXNA1 CO nco VSS VSS nm1p2_svt_lp L=6e-08 W=2.95e-07
MI0_MXNA1_2 CO nco VSS VSS nm1p2_svt_lp L=6e-08 W=2.95e-07
MXP0 nco CI p1 VDD pm1p2_svt_lp L=6e-08 W=5.65e-07
MXP3 nco A p2 VDD pm1p2_svt_lp L=6e-08 W=5.65e-07
MXP4 p2 B VDD VDD pm1p2_svt_lp L=6e-08 W=5.65e-07
MXP2 p1 B VDD VDD pm1p2_svt_lp L=6e-08 W=5.65e-07
MXP1 p1 A VDD VDD pm1p2_svt_lp L=6e-08 W=5.65e-07
MI0_MXPA1 CO nco VDD VDD pm1p2_svt_lp L=6e-08 W=4.1e-07
MI0_MXPA1_2 CO nco VDD VDD pm1p2_svt_lp L=6e-08 W=4.1e-07
.ENDS

.SUBCKT CGENX2H9R CO VDD VSS A B CI
MXN0 nco CI n1 VSS nm1p2_svt_lp L=6e-08 W=4e-07
MXN3 nco A n2 VSS nm1p2_svt_lp L=6e-08 W=4e-07
MXN4 n2 B VSS VSS nm1p2_svt_lp L=6e-08 W=4e-07
MXN2 n1 B VSS VSS nm1p2_svt_lp L=6e-08 W=4e-07
MXN1 n1 A VSS VSS nm1p2_svt_lp L=6e-08 W=4e-07
MI0_MXNA1 CO nco VSS VSS nm1p2_svt_lp L=6e-08 W=4.2e-07
MI0_MXNA1_2 CO nco VSS VSS nm1p2_svt_lp L=6e-08 W=4.2e-07
MXP0 nco CI p1 VDD pm1p2_svt_lp L=6e-08 W=5.65e-07
MXP3 nco A p2 VDD pm1p2_svt_lp L=6e-08 W=5.65e-07
MXP4 p2 B VDD VDD pm1p2_svt_lp L=6e-08 W=5.65e-07
MXP2 p1 B VDD VDD pm1p2_svt_lp L=6e-08 W=5.65e-07
MXP1 p1 A VDD VDD pm1p2_svt_lp L=6e-08 W=5.65e-07
MI0_MXPA1 CO nco VDD VDD pm1p2_svt_lp L=6e-08 W=5.85e-07
MI0_MXPA1_2 CO nco VDD VDD pm1p2_svt_lp L=6e-08 W=5.85e-07
.ENDS

.SUBCKT CGENCINX1H9R CO VDD VSS A B CIN
MI2_MXNA1 ba na VSS VSS nm1p2_svt_lp L=6e-08 W=3.35e-07
MI0_MXNA1 na A VSS VSS nm1p2_svt_lp L=6e-08 W=3.35e-07
MI4_MXNOE xorab B na VSS nm1p2_svt_lp L=6e-08 W=3.15e-07
MI5_MXNOE xorab nb ba VSS nm1p2_svt_lp L=6e-08 W=3.15e-07
MI3_MXNOE xnorab B ba VSS nm1p2_svt_lp L=6e-08 W=3.15e-07
MI1_MXNOE xnorab nb na VSS nm1p2_svt_lp L=6e-08 W=3.15e-07
MI8_MXNA1 nb B VSS VSS nm1p2_svt_lp L=6e-08 W=3.8e-07
MI9_MXNA1 bb nb VSS VSS nm1p2_svt_lp L=6e-08 W=3.8e-07
MI6_MXNOE CO xnorab bb VSS nm1p2_svt_lp L=6e-08 W=3.8e-07
MI7_MXNOE CO xorab ci VSS nm1p2_svt_lp L=6e-08 W=3.8e-07
MI10_MXNA1 ci CIN VSS VSS nm1p2_svt_lp L=6e-08 W=3.8e-07
MI2_MXPA1 ba na VDD VDD pm1p2_svt_lp L=6e-08 W=5.55e-07
MI0_MXPA1 na A VDD VDD pm1p2_svt_lp L=6e-08 W=5.55e-07
MI4_MXPOEN xorab nb na VDD pm1p2_svt_lp L=6e-08 W=3.45e-07
MI5_MXPOEN xorab B ba VDD pm1p2_svt_lp L=6e-08 W=3.45e-07
MI3_MXPOEN xnorab nb ba VDD pm1p2_svt_lp L=6e-08 W=3.45e-07
MI1_MXPOEN xnorab B na VDD pm1p2_svt_lp L=6e-08 W=3.45e-07
MI8_MXPA1 nb B VDD VDD pm1p2_svt_lp L=6e-08 W=5.65e-07
MI9_MXPA1 bb nb VDD VDD pm1p2_svt_lp L=6e-08 W=5.65e-07
MI6_MXPOEN CO xorab bb VDD pm1p2_svt_lp L=6e-08 W=3.8e-07
MI7_MXPOEN CO xnorab ci VDD pm1p2_svt_lp L=6e-08 W=3.8e-07
MI10_MXPA1 ci CIN VDD VDD pm1p2_svt_lp L=6e-08 W=5.85e-07
.ENDS

.SUBCKT CGENCINX1P4H9R CO VDD VSS A B CIN
MI2_MXNA1 ba na VSS VSS nm1p2_svt_lp L=6e-08 W=3.35e-07
MI0_MXNA1 na A VSS VSS nm1p2_svt_lp L=6e-08 W=3.35e-07
MI4_MXNOE xorab B na VSS nm1p2_svt_lp L=6e-08 W=3.15e-07
MI5_MXNOE xorab nb ba VSS nm1p2_svt_lp L=6e-08 W=3.15e-07
MI3_MXNOE xnorab B ba VSS nm1p2_svt_lp L=6e-08 W=3.15e-07
MI1_MXNOE xnorab nb na VSS nm1p2_svt_lp L=6e-08 W=3.15e-07
MI8_MXNA1 nb B VSS VSS nm1p2_svt_lp L=6e-08 W=2.7e-07
MI8_MXNA1_2 nb B VSS VSS nm1p2_svt_lp L=6e-08 W=2.7e-07
MI9_MXNA1 bb nb VSS VSS nm1p2_svt_lp L=6e-08 W=2.7e-07
MI9_MXNA1_2 bb nb VSS VSS nm1p2_svt_lp L=6e-08 W=2.7e-07
MI6_MXNOE CO xnorab bb VSS nm1p2_svt_lp L=6e-08 W=2.7e-07
MI7_MXNOE CO xorab ci VSS nm1p2_svt_lp L=6e-08 W=2.7e-07
MI7_MXNOE_2 CO xorab ci VSS nm1p2_svt_lp L=6e-08 W=2.7e-07
MI6_MXNOE_2 CO xnorab bb VSS nm1p2_svt_lp L=6e-08 W=2.7e-07
MI10_MXNA1 ci CIN VSS VSS nm1p2_svt_lp L=6e-08 W=2.7e-07
MI10_MXNA1_2 ci CIN VSS VSS nm1p2_svt_lp L=6e-08 W=2.7e-07
MI2_MXPA1 ba na VDD VDD pm1p2_svt_lp L=6e-08 W=5.55e-07
MI0_MXPA1 na A VDD VDD pm1p2_svt_lp L=6e-08 W=5.55e-07
MI4_MXPOEN xorab nb na VDD pm1p2_svt_lp L=6e-08 W=3.45e-07
MI5_MXPOEN xorab B ba VDD pm1p2_svt_lp L=6e-08 W=3.45e-07
MI3_MXPOEN xnorab nb ba VDD pm1p2_svt_lp L=6e-08 W=3.45e-07
MI1_MXPOEN xnorab B na VDD pm1p2_svt_lp L=6e-08 W=3.45e-07
MI8_MXPA1 nb B VDD VDD pm1p2_svt_lp L=6e-08 W=4.4e-07
MI8_MXPA1_2 nb B VDD VDD pm1p2_svt_lp L=6e-08 W=4.4e-07
MI9_MXPA1 bb nb VDD VDD pm1p2_svt_lp L=6e-08 W=4.4e-07
MI9_MXPA1_2 bb nb VDD VDD pm1p2_svt_lp L=6e-08 W=4.4e-07
MI6_MXPOEN CO xorab bb VDD pm1p2_svt_lp L=6e-08 W=2.7e-07
MI7_MXPOEN CO xnorab ci VDD pm1p2_svt_lp L=6e-08 W=2.7e-07
MI7_MXPOEN_2 CO xnorab ci VDD pm1p2_svt_lp L=6e-08 W=2.7e-07
MI6_MXPOEN_2 CO xorab bb VDD pm1p2_svt_lp L=6e-08 W=2.7e-07
MI10_MXPA1 ci CIN VDD VDD pm1p2_svt_lp L=6e-08 W=4.4e-07
MI10_MXPA1_2 ci CIN VDD VDD pm1p2_svt_lp L=6e-08 W=4.4e-07
.ENDS

.SUBCKT CGENCINX2H9R CO VDD VSS A B CIN
MI2_MXNA1 ba na VSS VSS nm1p2_svt_lp L=6e-08 W=3.35e-07
MI0_MXNA1 na A VSS VSS nm1p2_svt_lp L=6e-08 W=3.35e-07
MI4_MXNOE xorab B na VSS nm1p2_svt_lp L=6e-08 W=3.15e-07
MI5_MXNOE xorab nb ba VSS nm1p2_svt_lp L=6e-08 W=3.15e-07
MI3_MXNOE xnorab B ba VSS nm1p2_svt_lp L=6e-08 W=3.15e-07
MI1_MXNOE xnorab nb na VSS nm1p2_svt_lp L=6e-08 W=3.15e-07
MI8_MXNA1 nb B VSS VSS nm1p2_svt_lp L=6e-08 W=3.5e-07
MI8_MXNA1_2 nb B VSS VSS nm1p2_svt_lp L=6e-08 W=3.5e-07
MI9_MXNA1 bb nb VSS VSS nm1p2_svt_lp L=6e-08 W=3.5e-07
MI9_MXNA1_2 bb nb VSS VSS nm1p2_svt_lp L=6e-08 W=3.5e-07
MI6_MXNOE CO xnorab bb VSS nm1p2_svt_lp L=6e-08 W=3.6e-07
MI7_MXNOE CO xorab ci VSS nm1p2_svt_lp L=6e-08 W=3.6e-07
MI7_MXNOE_2 CO xorab ci VSS nm1p2_svt_lp L=6e-08 W=3.6e-07
MI6_MXNOE_2 CO xnorab bb VSS nm1p2_svt_lp L=6e-08 W=3.6e-07
MI10_MXNA1 ci CIN VSS VSS nm1p2_svt_lp L=6e-08 W=4.15e-07
MI10_MXNA1_2 ci CIN VSS VSS nm1p2_svt_lp L=6e-08 W=4.15e-07
MI2_MXPA1 ba na VDD VDD pm1p2_svt_lp L=6e-08 W=5.55e-07
MI0_MXPA1 na A VDD VDD pm1p2_svt_lp L=6e-08 W=5.55e-07
MI4_MXPOEN xorab nb na VDD pm1p2_svt_lp L=6e-08 W=3.45e-07
MI5_MXPOEN xorab B ba VDD pm1p2_svt_lp L=6e-08 W=3.45e-07
MI3_MXPOEN xnorab nb ba VDD pm1p2_svt_lp L=6e-08 W=3.45e-07
MI1_MXPOEN xnorab B na VDD pm1p2_svt_lp L=6e-08 W=3.45e-07
MI8_MXPA1 nb B VDD VDD pm1p2_svt_lp L=6e-08 W=5.35e-07
MI8_MXPA1_2 nb B VDD VDD pm1p2_svt_lp L=6e-08 W=5.35e-07
MI9_MXPA1 bb nb VDD VDD pm1p2_svt_lp L=6e-08 W=5.35e-07
MI9_MXPA1_2 bb nb VDD VDD pm1p2_svt_lp L=6e-08 W=5.35e-07
MI6_MXPOEN CO xorab bb VDD pm1p2_svt_lp L=6e-08 W=3.8e-07
MI7_MXPOEN CO xnorab ci VDD pm1p2_svt_lp L=6e-08 W=3.8e-07
MI7_MXPOEN_2 CO xnorab ci VDD pm1p2_svt_lp L=6e-08 W=3.8e-07
MI6_MXPOEN_2 CO xorab bb VDD pm1p2_svt_lp L=6e-08 W=3.8e-07
MI10_MXPA1 ci CIN VDD VDD pm1p2_svt_lp L=6e-08 W=5.85e-07
MI10_MXPA1_2 ci CIN VDD VDD pm1p2_svt_lp L=6e-08 W=5.85e-07
.ENDS

.SUBCKT CGENCONX1H9R CON VDD VSS A B CI
MI41_MXNA1 ba na VSS VSS nm1p2_svt_lp L=6e-08 W=3.8e-07
MI40_MXNA1 na A VSS VSS nm1p2_svt_lp L=6e-08 W=3.8e-07
MI2_MXNOE xorab B na VSS nm1p2_svt_lp L=6e-08 W=3.15e-07
MI4_MXNOE xorab nb ba VSS nm1p2_svt_lp L=6e-08 W=3.15e-07
MI39_MXNOE xnorab B ba VSS nm1p2_svt_lp L=6e-08 W=3.15e-07
MI38_MXNOE xnorab nb na VSS nm1p2_svt_lp L=6e-08 W=3.15e-07
MI0_MXNA1 nb B VSS VSS nm1p2_svt_lp L=6e-08 W=3.8e-07
MI46_MXNOE CON xnorab nb VSS nm1p2_svt_lp L=6e-08 W=3.8e-07
MI47_MXNOE CON xorab cin VSS nm1p2_svt_lp L=6e-08 W=3.8e-07
MI44_MXNA1 cin CI VSS VSS nm1p2_svt_lp L=6e-08 W=3.8e-07
MI41_MXPA1 ba na VDD VDD pm1p2_svt_lp L=6e-08 W=5.55e-07
MI40_MXPA1 na A VDD VDD pm1p2_svt_lp L=6e-08 W=5.55e-07
MI2_MXPOEN xorab nb na VDD pm1p2_svt_lp L=6e-08 W=3.45e-07
MI4_MXPOEN xorab B ba VDD pm1p2_svt_lp L=6e-08 W=3.45e-07
MI39_MXPOEN xnorab nb ba VDD pm1p2_svt_lp L=6e-08 W=3.45e-07
MI38_MXPOEN xnorab B na VDD pm1p2_svt_lp L=6e-08 W=3.45e-07
MI0_MXPA1 nb B VDD VDD pm1p2_svt_lp L=6e-08 W=5.85e-07
MI46_MXPOEN CON xorab nb VDD pm1p2_svt_lp L=6e-08 W=3.8e-07
MI47_MXPOEN CON xnorab cin VDD pm1p2_svt_lp L=6e-08 W=3.8e-07
MI44_MXPA1 cin CI VDD VDD pm1p2_svt_lp L=6e-08 W=5.85e-07
.ENDS

.SUBCKT CGENCONX1P4H9R CON VDD VSS A B CI
MI41_MXNA1 ba na VSS VSS nm1p2_svt_lp L=6e-08 W=3.8e-07
MI40_MXNA1 na A VSS VSS nm1p2_svt_lp L=6e-08 W=3.8e-07
MI2_MXNOE xorab B na VSS nm1p2_svt_lp L=6e-08 W=3.15e-07
MI4_MXNOE xorab nb ba VSS nm1p2_svt_lp L=6e-08 W=3.15e-07
MI39_MXNOE xnorab B ba VSS nm1p2_svt_lp L=6e-08 W=3.15e-07
MI38_MXNOE xnorab nb na VSS nm1p2_svt_lp L=6e-08 W=3.15e-07
MI0_MXNA1 nb B VSS VSS nm1p2_svt_lp L=6e-08 W=2.7e-07
MI0_MXNA1_2 nb B VSS VSS nm1p2_svt_lp L=6e-08 W=2.7e-07
MI46_MXNOE CON xnorab nb VSS nm1p2_svt_lp L=6e-08 W=2.7e-07
MI47_MXNOE CON xorab cin VSS nm1p2_svt_lp L=6e-08 W=2.7e-07
MI47_MXNOE_2 CON xorab cin VSS nm1p2_svt_lp L=6e-08 W=2.7e-07
MI46_MXNOE_2 CON xnorab nb VSS nm1p2_svt_lp L=6e-08 W=2.7e-07
MI44_MXNA1 cin CI VSS VSS nm1p2_svt_lp L=6e-08 W=2.7e-07
MI44_MXNA1_2 cin CI VSS VSS nm1p2_svt_lp L=6e-08 W=2.7e-07
MI41_MXPA1 ba na VDD VDD pm1p2_svt_lp L=6e-08 W=5.55e-07
MI40_MXPA1 na A VDD VDD pm1p2_svt_lp L=6e-08 W=5.55e-07
MI2_MXPOEN xorab nb na VDD pm1p2_svt_lp L=6e-08 W=3.45e-07
MI4_MXPOEN xorab B ba VDD pm1p2_svt_lp L=6e-08 W=3.45e-07
MI39_MXPOEN xnorab nb ba VDD pm1p2_svt_lp L=6e-08 W=3.45e-07
MI38_MXPOEN xnorab B na VDD pm1p2_svt_lp L=6e-08 W=3.45e-07
MI0_MXPA1 nb B VDD VDD pm1p2_svt_lp L=6e-08 W=4.4e-07
MI0_MXPA1_2 nb B VDD VDD pm1p2_svt_lp L=6e-08 W=4.4e-07
MI46_MXPOEN CON xorab nb VDD pm1p2_svt_lp L=6e-08 W=2.7e-07
MI47_MXPOEN CON xnorab cin VDD pm1p2_svt_lp L=6e-08 W=2.7e-07
MI47_MXPOEN_2 CON xnorab cin VDD pm1p2_svt_lp L=6e-08 W=2.7e-07
MI46_MXPOEN_2 CON xorab nb VDD pm1p2_svt_lp L=6e-08 W=2.7e-07
MI44_MXPA1 cin CI VDD VDD pm1p2_svt_lp L=6e-08 W=4.4e-07
MI44_MXPA1_2 cin CI VDD VDD pm1p2_svt_lp L=6e-08 W=4.4e-07
.ENDS

.SUBCKT CGENCONX2H9R CON VDD VSS A B CI
MI41_MXNA1 ba na VSS VSS nm1p2_svt_lp L=6e-08 W=3.8e-07
MI40_MXNA1 na A VSS VSS nm1p2_svt_lp L=6e-08 W=3.8e-07
MI2_MXNOE xorab B na VSS nm1p2_svt_lp L=6e-08 W=3.15e-07
MI4_MXNOE xorab nb ba VSS nm1p2_svt_lp L=6e-08 W=3.15e-07
MI39_MXNOE xnorab B ba VSS nm1p2_svt_lp L=6e-08 W=3.15e-07
MI38_MXNOE xnorab nb na VSS nm1p2_svt_lp L=6e-08 W=3.15e-07
MI0_MXNA1 nb B VSS VSS nm1p2_svt_lp L=6e-08 W=3.5e-07
MI0_MXNA1_2 nb B VSS VSS nm1p2_svt_lp L=6e-08 W=3.5e-07
MI46_MXNOE CON xnorab nb VSS nm1p2_svt_lp L=6e-08 W=3.6e-07
MI47_MXNOE CON xorab cin VSS nm1p2_svt_lp L=6e-08 W=3.6e-07
MI47_MXNOE_2 CON xorab cin VSS nm1p2_svt_lp L=6e-08 W=3.6e-07
MI46_MXNOE_2 CON xnorab nb VSS nm1p2_svt_lp L=6e-08 W=3.6e-07
MI44_MXNA1 cin CI VSS VSS nm1p2_svt_lp L=6e-08 W=3.95e-07
MI44_MXNA1_2 cin CI VSS VSS nm1p2_svt_lp L=6e-08 W=3.95e-07
MI41_MXPA1 ba na VDD VDD pm1p2_svt_lp L=6e-08 W=5.55e-07
MI40_MXPA1 na A VDD VDD pm1p2_svt_lp L=6e-08 W=5.55e-07
MI2_MXPOEN xorab nb na VDD pm1p2_svt_lp L=6e-08 W=3.45e-07
MI4_MXPOEN xorab B ba VDD pm1p2_svt_lp L=6e-08 W=3.45e-07
MI39_MXPOEN xnorab nb ba VDD pm1p2_svt_lp L=6e-08 W=3.45e-07
MI38_MXPOEN xnorab B na VDD pm1p2_svt_lp L=6e-08 W=3.45e-07
MI0_MXPA1 nb B VDD VDD pm1p2_svt_lp L=6e-08 W=5.35e-07
MI0_MXPA1_2 nb B VDD VDD pm1p2_svt_lp L=6e-08 W=5.35e-07
MI46_MXPOEN CON xorab nb VDD pm1p2_svt_lp L=6e-08 W=3.8e-07
MI47_MXPOEN CON xnorab cin VDD pm1p2_svt_lp L=6e-08 W=3.8e-07
MI47_MXPOEN_2 CON xnorab cin VDD pm1p2_svt_lp L=6e-08 W=3.8e-07
MI46_MXPOEN_2 CON xorab nb VDD pm1p2_svt_lp L=6e-08 W=3.8e-07
MI44_MXPA1 cin CI VDD VDD pm1p2_svt_lp L=6e-08 W=5.5e-07
MI44_MXPA1_2 cin CI VDD VDD pm1p2_svt_lp L=6e-08 W=5.5e-07
.ENDS

.SUBCKT CGENCONAX1H9R CON VDD VSS A B CI
MXN1 n1 A VSS VSS nm1p2_svt_lp L=6e-08 W=4e-07
MXN2 n1 B VSS VSS nm1p2_svt_lp L=6e-08 W=4e-07
MXN3 n2 B VSS VSS nm1p2_svt_lp L=6e-08 W=4e-07
MXN4 CON A n2 VSS nm1p2_svt_lp L=6e-08 W=4e-07
MXN0 CON CI n1 VSS nm1p2_svt_lp L=6e-08 W=4e-07
MXP0 p1 A VDD VDD pm1p2_svt_lp L=6e-08 W=5.85e-07
MXP1 p1 B VDD VDD pm1p2_svt_lp L=6e-08 W=5.85e-07
MXP4 p2 B VDD VDD pm1p2_svt_lp L=6e-08 W=5.85e-07
MXP3 CON A p2 VDD pm1p2_svt_lp L=6e-08 W=5.85e-07
MXP2 CON CI p1 VDD pm1p2_svt_lp L=6e-08 W=5.85e-07
.ENDS

.SUBCKT CGENCONAX1P4H9R CON VDD VSS A B CI
MXN1 n1 A VSS VSS nm1p2_svt_lp L=6e-08 W=3.05e-07
MXN2 n1 B VSS VSS nm1p2_svt_lp L=6e-08 W=3.05e-07
MXN3_2 n2__2 B VSS VSS nm1p2_svt_lp L=6e-08 W=3.05e-07
MXN4_2 CON A n2__2 VSS nm1p2_svt_lp L=6e-08 W=3.05e-07
MXN0 CON CI n1 VSS nm1p2_svt_lp L=6e-08 W=3.05e-07
MXN0_2 CON CI n1 VSS nm1p2_svt_lp L=6e-08 W=3.05e-07
MXN4 CON A n2 VSS nm1p2_svt_lp L=6e-08 W=3.05e-07
MXN3 n2 B VSS VSS nm1p2_svt_lp L=6e-08 W=3.05e-07
MXN2_2 n1 B VSS VSS nm1p2_svt_lp L=6e-08 W=3.05e-07
MXN1_2 n1 A VSS VSS nm1p2_svt_lp L=6e-08 W=3.05e-07
MXP0 p1 A VDD VDD pm1p2_svt_lp L=6e-08 W=4.1e-07
MXP1 p1 B VDD VDD pm1p2_svt_lp L=6e-08 W=4.1e-07
MXP4_2 p2__2 B VDD VDD pm1p2_svt_lp L=6e-08 W=4.1e-07
MXP3_2 CON A p2__2 VDD pm1p2_svt_lp L=6e-08 W=4.1e-07
MXP2 CON CI p1 VDD pm1p2_svt_lp L=6e-08 W=4.1e-07
MXP2_2 CON CI p1 VDD pm1p2_svt_lp L=6e-08 W=4.1e-07
MXP3 CON A p2 VDD pm1p2_svt_lp L=6e-08 W=4.1e-07
MXP4 p2 B VDD VDD pm1p2_svt_lp L=6e-08 W=4.1e-07
MXP1_2 p1 B VDD VDD pm1p2_svt_lp L=6e-08 W=4.1e-07
MXP0_2 p1 A VDD VDD pm1p2_svt_lp L=6e-08 W=4.1e-07
.ENDS

.SUBCKT CGENCONAX2H9R CON VDD VSS A B CI
MXN1 n1 A VSS VSS nm1p2_svt_lp L=6e-08 W=4e-07
MXN2 n1 B VSS VSS nm1p2_svt_lp L=6e-08 W=4e-07
MXN3_2 n2__2 B VSS VSS nm1p2_svt_lp L=6e-08 W=4e-07
MXN4_2 CON A n2__2 VSS nm1p2_svt_lp L=6e-08 W=4e-07
MXN0 CON CI n1 VSS nm1p2_svt_lp L=6e-08 W=4e-07
MXN0_2 CON CI n1 VSS nm1p2_svt_lp L=6e-08 W=4e-07
MXN4 CON A n2 VSS nm1p2_svt_lp L=6e-08 W=4e-07
MXN3 n2 B VSS VSS nm1p2_svt_lp L=6e-08 W=4e-07
MXN2_2 n1 B VSS VSS nm1p2_svt_lp L=6e-08 W=4e-07
MXN1_2 n1 A VSS VSS nm1p2_svt_lp L=6e-08 W=4e-07
MXP0 p1 A VDD VDD pm1p2_svt_lp L=6e-08 W=5.85e-07
MXP1 p1 B VDD VDD pm1p2_svt_lp L=6e-08 W=5.85e-07
MXP4_2 p2__2 B VDD VDD pm1p2_svt_lp L=6e-08 W=5.85e-07
MXP3_2 CON A p2__2 VDD pm1p2_svt_lp L=6e-08 W=5.85e-07
MXP2 CON CI p1 VDD pm1p2_svt_lp L=6e-08 W=5.85e-07
MXP2_2 CON CI p1 VDD pm1p2_svt_lp L=6e-08 W=5.85e-07
MXP3 CON A p2 VDD pm1p2_svt_lp L=6e-08 W=5.85e-07
MXP4 p2 B VDD VDD pm1p2_svt_lp L=6e-08 W=5.85e-07
MXP1_2 p1 B VDD VDD pm1p2_svt_lp L=6e-08 W=5.85e-07
MXP0_2 p1 A VDD VDD pm1p2_svt_lp L=6e-08 W=5.85e-07
.ENDS

.SUBCKT LATHQX0P5H9R Q VDD VSS D G
MI72_MXNA1 nclk G VSS VSS nm1p2_svt_lp L=6e-08 W=1.5e-07
MI74_MXNA1 nd D VSS VSS nm1p2_svt_lp L=6e-08 W=1.5e-07
MI70_MXNOE nm G nd VSS nm1p2_svt_lp L=6e-08 W=1.5e-07
MI71_MXNOE nm nclk XI71_n1 VSS nm1p2_svt_lp L=6e-08 W=1.5e-07
MI71_MXNA1 XI71_n1 m VSS VSS nm1p2_svt_lp L=6e-08 W=1.5e-07
MI69_MXNA1 m nm VSS VSS nm1p2_svt_lp L=6e-08 W=1.2e-07
MI75_MXNA1 Q nm VSS VSS nm1p2_svt_lp L=6e-08 W=2.1e-07
MI72_MXPA1 nclk G VDD VDD pm1p2_svt_lp L=6e-08 W=2e-07
MI74_MXPA1 nd D VDD VDD pm1p2_svt_lp L=6e-08 W=2.2e-07
MI70_MXPOEN nm nclk nd VDD pm1p2_svt_lp L=6e-08 W=1.5e-07
MI71_MXPOEN nm G XI71_p1 VDD pm1p2_svt_lp L=6e-08 W=1.5e-07
MI71_MXPA1 XI71_p1 m VDD VDD pm1p2_svt_lp L=6e-08 W=1.5e-07
MI69_MXPA1 m nm VDD VDD pm1p2_svt_lp L=6e-08 W=1.2e-07
MI75_MXPA1 Q nm VDD VDD pm1p2_svt_lp L=6e-08 W=2.95e-07
.ENDS

.SUBCKT LATHQX1H9R Q VDD VSS D G
MI72_MXNA1 nclk G VSS VSS nm1p2_svt_lp L=6e-08 W=1.5e-07
MI74_MXNA1 nd D VSS VSS nm1p2_svt_lp L=6e-08 W=2e-07
MI70_MXNOE nm G nd VSS nm1p2_svt_lp L=6e-08 W=2.6e-07
MI71_MXNOE nm nclk XI71_n1 VSS nm1p2_svt_lp L=6e-08 W=1.5e-07
MI71_MXNA1 XI71_n1 m VSS VSS nm1p2_svt_lp L=6e-08 W=1.5e-07
MI69_MXNA1 m nm VSS VSS nm1p2_svt_lp L=6e-08 W=1.2e-07
MI75_MXNA1 Q nm VSS VSS nm1p2_svt_lp L=6e-08 W=4.2e-07
MI72_MXPA1 nclk G VDD VDD pm1p2_svt_lp L=6e-08 W=2e-07
MI74_MXPA1 nd D VDD VDD pm1p2_svt_lp L=6e-08 W=3e-07
MI70_MXPOEN nm nclk nd VDD pm1p2_svt_lp L=6e-08 W=2.6e-07
MI71_MXPOEN nm G XI71_p1 VDD pm1p2_svt_lp L=6e-08 W=1.5e-07
MI71_MXPA1 XI71_p1 m VDD VDD pm1p2_svt_lp L=6e-08 W=1.5e-07
MI69_MXPA1 m nm VDD VDD pm1p2_svt_lp L=6e-08 W=1.2e-07
MI75_MXPA1 Q nm VDD VDD pm1p2_svt_lp L=6e-08 W=5.85e-07
.ENDS

.SUBCKT LATHQX2H9R Q VDD VSS D G
MI72_MXNA1 nclk G VSS VSS nm1p2_svt_lp L=6e-08 W=1.5e-07
MI74_MXNA1 nd D VSS VSS nm1p2_svt_lp L=6e-08 W=3e-07
MI70_MXNOE nm G nd VSS nm1p2_svt_lp L=6e-08 W=3.2e-07
MI71_MXNOE nm nclk XI71_n1 VSS nm1p2_svt_lp L=6e-08 W=1.5e-07
MI71_MXNA1 XI71_n1 m VSS VSS nm1p2_svt_lp L=6e-08 W=1.5e-07
MI69_MXNA1 m nm VSS VSS nm1p2_svt_lp L=6e-08 W=1.2e-07
MI75_MXNA1 Q nm VSS VSS nm1p2_svt_lp L=6e-08 W=4.2e-07
MI75_MXNA1_2 Q nm VSS VSS nm1p2_svt_lp L=6e-08 W=4.2e-07
MI72_MXPA1 nclk G VDD VDD pm1p2_svt_lp L=6e-08 W=2e-07
MI74_MXPA1 nd D VDD VDD pm1p2_svt_lp L=6e-08 W=4.7e-07
MI70_MXPOEN nm nclk nd VDD pm1p2_svt_lp L=6e-08 W=3.2e-07
MI71_MXPOEN nm G XI71_p1 VDD pm1p2_svt_lp L=6e-08 W=1.5e-07
MI71_MXPA1 XI71_p1 m VDD VDD pm1p2_svt_lp L=6e-08 W=1.5e-07
MI69_MXPA1 m nm VDD VDD pm1p2_svt_lp L=6e-08 W=1.2e-07
MI75_MXPA1 Q nm VDD VDD pm1p2_svt_lp L=6e-08 W=5.85e-07
MI75_MXPA1_2 Q nm VDD VDD pm1p2_svt_lp L=6e-08 W=5.85e-07
.ENDS

.SUBCKT LATHQX3H9R Q VDD VSS D G
MI72_MXNA1 nclk G VSS VSS nm1p2_svt_lp L=6e-08 W=1.7e-07
MI74_MXNA1 nd D VSS VSS nm1p2_svt_lp L=6e-08 W=3.55e-07
MI70_MXNOE nm G nd VSS nm1p2_svt_lp L=6e-08 W=3.9e-07
MI71_MXNOE nm nclk XI71_n1 VSS nm1p2_svt_lp L=6e-08 W=1.5e-07
MI71_MXNA1 XI71_n1 m VSS VSS nm1p2_svt_lp L=6e-08 W=1.5e-07
MI69_MXNA1 m nm VSS VSS nm1p2_svt_lp L=6e-08 W=1.2e-07
MI75_MXNA1 Q nm VSS VSS nm1p2_svt_lp L=6e-08 W=4.2e-07
MI75_MXNA1_2 Q nm VSS VSS nm1p2_svt_lp L=6e-08 W=4.2e-07
MI75_MXNA1_3 Q nm VSS VSS nm1p2_svt_lp L=6e-08 W=4.2e-07
MI72_MXPA1 nclk G VDD VDD pm1p2_svt_lp L=6e-08 W=2.4e-07
MI74_MXPA1 nd D VDD VDD pm1p2_svt_lp L=6e-08 W=5.85e-07
MI70_MXPOEN nm nclk nd VDD pm1p2_svt_lp L=6e-08 W=3.9e-07
MI71_MXPOEN nm G XI71_p1 VDD pm1p2_svt_lp L=6e-08 W=1.5e-07
MI71_MXPA1 XI71_p1 m VDD VDD pm1p2_svt_lp L=6e-08 W=1.5e-07
MI69_MXPA1 m nm VDD VDD pm1p2_svt_lp L=6e-08 W=1.2e-07
MI75_MXPA1 Q nm VDD VDD pm1p2_svt_lp L=6e-08 W=5.85e-07
MI75_MXPA1_2 Q nm VDD VDD pm1p2_svt_lp L=6e-08 W=5.85e-07
MI75_MXPA1_3 Q nm VDD VDD pm1p2_svt_lp L=6e-08 W=5.85e-07
.ENDS

.SUBCKT LATHQNX0P5H9R QN VDD VSS D G
MI72_MXNA1 nclk G VSS VSS nm1p2_svt_lp L=6e-08 W=1.5e-07
MI74_MXNA1 nd D VSS VSS nm1p2_svt_lp L=6e-08 W=1.5e-07
MI20_MXNOE nm G nd VSS nm1p2_svt_lp L=6e-08 W=1.5e-07
MI29_MXNOE nm nclk XI29_n1 VSS nm1p2_svt_lp L=6e-08 W=1.5e-07
MI29_MXNA1 XI29_n1 m VSS VSS nm1p2_svt_lp L=6e-08 W=1.5e-07
MI28_MXNA1 m nm VSS VSS nm1p2_svt_lp L=6e-08 W=1.5e-07
MI8_MXNA1 QN m VSS VSS nm1p2_svt_lp L=6e-08 W=2.1e-07
MI72_MXPA1 nclk G VDD VDD pm1p2_svt_lp L=6e-08 W=2e-07
MI74_MXPA1 nd D VDD VDD pm1p2_svt_lp L=6e-08 W=2.4e-07
MI20_MXPOEN nm nclk nd VDD pm1p2_svt_lp L=6e-08 W=1.5e-07
MI29_MXPOEN nm G XI29_p1 VDD pm1p2_svt_lp L=6e-08 W=1.5e-07
MI29_MXPA1 XI29_p1 m VDD VDD pm1p2_svt_lp L=6e-08 W=1.5e-07
MI28_MXPA1 m nm VDD VDD pm1p2_svt_lp L=6e-08 W=2.2e-07
MI8_MXPA1 QN m VDD VDD pm1p2_svt_lp L=6e-08 W=2.95e-07
.ENDS

.SUBCKT LATHQNX1H9R QN VDD VSS D G
MI72_MXNA1 nclk G VSS VSS nm1p2_svt_lp L=6e-08 W=1.5e-07
MI74_MXNA1 nd D VSS VSS nm1p2_svt_lp L=6e-08 W=2e-07
MI20_MXNOE nm G nd VSS nm1p2_svt_lp L=6e-08 W=2.6e-07
MI29_MXNOE nm nclk XI29_n1 VSS nm1p2_svt_lp L=6e-08 W=1.5e-07
MI29_MXNA1 XI29_n1 m VSS VSS nm1p2_svt_lp L=6e-08 W=1.5e-07
MI28_MXNA1 m nm VSS VSS nm1p2_svt_lp L=6e-08 W=2.2e-07
MI8_MXNA1 QN m VSS VSS nm1p2_svt_lp L=6e-08 W=4.2e-07
MI72_MXPA1 nclk G VDD VDD pm1p2_svt_lp L=6e-08 W=2e-07
MI74_MXPA1 nd D VDD VDD pm1p2_svt_lp L=6e-08 W=3.15e-07
MI20_MXPOEN nm nclk nd VDD pm1p2_svt_lp L=6e-08 W=2.6e-07
MI29_MXPOEN nm G XI29_p1 VDD pm1p2_svt_lp L=6e-08 W=1.5e-07
MI29_MXPA1 XI29_p1 m VDD VDD pm1p2_svt_lp L=6e-08 W=1.5e-07
MI28_MXPA1 m nm VDD VDD pm1p2_svt_lp L=6e-08 W=3e-07
MI8_MXPA1 QN m VDD VDD pm1p2_svt_lp L=6e-08 W=5.85e-07
.ENDS

.SUBCKT LATHQNX2H9R QN VDD VSS D G
MI72_MXNA1 nclk G VSS VSS nm1p2_svt_lp L=6e-08 W=1.5e-07
MI74_MXNA1 nd D VSS VSS nm1p2_svt_lp L=6e-08 W=3e-07
MI20_MXNOE nm G nd VSS nm1p2_svt_lp L=6e-08 W=3.2e-07
MI29_MXNOE nm nclk XI29_n1 VSS nm1p2_svt_lp L=6e-08 W=1.5e-07
MI29_MXNA1 XI29_n1 m VSS VSS nm1p2_svt_lp L=6e-08 W=1.5e-07
MI28_MXNA1 m nm VSS VSS nm1p2_svt_lp L=6e-08 W=3.2e-07
MI8_MXNA1 QN m VSS VSS nm1p2_svt_lp L=6e-08 W=4.2e-07
MI8_MXNA1_2 QN m VSS VSS nm1p2_svt_lp L=6e-08 W=4.2e-07
MI72_MXPA1 nclk G VDD VDD pm1p2_svt_lp L=6e-08 W=2e-07
MI74_MXPA1 nd D VDD VDD pm1p2_svt_lp L=6e-08 W=4.4e-07
MI20_MXPOEN nm nclk nd VDD pm1p2_svt_lp L=6e-08 W=3.2e-07
MI29_MXPOEN nm G XI29_p1 VDD pm1p2_svt_lp L=6e-08 W=1.5e-07
MI29_MXPA1 XI29_p1 m VDD VDD pm1p2_svt_lp L=6e-08 W=1.5e-07
MI28_MXPA1 m nm VDD VDD pm1p2_svt_lp L=6e-08 W=4e-07
MI8_MXPA1 QN m VDD VDD pm1p2_svt_lp L=6e-08 W=5.85e-07
MI8_MXPA1_2 QN m VDD VDD pm1p2_svt_lp L=6e-08 W=5.85e-07
.ENDS

.SUBCKT LATHQNX3H9R QN VDD VSS D G
MI72_MXNA1 nclk G VSS VSS nm1p2_svt_lp L=6e-08 W=1.5e-07
MI74_MXNA1 nd D VSS VSS nm1p2_svt_lp L=6e-08 W=3.2e-07
MI20_MXNOE nm G nd VSS nm1p2_svt_lp L=6e-08 W=3.2e-07
MI29_MXNOE nm nclk XI29_n1 VSS nm1p2_svt_lp L=6e-08 W=1.5e-07
MI29_MXNA1 XI29_n1 m VSS VSS nm1p2_svt_lp L=6e-08 W=1.5e-07
MI28_MXNA1 m nm VSS VSS nm1p2_svt_lp L=6e-08 W=3.3e-07
MI8_MXNA1 QN m VSS VSS nm1p2_svt_lp L=6e-08 W=4.2e-07
MI8_MXNA1_2 QN m VSS VSS nm1p2_svt_lp L=6e-08 W=4.2e-07
MI8_MXNA1_3 QN m VSS VSS nm1p2_svt_lp L=6e-08 W=4.2e-07
MI72_MXPA1 nclk G VDD VDD pm1p2_svt_lp L=6e-08 W=2e-07
MI74_MXPA1 nd D VDD VDD pm1p2_svt_lp L=6e-08 W=5.2e-07
MI20_MXPOEN nm nclk nd VDD pm1p2_svt_lp L=6e-08 W=3.2e-07
MI29_MXPOEN nm G XI29_p1 VDD pm1p2_svt_lp L=6e-08 W=1.5e-07
MI29_MXPA1 XI29_p1 m VDD VDD pm1p2_svt_lp L=6e-08 W=1.5e-07
MI28_MXPA1 m nm VDD VDD pm1p2_svt_lp L=6e-08 W=4.4e-07
MI8_MXPA1 QN m VDD VDD pm1p2_svt_lp L=6e-08 W=5.85e-07
MI8_MXPA1_2 QN m VDD VDD pm1p2_svt_lp L=6e-08 W=5.85e-07
MI8_MXPA1_3 QN m VDD VDD pm1p2_svt_lp L=6e-08 W=5.85e-07
.ENDS

.SUBCKT LATHQNX4H9R QN VDD VSS D G
MI72_MXNA1 nclk G VSS VSS nm1p2_svt_lp L=6e-08 W=1.7e-07
MI74_MXNA1 nd D VSS VSS nm1p2_svt_lp L=6e-08 W=3.6e-07
MI20_MXNOE nm G nd VSS nm1p2_svt_lp L=6e-08 W=4.5e-07
MI29_MXNOE nm nclk XI29_n1 VSS nm1p2_svt_lp L=6e-08 W=1.5e-07
MI29_MXNA1 XI29_n1 m VSS VSS nm1p2_svt_lp L=6e-08 W=1.5e-07
MI28_MXNA1 m nm VSS VSS nm1p2_svt_lp L=6e-08 W=3.7e-07
MI8_MXNA1 QN m VSS VSS nm1p2_svt_lp L=6e-08 W=4.2e-07
MI8_MXNA1_2 QN m VSS VSS nm1p2_svt_lp L=6e-08 W=4.2e-07
MI8_MXNA1_3 QN m VSS VSS nm1p2_svt_lp L=6e-08 W=4.2e-07
MI8_MXNA1_4 QN m VSS VSS nm1p2_svt_lp L=6e-08 W=4.2e-07
MI72_MXPA1 nclk G VDD VDD pm1p2_svt_lp L=6e-08 W=2.4e-07
MI74_MXPA1 nd D VDD VDD pm1p2_svt_lp L=6e-08 W=5.7e-07
MI20_MXPOEN nm nclk nd VDD pm1p2_svt_lp L=6e-08 W=4.5e-07
MI29_MXPOEN nm G XI29_p1 VDD pm1p2_svt_lp L=6e-08 W=1.5e-07
MI29_MXPA1 XI29_p1 m VDD VDD pm1p2_svt_lp L=6e-08 W=1.5e-07
MI28_MXPA1 m nm VDD VDD pm1p2_svt_lp L=6e-08 W=5.3e-07
MI8_MXPA1 QN m VDD VDD pm1p2_svt_lp L=6e-08 W=5.85e-07
MI8_MXPA1_2 QN m VDD VDD pm1p2_svt_lp L=6e-08 W=5.85e-07
MI8_MXPA1_3 QN m VDD VDD pm1p2_svt_lp L=6e-08 W=5.85e-07
MI8_MXPA1_4 QN m VDD VDD pm1p2_svt_lp L=6e-08 W=5.85e-07
.ENDS

.SUBCKT LATLQX0P5H9R Q VDD VSS D GN
MI72_MXNA1 nclk_ GN VSS VSS nm1p2_svt_lp L=6e-08 W=1.5e-07
MI74_MXNA1 nd D VSS VSS nm1p2_svt_lp L=6e-08 W=1.5e-07
MI70_MXNOE nm nclk_ nd VSS nm1p2_svt_lp L=6e-08 W=1.5e-07
MI71_MXNOE nm GN XI71_n1 VSS nm1p2_svt_lp L=6e-08 W=1.5e-07
MI71_MXNA1 XI71_n1 m VSS VSS nm1p2_svt_lp L=6e-08 W=1.5e-07
MI69_MXNA1 m nm VSS VSS nm1p2_svt_lp L=6e-08 W=1.2e-07
MI75_MXNA1 Q nm VSS VSS nm1p2_svt_lp L=6e-08 W=2.1e-07
MI72_MXPA1 nclk_ GN VDD VDD pm1p2_svt_lp L=6e-08 W=2e-07
MI74_MXPA1 nd D VDD VDD pm1p2_svt_lp L=6e-08 W=2.2e-07
MI70_MXPOEN nm GN nd VDD pm1p2_svt_lp L=6e-08 W=1.5e-07
MI71_MXPOEN nm nclk_ XI71_p1 VDD pm1p2_svt_lp L=6e-08 W=1.5e-07
MI71_MXPA1 XI71_p1 m VDD VDD pm1p2_svt_lp L=6e-08 W=1.5e-07
MI69_MXPA1 m nm VDD VDD pm1p2_svt_lp L=6e-08 W=1.2e-07
MI75_MXPA1 Q nm VDD VDD pm1p2_svt_lp L=6e-08 W=2.95e-07
.ENDS

.SUBCKT LATLQX1H9R Q VDD VSS D GN
MI72_MXNA1 nclk_ GN VSS VSS nm1p2_svt_lp L=6e-08 W=1.5e-07
MI74_MXNA1 nd D VSS VSS nm1p2_svt_lp L=6e-08 W=2e-07
MI70_MXNOE nm nclk_ nd VSS nm1p2_svt_lp L=6e-08 W=2.6e-07
MI71_MXNOE nm GN XI71_n1 VSS nm1p2_svt_lp L=6e-08 W=1.5e-07
MI71_MXNA1 XI71_n1 m VSS VSS nm1p2_svt_lp L=6e-08 W=1.5e-07
MI69_MXNA1 m nm VSS VSS nm1p2_svt_lp L=6e-08 W=1.2e-07
MI75_MXNA1 Q nm VSS VSS nm1p2_svt_lp L=6e-08 W=4.2e-07
MI72_MXPA1 nclk_ GN VDD VDD pm1p2_svt_lp L=6e-08 W=2e-07
MI74_MXPA1 nd D VDD VDD pm1p2_svt_lp L=6e-08 W=3.2e-07
MI70_MXPOEN nm GN nd VDD pm1p2_svt_lp L=6e-08 W=2.6e-07
MI71_MXPOEN nm nclk_ XI71_p1 VDD pm1p2_svt_lp L=6e-08 W=1.5e-07
MI71_MXPA1 XI71_p1 m VDD VDD pm1p2_svt_lp L=6e-08 W=1.5e-07
MI69_MXPA1 m nm VDD VDD pm1p2_svt_lp L=6e-08 W=1.2e-07
MI75_MXPA1 Q nm VDD VDD pm1p2_svt_lp L=6e-08 W=5.85e-07
.ENDS

.SUBCKT LATLQX2H9R Q VDD VSS D GN
MI72_MXNA1 nclk_ GN VSS VSS nm1p2_svt_lp L=6e-08 W=1.5e-07
MI74_MXNA1 nd D VSS VSS nm1p2_svt_lp L=6e-08 W=3.1e-07
MI70_MXNOE nm nclk_ nd VSS nm1p2_svt_lp L=6e-08 W=3.2e-07
MI71_MXNOE nm GN XI71_n1 VSS nm1p2_svt_lp L=6e-08 W=1.5e-07
MI71_MXNA1 XI71_n1 m VSS VSS nm1p2_svt_lp L=6e-08 W=1.5e-07
MI75_MXNA1 Q nm VSS VSS nm1p2_svt_lp L=6e-08 W=4.2e-07
MI75_MXNA1_2 Q nm VSS VSS nm1p2_svt_lp L=6e-08 W=4.2e-07
MI69_MXNA1 m nm VSS VSS nm1p2_svt_lp L=6e-08 W=1.2e-07
MI72_MXPA1 nclk_ GN VDD VDD pm1p2_svt_lp L=6e-08 W=2e-07
MI74_MXPA1 nd D VDD VDD pm1p2_svt_lp L=6e-08 W=5.3e-07
MI70_MXPOEN nm GN nd VDD pm1p2_svt_lp L=6e-08 W=3.2e-07
MI71_MXPOEN nm nclk_ XI71_p1 VDD pm1p2_svt_lp L=6e-08 W=1.5e-07
MI71_MXPA1 XI71_p1 m VDD VDD pm1p2_svt_lp L=6e-08 W=1.5e-07
MI75_MXPA1 Q nm VDD VDD pm1p2_svt_lp L=6e-08 W=5.85e-07
MI75_MXPA1_2 Q nm VDD VDD pm1p2_svt_lp L=6e-08 W=5.85e-07
MI69_MXPA1 m nm VDD VDD pm1p2_svt_lp L=6e-08 W=1.2e-07
.ENDS

.SUBCKT LATLQX3H9R Q VDD VSS D GN
MI72_MXNA1 nclk_ GN VSS VSS nm1p2_svt_lp L=6e-08 W=1.7e-07
MI74_MXNA1 nd D VSS VSS nm1p2_svt_lp L=6e-08 W=3.3e-07
MI70_MXNOE nm nclk_ nd VSS nm1p2_svt_lp L=6e-08 W=3.9e-07
MI71_MXNOE nm GN XI71_n1 VSS nm1p2_svt_lp L=6e-08 W=1.5e-07
MI71_MXNA1 XI71_n1 m VSS VSS nm1p2_svt_lp L=6e-08 W=1.5e-07
MI69_MXNA1 m nm VSS VSS nm1p2_svt_lp L=6e-08 W=1.2e-07
MI75_MXNA1 Q nm VSS VSS nm1p2_svt_lp L=6e-08 W=4.2e-07
MI75_MXNA1_2 Q nm VSS VSS nm1p2_svt_lp L=6e-08 W=4.2e-07
MI75_MXNA1_3 Q nm VSS VSS nm1p2_svt_lp L=6e-08 W=4.2e-07
MI72_MXPA1 nclk_ GN VDD VDD pm1p2_svt_lp L=6e-08 W=2.4e-07
MI74_MXPA1 nd D VDD VDD pm1p2_svt_lp L=6e-08 W=5.85e-07
MI70_MXPOEN nm GN nd VDD pm1p2_svt_lp L=6e-08 W=3.9e-07
MI71_MXPOEN nm nclk_ XI71_p1 VDD pm1p2_svt_lp L=6e-08 W=1.5e-07
MI71_MXPA1 XI71_p1 m VDD VDD pm1p2_svt_lp L=6e-08 W=1.5e-07
MI69_MXPA1 m nm VDD VDD pm1p2_svt_lp L=6e-08 W=1.2e-07
MI75_MXPA1 Q nm VDD VDD pm1p2_svt_lp L=6e-08 W=5.85e-07
MI75_MXPA1_2 Q nm VDD VDD pm1p2_svt_lp L=6e-08 W=5.85e-07
MI75_MXPA1_3 Q nm VDD VDD pm1p2_svt_lp L=6e-08 W=5.85e-07
.ENDS

.SUBCKT LATLQNX0P5H9R QN VDD VSS D GN
MI72_MXNA1 nclk_ GN VSS VSS nm1p2_svt_lp L=6e-08 W=1.5e-07
MI74_MXNA1 nd D VSS VSS nm1p2_svt_lp L=6e-08 W=1.5e-07
MI20_MXNOE nm nclk_ nd VSS nm1p2_svt_lp L=6e-08 W=1.5e-07
MI29_MXNOE nm GN XI29_n1 VSS nm1p2_svt_lp L=6e-08 W=1.5e-07
MI29_MXNA1 XI29_n1 m VSS VSS nm1p2_svt_lp L=6e-08 W=1.5e-07
MI28_MXNA1 m nm VSS VSS nm1p2_svt_lp L=6e-08 W=1.5e-07
MI8_MXNA1 QN m VSS VSS nm1p2_svt_lp L=6e-08 W=2.1e-07
MI72_MXPA1 nclk_ GN VDD VDD pm1p2_svt_lp L=6e-08 W=2e-07
MI74_MXPA1 nd D VDD VDD pm1p2_svt_lp L=6e-08 W=2.5e-07
MI20_MXPOEN nm GN nd VDD pm1p2_svt_lp L=6e-08 W=1.5e-07
MI29_MXPOEN nm nclk_ XI29_p1 VDD pm1p2_svt_lp L=6e-08 W=1.5e-07
MI29_MXPA1 XI29_p1 m VDD VDD pm1p2_svt_lp L=6e-08 W=1.5e-07
MI28_MXPA1 m nm VDD VDD pm1p2_svt_lp L=6e-08 W=2.2e-07
MI8_MXPA1 QN m VDD VDD pm1p2_svt_lp L=6e-08 W=2.95e-07
.ENDS

.SUBCKT LATLQNX1H9R QN VDD VSS D GN
MI72_MXNA1 nclk_ GN VSS VSS nm1p2_svt_lp L=6e-08 W=1.5e-07
MI74_MXNA1 nd D VSS VSS nm1p2_svt_lp L=6e-08 W=2e-07
MI20_MXNOE nm nclk_ nd VSS nm1p2_svt_lp L=6e-08 W=2.6e-07
MI29_MXNOE nm GN XI29_n1 VSS nm1p2_svt_lp L=6e-08 W=1.5e-07
MI29_MXNA1 XI29_n1 m VSS VSS nm1p2_svt_lp L=6e-08 W=1.5e-07
MI28_MXNA1 m nm VSS VSS nm1p2_svt_lp L=6e-08 W=2.4e-07
MI8_MXNA1 QN m VSS VSS nm1p2_svt_lp L=6e-08 W=4.2e-07
MI72_MXPA1 nclk_ GN VDD VDD pm1p2_svt_lp L=6e-08 W=2e-07
MI74_MXPA1 nd D VDD VDD pm1p2_svt_lp L=6e-08 W=3.6e-07
MI20_MXPOEN nm GN nd VDD pm1p2_svt_lp L=6e-08 W=2.6e-07
MI29_MXPOEN nm nclk_ XI29_p1 VDD pm1p2_svt_lp L=6e-08 W=1.5e-07
MI29_MXPA1 XI29_p1 m VDD VDD pm1p2_svt_lp L=6e-08 W=1.5e-07
MI28_MXPA1 m nm VDD VDD pm1p2_svt_lp L=6e-08 W=3.5e-07
MI8_MXPA1 QN m VDD VDD pm1p2_svt_lp L=6e-08 W=5.85e-07
.ENDS

.SUBCKT LATLQNX2H9R QN VDD VSS D GN
MI72_MXNA1 nclk_ GN VSS VSS nm1p2_svt_lp L=6e-08 W=1.5e-07
MI74_MXNA1 nd D VSS VSS nm1p2_svt_lp L=6e-08 W=3.2e-07
MI20_MXNOE nm nclk_ nd VSS nm1p2_svt_lp L=6e-08 W=3.2e-07
MI29_MXNOE nm GN XI29_n1 VSS nm1p2_svt_lp L=6e-08 W=1.5e-07
MI29_MXNA1 XI29_n1 m VSS VSS nm1p2_svt_lp L=6e-08 W=1.5e-07
MI8_MXNA1 QN m VSS VSS nm1p2_svt_lp L=6e-08 W=4.2e-07
MI8_MXNA1_2 QN m VSS VSS nm1p2_svt_lp L=6e-08 W=4.2e-07
MI28_MXNA1 m nm VSS VSS nm1p2_svt_lp L=6e-08 W=3.9e-07
MI72_MXPA1 nclk_ GN VDD VDD pm1p2_svt_lp L=6e-08 W=2e-07
MI74_MXPA1 nd D VDD VDD pm1p2_svt_lp L=6e-08 W=4.5e-07
MI20_MXPOEN nm GN nd VDD pm1p2_svt_lp L=6e-08 W=3.2e-07
MI29_MXPOEN nm nclk_ XI29_p1 VDD pm1p2_svt_lp L=6e-08 W=1.5e-07
MI29_MXPA1 XI29_p1 m VDD VDD pm1p2_svt_lp L=6e-08 W=1.5e-07
MI8_MXPA1 QN m VDD VDD pm1p2_svt_lp L=6e-08 W=5.85e-07
MI8_MXPA1_2 QN m VDD VDD pm1p2_svt_lp L=6e-08 W=5.85e-07
MI28_MXPA1 m nm VDD VDD pm1p2_svt_lp L=6e-08 W=4.4e-07
.ENDS

.SUBCKT LATLQNX3H9R QN VDD VSS D GN
MI72_MXNA1 nclk_ GN VSS VSS nm1p2_svt_lp L=6e-08 W=1.5e-07
MI74_MXNA1 nd D VSS VSS nm1p2_svt_lp L=6e-08 W=3.2e-07
MI20_MXNOE nm nclk_ nd VSS nm1p2_svt_lp L=6e-08 W=3.9e-07
MI29_MXNOE nm GN XI29_n1 VSS nm1p2_svt_lp L=6e-08 W=1.5e-07
MI29_MXNA1 XI29_n1 m VSS VSS nm1p2_svt_lp L=6e-08 W=1.5e-07
MI28_MXNA1 m nm VSS VSS nm1p2_svt_lp L=6e-08 W=4.2e-07
MI8_MXNA1 QN m VSS VSS nm1p2_svt_lp L=6e-08 W=4.2e-07
MI8_MXNA1_2 QN m VSS VSS nm1p2_svt_lp L=6e-08 W=4.2e-07
MI8_MXNA1_3 QN m VSS VSS nm1p2_svt_lp L=6e-08 W=4.2e-07
MI72_MXPA1 nclk_ GN VDD VDD pm1p2_svt_lp L=6e-08 W=2e-07
MI74_MXPA1 nd D VDD VDD pm1p2_svt_lp L=6e-08 W=5.4e-07
MI20_MXPOEN nm GN nd VDD pm1p2_svt_lp L=6e-08 W=3.9e-07
MI29_MXPOEN nm nclk_ XI29_p1 VDD pm1p2_svt_lp L=6e-08 W=1.5e-07
MI29_MXPA1 XI29_p1 m VDD VDD pm1p2_svt_lp L=6e-08 W=1.5e-07
MI28_MXPA1 m nm VDD VDD pm1p2_svt_lp L=6e-08 W=5.6e-07
MI8_MXPA1 QN m VDD VDD pm1p2_svt_lp L=6e-08 W=5.85e-07
MI8_MXPA1_2 QN m VDD VDD pm1p2_svt_lp L=6e-08 W=5.85e-07
MI8_MXPA1_3 QN m VDD VDD pm1p2_svt_lp L=6e-08 W=5.85e-07
.ENDS

.SUBCKT LATLQNX4H9R QN VDD VSS D GN
MI72_MXNA1 nclk_ GN VSS VSS nm1p2_svt_lp L=6e-08 W=1.7e-07
MI74_MXNA1 nd D VSS VSS nm1p2_svt_lp L=6e-08 W=3.8e-07
MI20_MXNOE nm nclk_ nd VSS nm1p2_svt_lp L=6e-08 W=4.5e-07
MI29_MXNOE nm GN XI29_n1 VSS nm1p2_svt_lp L=6e-08 W=1.5e-07
MI29_MXNA1 XI29_n1 m VSS VSS nm1p2_svt_lp L=6e-08 W=1.5e-07
MI28_MXNA1 m nm VSS VSS nm1p2_svt_lp L=6e-08 W=4.7e-07
MI8_MXNA1 QN m VSS VSS nm1p2_svt_lp L=6e-08 W=4.2e-07
MI8_MXNA1_2 QN m VSS VSS nm1p2_svt_lp L=6e-08 W=4.2e-07
MI8_MXNA1_3 QN m VSS VSS nm1p2_svt_lp L=6e-08 W=4.2e-07
MI8_MXNA1_4 QN m VSS VSS nm1p2_svt_lp L=6e-08 W=4.2e-07
MI72_MXPA1 nclk_ GN VDD VDD pm1p2_svt_lp L=6e-08 W=2.4e-07
MI74_MXPA1 nd D VDD VDD pm1p2_svt_lp L=6e-08 W=5.8e-07
MI20_MXPOEN nm GN nd VDD pm1p2_svt_lp L=6e-08 W=4.5e-07
MI29_MXPOEN nm nclk_ XI29_p1 VDD pm1p2_svt_lp L=6e-08 W=1.5e-07
MI29_MXPA1 XI29_p1 m VDD VDD pm1p2_svt_lp L=6e-08 W=1.5e-07
MI28_MXPA1 m nm VDD VDD pm1p2_svt_lp L=6e-08 W=5.85e-07
MI8_MXPA1 QN m VDD VDD pm1p2_svt_lp L=6e-08 W=5.85e-07
MI8_MXPA1_2 QN m VDD VDD pm1p2_svt_lp L=6e-08 W=5.85e-07
MI8_MXPA1_3 QN m VDD VDD pm1p2_svt_lp L=6e-08 W=5.85e-07
MI8_MXPA1_4 QN m VDD VDD pm1p2_svt_lp L=6e-08 W=5.85e-07
.ENDS

.SUBCKT LATHRQX0P5H9R Q VDD VSS D G RN
MI72_MXNA1 nclk G VSS VSS nm1p2_svt_lp L=6e-08 W=1.5e-07
MXN1 net39 RN VSS VSS nm1p2_svt_lp L=6e-08 W=1.8e-07
MXN0 nd D net39 VSS nm1p2_svt_lp L=6e-08 W=1.8e-07
MI70_MXNOE nm G nd VSS nm1p2_svt_lp L=6e-08 W=1.5e-07
MXN2 nm nclk net42 VSS nm1p2_svt_lp L=6e-08 W=2e-07
MXN3 net42 m net46 VSS nm1p2_svt_lp L=6e-08 W=2e-07
MXN4 net46 RN VSS VSS nm1p2_svt_lp L=6e-08 W=2e-07
MI69_MXNA1 m nm VSS VSS nm1p2_svt_lp L=6e-08 W=1.2e-07
MI75_MXNA1 Q nm VSS VSS nm1p2_svt_lp L=6e-08 W=2.1e-07
MI72_MXPA1 nclk G VDD VDD pm1p2_svt_lp L=6e-08 W=2e-07
MXP0 nd D VDD VDD pm1p2_svt_lp L=6e-08 W=1.7e-07
MI70_MXPOEN nm nclk nd VDD pm1p2_svt_lp L=6e-08 W=1.5e-07
MXP3 nm G net67 VDD pm1p2_svt_lp L=6e-08 W=1.5e-07
MXP2 net67 m VDD VDD pm1p2_svt_lp L=6e-08 W=1.5e-07
MXP1 nm RN VDD VDD pm1p2_svt_lp L=6e-08 W=1.5e-07
MI69_MXPA1 m nm VDD VDD pm1p2_svt_lp L=6e-08 W=1.2e-07
MI75_MXPA1 Q nm VDD VDD pm1p2_svt_lp L=6e-08 W=2.95e-07
.ENDS

.SUBCKT LATHRQX1H9R Q VDD VSS D G RN
MI72_MXNA1 nclk G VSS VSS nm1p2_svt_lp L=6e-08 W=1.5e-07
MXN1 net39 RN VSS VSS nm1p2_svt_lp L=6e-08 W=2.9e-07
MXN0 nd D net39 VSS nm1p2_svt_lp L=6e-08 W=2.9e-07
MI70_MXNOE nm G nd VSS nm1p2_svt_lp L=6e-08 W=2.6e-07
MXN2 nm nclk net42 VSS nm1p2_svt_lp L=6e-08 W=2e-07
MXN3 net42 m net46 VSS nm1p2_svt_lp L=6e-08 W=2e-07
MXN4 net46 RN VSS VSS nm1p2_svt_lp L=6e-08 W=2e-07
MI69_MXNA1 m nm VSS VSS nm1p2_svt_lp L=6e-08 W=1.2e-07
MI75_MXNA1 Q nm VSS VSS nm1p2_svt_lp L=6e-08 W=4.2e-07
MI72_MXPA1 nclk G VDD VDD pm1p2_svt_lp L=6e-08 W=2e-07
MXP0 nd D VDD VDD pm1p2_svt_lp L=6e-08 W=2.8e-07
MI70_MXPOEN nm nclk nd VDD pm1p2_svt_lp L=6e-08 W=2.6e-07
MXP3 nm G net67 VDD pm1p2_svt_lp L=6e-08 W=1.5e-07
MXP2 net67 m VDD VDD pm1p2_svt_lp L=6e-08 W=1.5e-07
MXP1 nm RN VDD VDD pm1p2_svt_lp L=6e-08 W=1.5e-07
MI69_MXPA1 m nm VDD VDD pm1p2_svt_lp L=6e-08 W=1.2e-07
MI75_MXPA1 Q nm VDD VDD pm1p2_svt_lp L=6e-08 W=5.85e-07
.ENDS

.SUBCKT LATHRQX2H9R Q VDD VSS D G RN
MI72_MXNA1 nclk G VSS VSS nm1p2_svt_lp L=6e-08 W=1.5e-07
MXN1 net39 RN VSS VSS nm1p2_svt_lp L=6e-08 W=4e-07
MXN0 nd D net39 VSS nm1p2_svt_lp L=6e-08 W=4e-07
MI70_MXNOE nm G nd VSS nm1p2_svt_lp L=6e-08 W=3.2e-07
MXN2 nm nclk net42 VSS nm1p2_svt_lp L=6e-08 W=2e-07
MXN3 net42 m net46 VSS nm1p2_svt_lp L=6e-08 W=2e-07
MXN4 net46 RN VSS VSS nm1p2_svt_lp L=6e-08 W=2e-07
MI69_MXNA1 m nm VSS VSS nm1p2_svt_lp L=6e-08 W=1.2e-07
MI75_MXNA1 Q nm VSS VSS nm1p2_svt_lp L=6e-08 W=4.2e-07
MI75_MXNA1_2 Q nm VSS VSS nm1p2_svt_lp L=6e-08 W=4.2e-07
MI72_MXPA1 nclk G VDD VDD pm1p2_svt_lp L=6e-08 W=2e-07
MXP0 nd D VDD VDD pm1p2_svt_lp L=6e-08 W=4e-07
MI70_MXPOEN nm nclk nd VDD pm1p2_svt_lp L=6e-08 W=3.2e-07
MXP3 nm G net67 VDD pm1p2_svt_lp L=6e-08 W=1.5e-07
MXP2 net67 m VDD VDD pm1p2_svt_lp L=6e-08 W=1.5e-07
MXP1 nm RN VDD VDD pm1p2_svt_lp L=6e-08 W=1.5e-07
MI69_MXPA1 m nm VDD VDD pm1p2_svt_lp L=6e-08 W=1.2e-07
MI75_MXPA1 Q nm VDD VDD pm1p2_svt_lp L=6e-08 W=5.85e-07
MI75_MXPA1_2 Q nm VDD VDD pm1p2_svt_lp L=6e-08 W=5.85e-07
.ENDS

.SUBCKT LATHRQX3H9R Q VDD VSS D G RN
MI72_MXNA1 nclk G VSS VSS nm1p2_svt_lp L=6e-08 W=1.7e-07
MXN1 net39 RN VSS VSS nm1p2_svt_lp L=6e-08 W=4.7e-07
MXN0 nd D net39 VSS nm1p2_svt_lp L=6e-08 W=4.7e-07
MI70_MXNOE nm G nd VSS nm1p2_svt_lp L=6e-08 W=3.9e-07
MXN2 nm nclk net42 VSS nm1p2_svt_lp L=6e-08 W=2e-07
MXN3 net42 m net46 VSS nm1p2_svt_lp L=6e-08 W=2e-07
MXN4 net46 RN VSS VSS nm1p2_svt_lp L=6e-08 W=2e-07
MI69_MXNA1 m nm VSS VSS nm1p2_svt_lp L=6e-08 W=1.2e-07
MI75_MXNA1 Q nm VSS VSS nm1p2_svt_lp L=6e-08 W=4.2e-07
MI75_MXNA1_2 Q nm VSS VSS nm1p2_svt_lp L=6e-08 W=4.2e-07
MI75_MXNA1_3 Q nm VSS VSS nm1p2_svt_lp L=6e-08 W=4.2e-07
MI72_MXPA1 nclk G VDD VDD pm1p2_svt_lp L=6e-08 W=2.4e-07
MXP0 nd D VDD VDD pm1p2_svt_lp L=6e-08 W=4.7e-07
MI70_MXPOEN nm nclk nd VDD pm1p2_svt_lp L=6e-08 W=3.9e-07
MXP3 nm G net67 VDD pm1p2_svt_lp L=6e-08 W=1.5e-07
MXP2 net67 m VDD VDD pm1p2_svt_lp L=6e-08 W=1.5e-07
MXP1 nm RN VDD VDD pm1p2_svt_lp L=6e-08 W=1.5e-07
MI69_MXPA1 m nm VDD VDD pm1p2_svt_lp L=6e-08 W=1.2e-07
MI75_MXPA1 Q nm VDD VDD pm1p2_svt_lp L=6e-08 W=5.85e-07
MI75_MXPA1_2 Q nm VDD VDD pm1p2_svt_lp L=6e-08 W=5.85e-07
MI75_MXPA1_3 Q nm VDD VDD pm1p2_svt_lp L=6e-08 W=5.85e-07
.ENDS

.SUBCKT LATHRPQNX0P5H9R QN VDD VSS D G R
MI72_MXNA1 nclk G VSS VSS nm1p2_svt_lp L=6e-08 W=1.5e-07
MI74_MXNA1 nd D VSS VSS nm1p2_svt_lp L=6e-08 W=1.5e-07
MI20_MXNOE nm G nd VSS nm1p2_svt_lp L=6e-08 W=1.5e-07
MI29_MXNOE nm nclk XI29_n1 VSS nm1p2_svt_lp L=6e-08 W=1.5e-07
MI29_MXNA1 XI29_n1 m VSS VSS nm1p2_svt_lp L=6e-08 W=1.5e-07
MI78_MXNA1 m nm VSS VSS nm1p2_svt_lp L=6e-08 W=1.5e-07
MI78_MXNA2 m R VSS VSS nm1p2_svt_lp L=6e-08 W=1.5e-07
MI8_MXNA1 QN m VSS VSS nm1p2_svt_lp L=6e-08 W=2.1e-07
MI72_MXPA1 nclk G VDD VDD pm1p2_svt_lp L=6e-08 W=2e-07
MI74_MXPA1 nd D VDD VDD pm1p2_svt_lp L=6e-08 W=2e-07
MI20_MXPOEN nm nclk nd VDD pm1p2_svt_lp L=6e-08 W=1.5e-07
MI29_MXPOEN nm G XI29_p1 VDD pm1p2_svt_lp L=6e-08 W=1.5e-07
MI29_MXPA1 XI29_p1 m VDD VDD pm1p2_svt_lp L=6e-08 W=1.5e-07
MI78_MXPA1 m nm XI78_p1 VDD pm1p2_svt_lp L=6e-08 W=3e-07
MI78_MXPA2 XI78_p1 R VDD VDD pm1p2_svt_lp L=6e-08 W=3e-07
MI8_MXPA1 QN m VDD VDD pm1p2_svt_lp L=6e-08 W=2.95e-07
.ENDS

.SUBCKT LATHRPQNX1H9R QN VDD VSS D G R
MI72_MXNA1 nclk G VSS VSS nm1p2_svt_lp L=6e-08 W=1.5e-07
MI74_MXNA1 nd D VSS VSS nm1p2_svt_lp L=6e-08 W=2.2e-07
MI20_MXNOE nm G nd VSS nm1p2_svt_lp L=6e-08 W=2.6e-07
MI29_MXNOE nm nclk XI29_n1 VSS nm1p2_svt_lp L=6e-08 W=1.5e-07
MI29_MXNA1 XI29_n1 m VSS VSS nm1p2_svt_lp L=6e-08 W=1.5e-07
MI78_MXNA1 m nm VSS VSS nm1p2_svt_lp L=6e-08 W=2e-07
MI78_MXNA2 m R VSS VSS nm1p2_svt_lp L=6e-08 W=2e-07
MI8_MXNA1 QN m VSS VSS nm1p2_svt_lp L=6e-08 W=4.2e-07
MI72_MXPA1 nclk G VDD VDD pm1p2_svt_lp L=6e-08 W=2e-07
MI74_MXPA1 nd D VDD VDD pm1p2_svt_lp L=6e-08 W=3.1e-07
MI20_MXPOEN nm nclk nd VDD pm1p2_svt_lp L=6e-08 W=2.6e-07
MI29_MXPOEN nm G XI29_p1 VDD pm1p2_svt_lp L=6e-08 W=1.5e-07
MI29_MXPA1 XI29_p1 m VDD VDD pm1p2_svt_lp L=6e-08 W=1.5e-07
MI78_MXPA1 m nm XI78_p1 VDD pm1p2_svt_lp L=6e-08 W=4.5e-07
MI78_MXPA2 XI78_p1 R VDD VDD pm1p2_svt_lp L=6e-08 W=4.5e-07
MI8_MXPA1 QN m VDD VDD pm1p2_svt_lp L=6e-08 W=5.85e-07
.ENDS

.SUBCKT LATHRPQNX2H9R QN VDD VSS D G R
MI72_MXNA1 nclk G VSS VSS nm1p2_svt_lp L=6e-08 W=1.5e-07
MI74_MXNA1 nd D VSS VSS nm1p2_svt_lp L=6e-08 W=2.8e-07
MI20_MXNOE nm G nd VSS nm1p2_svt_lp L=6e-08 W=3.2e-07
MI29_MXNOE nm nclk XI29_n1 VSS nm1p2_svt_lp L=6e-08 W=1.5e-07
MI29_MXNA1 XI29_n1 m VSS VSS nm1p2_svt_lp L=6e-08 W=1.5e-07
MI78_MXNA1 m nm VSS VSS nm1p2_svt_lp L=6e-08 W=2e-07
MI78_MXNA2 m R VSS VSS nm1p2_svt_lp L=6e-08 W=2e-07
MI8_MXNA1 QN m VSS VSS nm1p2_svt_lp L=6e-08 W=4.2e-07
MI8_MXNA1_2 QN m VSS VSS nm1p2_svt_lp L=6e-08 W=4.2e-07
MI72_MXPA1 nclk G VDD VDD pm1p2_svt_lp L=6e-08 W=2e-07
MI74_MXPA1 nd D VDD VDD pm1p2_svt_lp L=6e-08 W=4.5e-07
MI20_MXPOEN nm nclk nd VDD pm1p2_svt_lp L=6e-08 W=3.2e-07
MI29_MXPOEN nm G XI29_p1 VDD pm1p2_svt_lp L=6e-08 W=1.5e-07
MI29_MXPA1 XI29_p1 m VDD VDD pm1p2_svt_lp L=6e-08 W=1.5e-07
MI78_MXPA1 m nm XI78_p1 VDD pm1p2_svt_lp L=6e-08 W=5.7e-07
MI78_MXPA2 XI78_p1 R VDD VDD pm1p2_svt_lp L=6e-08 W=5.7e-07
MI8_MXPA1 QN m VDD VDD pm1p2_svt_lp L=6e-08 W=5.85e-07
MI8_MXPA1_2 QN m VDD VDD pm1p2_svt_lp L=6e-08 W=5.85e-07
.ENDS

.SUBCKT LATHRPQNX3H9R QN VDD VSS D G R
MI72_MXNA1 nclk G VSS VSS nm1p2_svt_lp L=6e-08 W=1.5e-07
MI74_MXNA1 nd D VSS VSS nm1p2_svt_lp L=6e-08 W=3.4e-07
MI20_MXNOE nm G nd VSS nm1p2_svt_lp L=6e-08 W=3.9e-07
MI29_MXNOE nm nclk XI29_n1 VSS nm1p2_svt_lp L=6e-08 W=1.5e-07
MI29_MXNA1 XI29_n1 m VSS VSS nm1p2_svt_lp L=6e-08 W=1.5e-07
MI78_MXNA1 m nm VSS VSS nm1p2_svt_lp L=6e-08 W=2e-07
MI78_MXNA2 m R VSS VSS nm1p2_svt_lp L=6e-08 W=2e-07
MI8_MXNA1 QN m VSS VSS nm1p2_svt_lp L=6e-08 W=4.2e-07
MI8_MXNA1_2 QN m VSS VSS nm1p2_svt_lp L=6e-08 W=4.2e-07
MI8_MXNA1_3 QN m VSS VSS nm1p2_svt_lp L=6e-08 W=4.2e-07
MI72_MXPA1 nclk G VDD VDD pm1p2_svt_lp L=6e-08 W=2e-07
MI74_MXPA1 nd D VDD VDD pm1p2_svt_lp L=6e-08 W=5.4e-07
MI20_MXPOEN nm nclk nd VDD pm1p2_svt_lp L=6e-08 W=3.9e-07
MI29_MXPOEN nm G XI29_p1 VDD pm1p2_svt_lp L=6e-08 W=1.5e-07
MI29_MXPA1 XI29_p1 m VDD VDD pm1p2_svt_lp L=6e-08 W=1.5e-07
MI78_MXPA1 m nm XI78_p1 VDD pm1p2_svt_lp L=6e-08 W=5.85e-07
MI78_MXPA2 XI78_p1 R VDD VDD pm1p2_svt_lp L=6e-08 W=5.85e-07
MI8_MXPA1 QN m VDD VDD pm1p2_svt_lp L=6e-08 W=5.85e-07
MI8_MXPA1_2 QN m VDD VDD pm1p2_svt_lp L=6e-08 W=5.85e-07
MI8_MXPA1_3 QN m VDD VDD pm1p2_svt_lp L=6e-08 W=5.85e-07
.ENDS

.SUBCKT LATHRPQNX4H9R QN VDD VSS D G R
MI72_MXNA1 nclk G VSS VSS nm1p2_svt_lp L=6e-08 W=1.7e-07
MI74_MXNA1 nd D VSS VSS nm1p2_svt_lp L=6e-08 W=4e-07
MI20_MXNOE nm G nd VSS nm1p2_svt_lp L=6e-08 W=4.5e-07
MI29_MXNOE nm nclk XI29_n1 VSS nm1p2_svt_lp L=6e-08 W=1.5e-07
MI29_MXNA1 XI29_n1 m VSS VSS nm1p2_svt_lp L=6e-08 W=1.5e-07
MI78_MXNA1 m nm VSS VSS nm1p2_svt_lp L=6e-08 W=2e-07
MI78_MXNA2 m R VSS VSS nm1p2_svt_lp L=6e-08 W=2e-07
MI8_MXNA1 QN m VSS VSS nm1p2_svt_lp L=6e-08 W=4.2e-07
MI8_MXNA1_2 QN m VSS VSS nm1p2_svt_lp L=6e-08 W=4.2e-07
MI8_MXNA1_3 QN m VSS VSS nm1p2_svt_lp L=6e-08 W=4.2e-07
MI8_MXNA1_4 QN m VSS VSS nm1p2_svt_lp L=6e-08 W=4.2e-07
MI72_MXPA1 nclk G VDD VDD pm1p2_svt_lp L=6e-08 W=2.4e-07
MI74_MXPA1 nd D VDD VDD pm1p2_svt_lp L=6e-08 W=5.5e-07
MI20_MXPOEN nm nclk nd VDD pm1p2_svt_lp L=6e-08 W=4.5e-07
MI29_MXPOEN nm G XI29_p1 VDD pm1p2_svt_lp L=6e-08 W=1.5e-07
MI29_MXPA1 XI29_p1 m VDD VDD pm1p2_svt_lp L=6e-08 W=1.5e-07
MI78_MXPA1 m nm XI78_p1 VDD pm1p2_svt_lp L=6e-08 W=5.85e-07
MI78_MXPA2 XI78_p1 R VDD VDD pm1p2_svt_lp L=6e-08 W=5.85e-07
MI8_MXPA1 QN m VDD VDD pm1p2_svt_lp L=6e-08 W=5.85e-07
MI8_MXPA1_2 QN m VDD VDD pm1p2_svt_lp L=6e-08 W=5.85e-07
MI8_MXPA1_3 QN m VDD VDD pm1p2_svt_lp L=6e-08 W=5.85e-07
MI8_MXPA1_4 QN m VDD VDD pm1p2_svt_lp L=6e-08 W=5.85e-07
.ENDS

.SUBCKT LATLRQX0P5H9R Q VDD VSS D GN RN
MI72_MXNA1 nclk_ GN VSS VSS nm1p2_svt_lp L=6e-08 W=1.5e-07
MXN1 net39 RN VSS VSS nm1p2_svt_lp L=6e-08 W=1.9e-07
MXN0 nd D net39 VSS nm1p2_svt_lp L=6e-08 W=1.9e-07
MI70_MXNOE nm nclk_ nd VSS nm1p2_svt_lp L=6e-08 W=1.5e-07
MXN2 nm GN net42 VSS nm1p2_svt_lp L=6e-08 W=2e-07
MXN3 net42 m net46 VSS nm1p2_svt_lp L=6e-08 W=2e-07
MXN4 net46 RN VSS VSS nm1p2_svt_lp L=6e-08 W=2e-07
MI69_MXNA1 m nm VSS VSS nm1p2_svt_lp L=6e-08 W=1.2e-07
MI75_MXNA1 Q nm VSS VSS nm1p2_svt_lp L=6e-08 W=2.1e-07
MI72_MXPA1 nclk_ GN VDD VDD pm1p2_svt_lp L=6e-08 W=2e-07
MXP0 nd D VDD VDD pm1p2_svt_lp L=6e-08 W=1.75e-07
MI70_MXPOEN nm GN nd VDD pm1p2_svt_lp L=6e-08 W=1.5e-07
MXP3 nm nclk_ net67 VDD pm1p2_svt_lp L=6e-08 W=1.5e-07
MXP2 net67 m VDD VDD pm1p2_svt_lp L=6e-08 W=1.5e-07
MXP1 nm RN VDD VDD pm1p2_svt_lp L=6e-08 W=1.5e-07
MI69_MXPA1 m nm VDD VDD pm1p2_svt_lp L=6e-08 W=1.2e-07
MI75_MXPA1 Q nm VDD VDD pm1p2_svt_lp L=6e-08 W=2.95e-07
.ENDS

.SUBCKT LATLRQX1H9R Q VDD VSS D GN RN
MI72_MXNA1 nclk_ GN VSS VSS nm1p2_svt_lp L=6e-08 W=1.5e-07
MXN1 net27 RN VSS VSS nm1p2_svt_lp L=6e-08 W=2.7e-07
MXN0 nd D net27 VSS nm1p2_svt_lp L=6e-08 W=2.7e-07
MI70_MXNOE nm nclk_ nd VSS nm1p2_svt_lp L=6e-08 W=2.6e-07
MXN2 nm GN net23 VSS nm1p2_svt_lp L=6e-08 W=2e-07
MXN3 net23 m net20 VSS nm1p2_svt_lp L=6e-08 W=2e-07
MXN4 net20 RN VSS VSS nm1p2_svt_lp L=6e-08 W=2e-07
MI69_MXNA1 m nm VSS VSS nm1p2_svt_lp L=6e-08 W=1.2e-07
MI75_MXNA1 Q nm VSS VSS nm1p2_svt_lp L=6e-08 W=4.2e-07
MI72_MXPA1 nclk_ GN VDD VDD pm1p2_svt_lp L=6e-08 W=2e-07
MXP0 nd D VDD VDD pm1p2_svt_lp L=6e-08 W=2.6e-07
MI70_MXPOEN nm GN nd VDD pm1p2_svt_lp L=6e-08 W=2.6e-07
MXP3 nm nclk_ net33 VDD pm1p2_svt_lp L=6e-08 W=1.5e-07
MXP2 net33 m VDD VDD pm1p2_svt_lp L=6e-08 W=1.5e-07
MXP1 nm RN VDD VDD pm1p2_svt_lp L=6e-08 W=1.5e-07
MI69_MXPA1 m nm VDD VDD pm1p2_svt_lp L=6e-08 W=1.2e-07
MI75_MXPA1 Q nm VDD VDD pm1p2_svt_lp L=6e-08 W=5.85e-07
.ENDS

.SUBCKT LATLRQX2H9R Q VDD VSS D GN RN
MI72_MXNA1 nclk_ GN VSS VSS nm1p2_svt_lp L=6e-08 W=1.5e-07
MXN1 net27 RN VSS VSS nm1p2_svt_lp L=6e-08 W=3.9e-07
MXN0 nd D net27 VSS nm1p2_svt_lp L=6e-08 W=3.9e-07
MI70_MXNOE nm nclk_ nd VSS nm1p2_svt_lp L=6e-08 W=3.2e-07
MXN2 nm GN net23 VSS nm1p2_svt_lp L=6e-08 W=2e-07
MXN3 net23 m net20 VSS nm1p2_svt_lp L=6e-08 W=2e-07
MXN4 net20 RN VSS VSS nm1p2_svt_lp L=6e-08 W=2e-07
MI69_MXNA1 m nm VSS VSS nm1p2_svt_lp L=6e-08 W=1.2e-07
MI75_MXNA1 Q nm VSS VSS nm1p2_svt_lp L=6e-08 W=4.2e-07
MI75_MXNA1_2 Q nm VSS VSS nm1p2_svt_lp L=6e-08 W=4.2e-07
MI72_MXPA1 nclk_ GN VDD VDD pm1p2_svt_lp L=6e-08 W=2e-07
MXP0 nd D VDD VDD pm1p2_svt_lp L=6e-08 W=3.9e-07
MI70_MXPOEN nm GN nd VDD pm1p2_svt_lp L=6e-08 W=3.2e-07
MXP3 nm nclk_ net33 VDD pm1p2_svt_lp L=6e-08 W=1.5e-07
MXP2 net33 m VDD VDD pm1p2_svt_lp L=6e-08 W=1.5e-07
MXP1 nm RN VDD VDD pm1p2_svt_lp L=6e-08 W=1.5e-07
MI69_MXPA1 m nm VDD VDD pm1p2_svt_lp L=6e-08 W=1.2e-07
MI75_MXPA1 Q nm VDD VDD pm1p2_svt_lp L=6e-08 W=5.85e-07
MI75_MXPA1_2 Q nm VDD VDD pm1p2_svt_lp L=6e-08 W=5.85e-07
.ENDS

.SUBCKT LATLRQX3H9R Q VDD VSS D GN RN
MI72_MXNA1 nclk_ GN VSS VSS nm1p2_svt_lp L=6e-08 W=1.5e-07
MXN1 net39 RN VSS VSS nm1p2_svt_lp L=6e-08 W=4.1e-07
MXN0 nd D net39 VSS nm1p2_svt_lp L=6e-08 W=4.1e-07
MI70_MXNOE nm nclk_ nd VSS nm1p2_svt_lp L=6e-08 W=3.9e-07
MXN2 nm GN net42 VSS nm1p2_svt_lp L=6e-08 W=2e-07
MXN3 net42 m net46 VSS nm1p2_svt_lp L=6e-08 W=2e-07
MXN4 net46 RN VSS VSS nm1p2_svt_lp L=6e-08 W=2e-07
MI69_MXNA1 m nm VSS VSS nm1p2_svt_lp L=6e-08 W=1.2e-07
MI75_MXNA1 Q nm VSS VSS nm1p2_svt_lp L=6e-08 W=4.2e-07
MI75_MXNA1_2 Q nm VSS VSS nm1p2_svt_lp L=6e-08 W=4.2e-07
MI75_MXNA1_3 Q nm VSS VSS nm1p2_svt_lp L=6e-08 W=4.2e-07
MI72_MXPA1 nclk_ GN VDD VDD pm1p2_svt_lp L=6e-08 W=2e-07
MXP0 nd D VDD VDD pm1p2_svt_lp L=6e-08 W=4.3e-07
MI70_MXPOEN nm GN nd VDD pm1p2_svt_lp L=6e-08 W=3.9e-07
MXP3 nm nclk_ net67 VDD pm1p2_svt_lp L=6e-08 W=1.5e-07
MXP2 net67 m VDD VDD pm1p2_svt_lp L=6e-08 W=1.5e-07
MXP1 nm RN VDD VDD pm1p2_svt_lp L=6e-08 W=1.5e-07
MI69_MXPA1 m nm VDD VDD pm1p2_svt_lp L=6e-08 W=1.2e-07
MI75_MXPA1 Q nm VDD VDD pm1p2_svt_lp L=6e-08 W=5.85e-07
MI75_MXPA1_2 Q nm VDD VDD pm1p2_svt_lp L=6e-08 W=5.85e-07
MI75_MXPA1_3 Q nm VDD VDD pm1p2_svt_lp L=6e-08 W=5.85e-07
.ENDS

.SUBCKT LATLRPQNX0P5H9R QN VDD VSS D GN R
MI72_MXNA1 nclk_ GN VSS VSS nm1p2_svt_lp L=6e-08 W=1.5e-07
MI74_MXNA1 nd D VSS VSS nm1p2_svt_lp L=6e-08 W=1.5e-07
MI20_MXNOE nm nclk_ nd VSS nm1p2_svt_lp L=6e-08 W=1.5e-07
MI29_MXNOE nm GN XI29_n1 VSS nm1p2_svt_lp L=6e-08 W=1.5e-07
MI29_MXNA1 XI29_n1 m VSS VSS nm1p2_svt_lp L=6e-08 W=1.5e-07
MI78_MXNA1 m nm VSS VSS nm1p2_svt_lp L=6e-08 W=1.5e-07
MI78_MXNA2 m R VSS VSS nm1p2_svt_lp L=6e-08 W=1.5e-07
MI8_MXNA1 QN m VSS VSS nm1p2_svt_lp L=6e-08 W=2.1e-07
MI72_MXPA1 nclk_ GN VDD VDD pm1p2_svt_lp L=6e-08 W=2e-07
MI74_MXPA1 nd D VDD VDD pm1p2_svt_lp L=6e-08 W=2e-07
MI20_MXPOEN nm GN nd VDD pm1p2_svt_lp L=6e-08 W=1.5e-07
MI29_MXPOEN nm nclk_ XI29_p1 VDD pm1p2_svt_lp L=6e-08 W=1.5e-07
MI29_MXPA1 XI29_p1 m VDD VDD pm1p2_svt_lp L=6e-08 W=1.5e-07
MI78_MXPA1 m nm XI78_p1 VDD pm1p2_svt_lp L=6e-08 W=3.2e-07
MI78_MXPA2 XI78_p1 R VDD VDD pm1p2_svt_lp L=6e-08 W=3.2e-07
MI8_MXPA1 QN m VDD VDD pm1p2_svt_lp L=6e-08 W=2.95e-07
.ENDS

.SUBCKT LATLRPQNX1H9R QN VDD VSS D GN R
MI72_MXNA1 nclk_ GN VSS VSS nm1p2_svt_lp L=6e-08 W=1.5e-07
MI74_MXNA1 nd D VSS VSS nm1p2_svt_lp L=6e-08 W=2.2e-07
MI20_MXNOE nm nclk_ nd VSS nm1p2_svt_lp L=6e-08 W=2.6e-07
MI29_MXNOE nm GN XI29_n1 VSS nm1p2_svt_lp L=6e-08 W=1.5e-07
MI29_MXNA1 XI29_n1 m VSS VSS nm1p2_svt_lp L=6e-08 W=1.5e-07
MI78_MXNA1 m nm VSS VSS nm1p2_svt_lp L=6e-08 W=2e-07
MI78_MXNA2 m R VSS VSS nm1p2_svt_lp L=6e-08 W=2e-07
MI8_MXNA1 QN m VSS VSS nm1p2_svt_lp L=6e-08 W=4.2e-07
MI72_MXPA1 nclk_ GN VDD VDD pm1p2_svt_lp L=6e-08 W=2e-07
MI74_MXPA1 nd D VDD VDD pm1p2_svt_lp L=6e-08 W=3.1e-07
MI20_MXPOEN nm GN nd VDD pm1p2_svt_lp L=6e-08 W=2.6e-07
MI29_MXPOEN nm nclk_ XI29_p1 VDD pm1p2_svt_lp L=6e-08 W=1.5e-07
MI29_MXPA1 XI29_p1 m VDD VDD pm1p2_svt_lp L=6e-08 W=1.5e-07
MI78_MXPA1 m nm XI78_p1 VDD pm1p2_svt_lp L=6e-08 W=4.1e-07
MI78_MXPA2 XI78_p1 R VDD VDD pm1p2_svt_lp L=6e-08 W=4.1e-07
MI8_MXPA1 QN m VDD VDD pm1p2_svt_lp L=6e-08 W=5.85e-07
.ENDS

.SUBCKT LATLRPQNX2H9R QN VDD VSS D GN R
MI72_MXNA1 nclk_ GN VSS VSS nm1p2_svt_lp L=6e-08 W=1.5e-07
MI74_MXNA1 nd D VSS VSS nm1p2_svt_lp L=6e-08 W=3.2e-07
MI20_MXNOE nm nclk_ nd VSS nm1p2_svt_lp L=6e-08 W=3.2e-07
MI29_MXNOE nm GN XI29_n1 VSS nm1p2_svt_lp L=6e-08 W=1.5e-07
MI29_MXNA1 XI29_n1 m VSS VSS nm1p2_svt_lp L=6e-08 W=1.5e-07
MI78_MXNA1 m nm VSS VSS nm1p2_svt_lp L=6e-08 W=2e-07
MI78_MXNA2 m R VSS VSS nm1p2_svt_lp L=6e-08 W=2e-07
MI8_MXNA1 QN m VSS VSS nm1p2_svt_lp L=6e-08 W=4.2e-07
MI8_MXNA1_2 QN m VSS VSS nm1p2_svt_lp L=6e-08 W=4.2e-07
MI72_MXPA1 nclk_ GN VDD VDD pm1p2_svt_lp L=6e-08 W=2e-07
MI74_MXPA1 nd D VDD VDD pm1p2_svt_lp L=6e-08 W=4.5e-07
MI20_MXPOEN nm GN nd VDD pm1p2_svt_lp L=6e-08 W=3.2e-07
MI29_MXPOEN nm nclk_ XI29_p1 VDD pm1p2_svt_lp L=6e-08 W=1.5e-07
MI29_MXPA1 XI29_p1 m VDD VDD pm1p2_svt_lp L=6e-08 W=1.5e-07
MI78_MXPA1 m nm XI78_p1 VDD pm1p2_svt_lp L=6e-08 W=5e-07
MI78_MXPA2 XI78_p1 R VDD VDD pm1p2_svt_lp L=6e-08 W=5e-07
MI8_MXPA1 QN m VDD VDD pm1p2_svt_lp L=6e-08 W=5.85e-07
MI8_MXPA1_2 QN m VDD VDD pm1p2_svt_lp L=6e-08 W=5.85e-07
.ENDS

.SUBCKT LATLRPQNX3H9R QN VDD VSS D GN R
MI72_MXNA1 nclk_ GN VSS VSS nm1p2_svt_lp L=6e-08 W=1.5e-07
MI74_MXNA1 nd D VSS VSS nm1p2_svt_lp L=6e-08 W=4.2e-07
MI20_MXNOE nm nclk_ nd VSS nm1p2_svt_lp L=6e-08 W=3.9e-07
MI29_MXNOE nm GN XI29_n1 VSS nm1p2_svt_lp L=6e-08 W=1.5e-07
MI29_MXNA1 XI29_n1 m VSS VSS nm1p2_svt_lp L=6e-08 W=1.5e-07
MI78_MXNA1 m nm VSS VSS nm1p2_svt_lp L=6e-08 W=2.2e-07
MI78_MXNA2 m R VSS VSS nm1p2_svt_lp L=6e-08 W=2.2e-07
MI8_MXNA1 QN m VSS VSS nm1p2_svt_lp L=6e-08 W=4.2e-07
MI8_MXNA1_2 QN m VSS VSS nm1p2_svt_lp L=6e-08 W=4.2e-07
MI8_MXNA1_3 QN m VSS VSS nm1p2_svt_lp L=6e-08 W=4.2e-07
MI72_MXPA1 nclk_ GN VDD VDD pm1p2_svt_lp L=6e-08 W=2e-07
MI74_MXPA1 nd D VDD VDD pm1p2_svt_lp L=6e-08 W=5.2e-07
MI20_MXPOEN nm GN nd VDD pm1p2_svt_lp L=6e-08 W=3.9e-07
MI29_MXPOEN nm nclk_ XI29_p1 VDD pm1p2_svt_lp L=6e-08 W=1.5e-07
MI29_MXPA1 XI29_p1 m VDD VDD pm1p2_svt_lp L=6e-08 W=1.5e-07
MI78_MXPA1 m nm XI78_p1 VDD pm1p2_svt_lp L=6e-08 W=5.5e-07
MI78_MXPA2 XI78_p1 R VDD VDD pm1p2_svt_lp L=6e-08 W=5.5e-07
MI8_MXPA1 QN m VDD VDD pm1p2_svt_lp L=6e-08 W=5.85e-07
MI8_MXPA1_2 QN m VDD VDD pm1p2_svt_lp L=6e-08 W=5.85e-07
MI8_MXPA1_3 QN m VDD VDD pm1p2_svt_lp L=6e-08 W=5.85e-07
.ENDS

.SUBCKT LATLRPQNX4H9R QN VDD VSS D GN R
MI72_MXNA1 nclk_ GN VSS VSS nm1p2_svt_lp L=6e-08 W=1.7e-07
MI74_MXNA1 nd D VSS VSS nm1p2_svt_lp L=6e-08 W=4.5e-07
MI20_MXNOE nm nclk_ nd VSS nm1p2_svt_lp L=6e-08 W=4.5e-07
MI29_MXNOE nm GN XI29_n1 VSS nm1p2_svt_lp L=6e-08 W=1.5e-07
MI29_MXNA1 XI29_n1 m VSS VSS nm1p2_svt_lp L=6e-08 W=1.5e-07
MI78_MXNA1 m nm VSS VSS nm1p2_svt_lp L=6e-08 W=2.2e-07
MI78_MXNA2 m R VSS VSS nm1p2_svt_lp L=6e-08 W=2.2e-07
MI8_MXNA1 QN m VSS VSS nm1p2_svt_lp L=6e-08 W=4.2e-07
MI8_MXNA1_2 QN m VSS VSS nm1p2_svt_lp L=6e-08 W=4.2e-07
MI8_MXNA1_3 QN m VSS VSS nm1p2_svt_lp L=6e-08 W=4.2e-07
MI8_MXNA1_4 QN m VSS VSS nm1p2_svt_lp L=6e-08 W=4.2e-07
MI72_MXPA1 nclk_ GN VDD VDD pm1p2_svt_lp L=6e-08 W=2.4e-07
MI74_MXPA1 nd D VDD VDD pm1p2_svt_lp L=6e-08 W=5.5e-07
MI20_MXPOEN nm GN nd VDD pm1p2_svt_lp L=6e-08 W=4.5e-07
MI29_MXPOEN nm nclk_ XI29_p1 VDD pm1p2_svt_lp L=6e-08 W=1.5e-07
MI29_MXPA1 XI29_p1 m VDD VDD pm1p2_svt_lp L=6e-08 W=1.5e-07
MI78_MXPA1 m nm XI78_p1 VDD pm1p2_svt_lp L=6e-08 W=5.85e-07
MI78_MXPA2 XI78_p1 R VDD VDD pm1p2_svt_lp L=6e-08 W=5.85e-07
MI8_MXPA1 QN m VDD VDD pm1p2_svt_lp L=6e-08 W=5.85e-07
MI8_MXPA1_2 QN m VDD VDD pm1p2_svt_lp L=6e-08 W=5.85e-07
MI8_MXPA1_3 QN m VDD VDD pm1p2_svt_lp L=6e-08 W=5.85e-07
MI8_MXPA1_4 QN m VDD VDD pm1p2_svt_lp L=6e-08 W=5.85e-07
.ENDS

.SUBCKT LATHSQNX0P5H9R QN VDD VSS D G SN
MI72_MXNA1 nclk G VSS VSS nm1p2_svt_lp L=6e-08 W=1.5e-07
MI74_MXNA1 nd D VSS VSS nm1p2_svt_lp L=6e-08 W=1.5e-07
MI20_MXNOE nm G nd VSS nm1p2_svt_lp L=6e-08 W=1.5e-07
MI29_MXNOE nm nclk XI29_n1 VSS nm1p2_svt_lp L=6e-08 W=1.5e-07
MI29_MXNA1 XI29_n1 m VSS VSS nm1p2_svt_lp L=6e-08 W=1.5e-07
MI78_MXNA1 m nm XI78_n1 VSS nm1p2_svt_lp L=6e-08 W=1.8e-07
MI78_MXNA2 XI78_n1 SN VSS VSS nm1p2_svt_lp L=6e-08 W=1.8e-07
MI8_MXNA1 QN m VSS VSS nm1p2_svt_lp L=6e-08 W=2.1e-07
MI72_MXPA1 nclk G VDD VDD pm1p2_svt_lp L=6e-08 W=2e-07
MI74_MXPA1 nd D VDD VDD pm1p2_svt_lp L=6e-08 W=2.5e-07
MI20_MXPOEN nm nclk nd VDD pm1p2_svt_lp L=6e-08 W=1.5e-07
MI29_MXPOEN nm G XI29_p1 VDD pm1p2_svt_lp L=6e-08 W=1.5e-07
MI29_MXPA1 XI29_p1 m VDD VDD pm1p2_svt_lp L=6e-08 W=1.5e-07
MI78_MXPA1 m nm VDD VDD pm1p2_svt_lp L=6e-08 W=1.5e-07
MI78_MXPA2 m SN VDD VDD pm1p2_svt_lp L=6e-08 W=1.5e-07
MI8_MXPA1 QN m VDD VDD pm1p2_svt_lp L=6e-08 W=2.95e-07
.ENDS

.SUBCKT LATHSQNX1H9R QN VDD VSS D G SN
MI72_MXNA1 nclk G VSS VSS nm1p2_svt_lp L=6e-08 W=1.5e-07
MI74_MXNA1 nd D VSS VSS nm1p2_svt_lp L=6e-08 W=2e-07
MI20_MXNOE nm G nd VSS nm1p2_svt_lp L=6e-08 W=2.6e-07
MI29_MXNOE nm nclk XI29_n1 VSS nm1p2_svt_lp L=6e-08 W=1.5e-07
MI29_MXNA1 XI29_n1 m VSS VSS nm1p2_svt_lp L=6e-08 W=1.5e-07
MI78_MXNA1 m nm XI78_n1 VSS nm1p2_svt_lp L=6e-08 W=3e-07
MI78_MXNA2 XI78_n1 SN VSS VSS nm1p2_svt_lp L=6e-08 W=3e-07
MI8_MXNA1 QN m VSS VSS nm1p2_svt_lp L=6e-08 W=4.2e-07
MI72_MXPA1 nclk G VDD VDD pm1p2_svt_lp L=6e-08 W=2e-07
MI74_MXPA1 nd D VDD VDD pm1p2_svt_lp L=6e-08 W=3.3e-07
MI20_MXPOEN nm nclk nd VDD pm1p2_svt_lp L=6e-08 W=2.55e-07
MI29_MXPOEN nm G XI29_p1 VDD pm1p2_svt_lp L=6e-08 W=1.5e-07
MI29_MXPA1 XI29_p1 m VDD VDD pm1p2_svt_lp L=6e-08 W=1.5e-07
MI78_MXPA1 m nm VDD VDD pm1p2_svt_lp L=6e-08 W=2.4e-07
MI78_MXPA2 m SN VDD VDD pm1p2_svt_lp L=6e-08 W=2.4e-07
MI8_MXPA1 QN m VDD VDD pm1p2_svt_lp L=6e-08 W=5.85e-07
.ENDS

.SUBCKT LATHSQNX2H9R QN VDD VSS D G SN
MI72_MXNA1 nclk G VSS VSS nm1p2_svt_lp L=6e-08 W=1.5e-07
MI74_MXNA1 nd D VSS VSS nm1p2_svt_lp L=6e-08 W=2.15e-07
MI20_MXNOE nm G nd VSS nm1p2_svt_lp L=6e-08 W=3.2e-07
MI29_MXNOE nm nclk XI29_n1 VSS nm1p2_svt_lp L=6e-08 W=1.5e-07
MI29_MXNA1 XI29_n1 m VSS VSS nm1p2_svt_lp L=6e-08 W=1.5e-07
MI8_MXNA1 QN m VSS VSS nm1p2_svt_lp L=6e-08 W=4.2e-07
MI8_MXNA1_2 QN m VSS VSS nm1p2_svt_lp L=6e-08 W=4.2e-07
MI78_MXNA2 XI78_n1 SN VSS VSS nm1p2_svt_lp L=6e-08 W=4e-07
MI78_MXNA1 m nm XI78_n1 VSS nm1p2_svt_lp L=6e-08 W=4e-07
MI72_MXPA1 nclk G VDD VDD pm1p2_svt_lp L=6e-08 W=2e-07
MI74_MXPA1 nd D VDD VDD pm1p2_svt_lp L=6e-08 W=3.5e-07
MI20_MXPOEN nm nclk nd VDD pm1p2_svt_lp L=6e-08 W=3.2e-07
MI29_MXPOEN nm G XI29_p1 VDD pm1p2_svt_lp L=6e-08 W=1.5e-07
MI29_MXPA1 XI29_p1 m VDD VDD pm1p2_svt_lp L=6e-08 W=1.5e-07
MI8_MXPA1 QN m VDD VDD pm1p2_svt_lp L=6e-08 W=5.85e-07
MI8_MXPA1_2 QN m VDD VDD pm1p2_svt_lp L=6e-08 W=5.85e-07
MI78_MXPA2 m SN VDD VDD pm1p2_svt_lp L=6e-08 W=3.3e-07
MI78_MXPA1 m nm VDD VDD pm1p2_svt_lp L=6e-08 W=3.3e-07
.ENDS

.SUBCKT LATHSQNX3H9R QN VDD VSS D G SN
MI72_MXNA1 nclk G VSS VSS nm1p2_svt_lp L=6e-08 W=1.5e-07
MI74_MXNA1 nd D VSS VSS nm1p2_svt_lp L=6e-08 W=3e-07
MI20_MXNOE nm G nd VSS nm1p2_svt_lp L=6e-08 W=3.9e-07
MI29_MXNOE nm nclk XI29_n1 VSS nm1p2_svt_lp L=6e-08 W=1.5e-07
MI29_MXNA1 XI29_n1 m VSS VSS nm1p2_svt_lp L=6e-08 W=1.5e-07
MI78_MXNA1 m nm XI78_n1 VSS nm1p2_svt_lp L=6e-08 W=4.4e-07
MI78_MXNA2 XI78_n1 SN VSS VSS nm1p2_svt_lp L=6e-08 W=4.4e-07
MI8_MXNA1 QN m VSS VSS nm1p2_svt_lp L=6e-08 W=4.2e-07
MI8_MXNA1_2 QN m VSS VSS nm1p2_svt_lp L=6e-08 W=4.2e-07
MI8_MXNA1_3 QN m VSS VSS nm1p2_svt_lp L=6e-08 W=4.2e-07
MI72_MXPA1 nclk G VDD VDD pm1p2_svt_lp L=6e-08 W=2e-07
MI74_MXPA1 nd D VDD VDD pm1p2_svt_lp L=6e-08 W=4.4e-07
MI20_MXPOEN nm nclk nd VDD pm1p2_svt_lp L=6e-08 W=3.9e-07
MI29_MXPOEN nm G XI29_p1 VDD pm1p2_svt_lp L=6e-08 W=1.5e-07
MI29_MXPA1 XI29_p1 m VDD VDD pm1p2_svt_lp L=6e-08 W=1.5e-07
MI78_MXPA1 m nm VDD VDD pm1p2_svt_lp L=6e-08 W=3.5e-07
MI78_MXPA2 m SN VDD VDD pm1p2_svt_lp L=6e-08 W=3.5e-07
MI8_MXPA1 QN m VDD VDD pm1p2_svt_lp L=6e-08 W=5.85e-07
MI8_MXPA1_2 QN m VDD VDD pm1p2_svt_lp L=6e-08 W=5.85e-07
MI8_MXPA1_3 QN m VDD VDD pm1p2_svt_lp L=6e-08 W=5.85e-07
.ENDS

.SUBCKT LATHSQNX4H9R QN VDD VSS D G SN
MI72_MXNA1 nclk G VSS VSS nm1p2_svt_lp L=6e-08 W=1.7e-07
MI74_MXNA1 nd D VSS VSS nm1p2_svt_lp L=6e-08 W=3.6e-07
MI20_MXNOE nm G nd VSS nm1p2_svt_lp L=6e-08 W=4.5e-07
MI29_MXNOE nm nclk XI29_n1 VSS nm1p2_svt_lp L=6e-08 W=1.5e-07
MI29_MXNA1 XI29_n1 m VSS VSS nm1p2_svt_lp L=6e-08 W=1.5e-07
MI78_MXNA1 m nm XI78_n1 VSS nm1p2_svt_lp L=6e-08 W=4.6e-07
MI78_MXNA2 XI78_n1 SN VSS VSS nm1p2_svt_lp L=6e-08 W=4.6e-07
MI8_MXNA1 QN m VSS VSS nm1p2_svt_lp L=6e-08 W=4.2e-07
MI8_MXNA1_2 QN m VSS VSS nm1p2_svt_lp L=6e-08 W=4.2e-07
MI8_MXNA1_3 QN m VSS VSS nm1p2_svt_lp L=6e-08 W=4.2e-07
MI8_MXNA1_4 QN m VSS VSS nm1p2_svt_lp L=6e-08 W=4.2e-07
MI72_MXPA1 nclk G VDD VDD pm1p2_svt_lp L=6e-08 W=2.4e-07
MI74_MXPA1 nd D VDD VDD pm1p2_svt_lp L=6e-08 W=5.2e-07
MI20_MXPOEN nm nclk nd VDD pm1p2_svt_lp L=6e-08 W=4.5e-07
MI29_MXPOEN nm G XI29_p1 VDD pm1p2_svt_lp L=6e-08 W=1.5e-07
MI29_MXPA1 XI29_p1 m VDD VDD pm1p2_svt_lp L=6e-08 W=1.5e-07
MI78_MXPA1 m nm VDD VDD pm1p2_svt_lp L=6e-08 W=3.7e-07
MI78_MXPA2 m SN VDD VDD pm1p2_svt_lp L=6e-08 W=3.7e-07
MI8_MXPA1 QN m VDD VDD pm1p2_svt_lp L=6e-08 W=5.85e-07
MI8_MXPA1_2 QN m VDD VDD pm1p2_svt_lp L=6e-08 W=5.85e-07
MI8_MXPA1_3 QN m VDD VDD pm1p2_svt_lp L=6e-08 W=5.85e-07
MI8_MXPA1_4 QN m VDD VDD pm1p2_svt_lp L=6e-08 W=5.85e-07
.ENDS

.SUBCKT LATHSPQX0P5H9R Q VDD VSS D G S
MI72_MXNA1 nclk G VSS VSS nm1p2_svt_lp L=6e-08 W=1.5e-07
MXN0 nd D VSS VSS nm1p2_svt_lp L=6e-08 W=1.5e-07
MI70_MXNOE nm G nd VSS nm1p2_svt_lp L=6e-08 W=1.5e-07
MXN2 nm nclk net23 VSS nm1p2_svt_lp L=6e-08 W=1.5e-07
MXN3 net23 m VSS VSS nm1p2_svt_lp L=6e-08 W=1.5e-07
MXN5 nm S VSS VSS nm1p2_svt_lp L=6e-08 W=1.5e-07
MI69_MXNA1 m nm VSS VSS nm1p2_svt_lp L=6e-08 W=1.2e-07
MI75_MXNA1 Q nm VSS VSS nm1p2_svt_lp L=6e-08 W=2.1e-07
MI72_MXPA1 nclk G VDD VDD pm1p2_svt_lp L=6e-08 W=2e-07
MXP4 net048 S VDD VDD pm1p2_svt_lp L=6e-08 W=4e-07
MXP0 nd D net048 VDD pm1p2_svt_lp L=6e-08 W=4e-07
MI70_MXPOEN nm nclk nd VDD pm1p2_svt_lp L=6e-08 W=1.5e-07
MXP3 nm G net33 VDD pm1p2_svt_lp L=6e-08 W=2e-07
MXP2 net33 m net043 VDD pm1p2_svt_lp L=6e-08 W=2e-07
MXP5 net043 S VDD VDD pm1p2_svt_lp L=6e-08 W=2e-07
MI69_MXPA1 m nm VDD VDD pm1p2_svt_lp L=6e-08 W=1.2e-07
MI75_MXPA1 Q nm VDD VDD pm1p2_svt_lp L=6e-08 W=2.95e-07
.ENDS

.SUBCKT LATHSPQX1H9R Q VDD VSS D G S
MI72_MXNA1 nclk G VSS VSS nm1p2_svt_lp L=6e-08 W=1.5e-07
MXN0 nd D VSS VSS nm1p2_svt_lp L=6e-08 W=2.05e-07
MI70_MXNOE nm G nd VSS nm1p2_svt_lp L=6e-08 W=2.6e-07
MXN2 nm nclk net23 VSS nm1p2_svt_lp L=6e-08 W=1.5e-07
MXN3 net23 m VSS VSS nm1p2_svt_lp L=6e-08 W=1.5e-07
MXN5 nm S VSS VSS nm1p2_svt_lp L=6e-08 W=1.5e-07
MI69_MXNA1 m nm VSS VSS nm1p2_svt_lp L=6e-08 W=1.2e-07
MI75_MXNA1 Q nm VSS VSS nm1p2_svt_lp L=6e-08 W=4.2e-07
MI72_MXPA1 nclk G VDD VDD pm1p2_svt_lp L=6e-08 W=2e-07
MXP4 net048 S VDD VDD pm1p2_svt_lp L=6e-08 W=5.5e-07
MXP0 nd D net048 VDD pm1p2_svt_lp L=6e-08 W=5.5e-07
MI70_MXPOEN nm nclk nd VDD pm1p2_svt_lp L=6e-08 W=2.6e-07
MXP3 nm G net33 VDD pm1p2_svt_lp L=6e-08 W=2e-07
MXP2 net33 m net043 VDD pm1p2_svt_lp L=6e-08 W=2e-07
MXP5 net043 S VDD VDD pm1p2_svt_lp L=6e-08 W=2e-07
MI69_MXPA1 m nm VDD VDD pm1p2_svt_lp L=6e-08 W=1.2e-07
MI75_MXPA1 Q nm VDD VDD pm1p2_svt_lp L=6e-08 W=5.85e-07
.ENDS

.SUBCKT LATHSPQX2H9R Q VDD VSS D G S
MI72_MXNA1 nclk G VSS VSS nm1p2_svt_lp L=6e-08 W=1.5e-07
MXN0 nd D VSS VSS nm1p2_svt_lp L=6e-08 W=2e-07
MI70_MXNOE nm G nd VSS nm1p2_svt_lp L=6e-08 W=3e-07
MXN2 nm nclk net38 VSS nm1p2_svt_lp L=6e-08 W=1.5e-07
MXN3 net38 m VSS VSS nm1p2_svt_lp L=6e-08 W=1.5e-07
MXN5 nm S VSS VSS nm1p2_svt_lp L=6e-08 W=1.5e-07
MI69_MXNA1 m nm VSS VSS nm1p2_svt_lp L=6e-08 W=1.2e-07
MI75_MXNA1 Q nm VSS VSS nm1p2_svt_lp L=6e-08 W=4.2e-07
MI75_MXNA1_2 Q nm VSS VSS nm1p2_svt_lp L=6e-08 W=4.2e-07
MI72_MXPA1 nclk G VDD VDD pm1p2_svt_lp L=6e-08 W=2e-07
MXP4 net50 S VDD VDD pm1p2_svt_lp L=6e-08 W=5.85e-07
MXP0 nd D net50 VDD pm1p2_svt_lp L=6e-08 W=5.85e-07
MI70_MXPOEN nm nclk nd VDD pm1p2_svt_lp L=6e-08 W=3.4e-07
MXP3 nm G net67 VDD pm1p2_svt_lp L=6e-08 W=2e-07
MXP2 net67 m net55 VDD pm1p2_svt_lp L=6e-08 W=2e-07
MXP5 net55 S VDD VDD pm1p2_svt_lp L=6e-08 W=2e-07
MI69_MXPA1 m nm VDD VDD pm1p2_svt_lp L=6e-08 W=1.2e-07
MI75_MXPA1 Q nm VDD VDD pm1p2_svt_lp L=6e-08 W=5.85e-07
MI75_MXPA1_2 Q nm VDD VDD pm1p2_svt_lp L=6e-08 W=5.85e-07
.ENDS

.SUBCKT LATHSPQX3H9R Q VDD VSS D G S
MI72_MXNA1 nclk G VSS VSS nm1p2_svt_lp L=6e-08 W=1.7e-07
MXN0 nd D VSS VSS nm1p2_svt_lp L=6e-08 W=4.5e-07
MI70_MXNOE nm G nd VSS nm1p2_svt_lp L=6e-08 W=3.9e-07
MXN2 nm nclk net23 VSS nm1p2_svt_lp L=6e-08 W=1.5e-07
MXN3 net23 m VSS VSS nm1p2_svt_lp L=6e-08 W=1.5e-07
MXN5 nm S VSS VSS nm1p2_svt_lp L=6e-08 W=1.5e-07
MI69_MXNA1 m nm VSS VSS nm1p2_svt_lp L=6e-08 W=1.2e-07
MI75_MXNA1 Q nm VSS VSS nm1p2_svt_lp L=6e-08 W=4.2e-07
MI75_MXNA1_2 Q nm VSS VSS nm1p2_svt_lp L=6e-08 W=4.2e-07
MI75_MXNA1_3 Q nm VSS VSS nm1p2_svt_lp L=6e-08 W=4.2e-07
MI72_MXPA1 nclk G VDD VDD pm1p2_svt_lp L=6e-08 W=2.4e-07
MXP4_2 net048__2 S VDD VDD pm1p2_svt_lp L=6e-08 W=5.85e-07
MXP0_2 nd D net048__2 VDD pm1p2_svt_lp L=6e-08 W=5.85e-07
MXP0 nd D net048 VDD pm1p2_svt_lp L=6e-08 W=5.85e-07
MXP4 net048 S VDD VDD pm1p2_svt_lp L=6e-08 W=5.85e-07
MI70_MXPOEN nm nclk nd VDD pm1p2_svt_lp L=6e-08 W=3.9e-07
MXP3 nm G net33 VDD pm1p2_svt_lp L=6e-08 W=2e-07
MXP2 net33 m net043 VDD pm1p2_svt_lp L=6e-08 W=2e-07
MXP5 net043 S VDD VDD pm1p2_svt_lp L=6e-08 W=2e-07
MI69_MXPA1 m nm VDD VDD pm1p2_svt_lp L=6e-08 W=1.2e-07
MI75_MXPA1 Q nm VDD VDD pm1p2_svt_lp L=6e-08 W=5.85e-07
MI75_MXPA1_2 Q nm VDD VDD pm1p2_svt_lp L=6e-08 W=5.85e-07
MI75_MXPA1_3 Q nm VDD VDD pm1p2_svt_lp L=6e-08 W=5.85e-07
.ENDS

.SUBCKT LATLSQNX0P5H9R QN VDD VSS D GN SN
MI72_MXNA1 nclk_ GN VSS VSS nm1p2_svt_lp L=6e-08 W=1.5e-07
MI74_MXNA1 nd D VSS VSS nm1p2_svt_lp L=6e-08 W=1.5e-07
MI20_MXNOE nm nclk_ nd VSS nm1p2_svt_lp L=6e-08 W=1.5e-07
MI29_MXNOE nm GN XI29_n1 VSS nm1p2_svt_lp L=6e-08 W=1.5e-07
MI29_MXNA1 XI29_n1 m VSS VSS nm1p2_svt_lp L=6e-08 W=1.5e-07
MI78_MXNA1 m nm XI78_n1 VSS nm1p2_svt_lp L=6e-08 W=2.1e-07
MI78_MXNA2 XI78_n1 SN VSS VSS nm1p2_svt_lp L=6e-08 W=2.1e-07
MI8_MXNA1 QN m VSS VSS nm1p2_svt_lp L=6e-08 W=2.1e-07
MI72_MXPA1 nclk_ GN VDD VDD pm1p2_svt_lp L=6e-08 W=2e-07
MI74_MXPA1 nd D VDD VDD pm1p2_svt_lp L=6e-08 W=2.1e-07
MI20_MXPOEN nm GN nd VDD pm1p2_svt_lp L=6e-08 W=1.5e-07
MI29_MXPOEN nm nclk_ XI29_p1 VDD pm1p2_svt_lp L=6e-08 W=1.5e-07
MI29_MXPA1 XI29_p1 m VDD VDD pm1p2_svt_lp L=6e-08 W=1.5e-07
MI78_MXPA1 m nm VDD VDD pm1p2_svt_lp L=6e-08 W=1.5e-07
MI78_MXPA2 m SN VDD VDD pm1p2_svt_lp L=6e-08 W=1.5e-07
MI8_MXPA1 QN m VDD VDD pm1p2_svt_lp L=6e-08 W=2.95e-07
.ENDS

.SUBCKT LATLSQNX1H9R QN VDD VSS D GN SN
MI72_MXNA1 nclk_ GN VSS VSS nm1p2_svt_lp L=6e-08 W=1.5e-07
MI74_MXNA1 nd D VSS VSS nm1p2_svt_lp L=6e-08 W=2e-07
MI20_MXNOE nm nclk_ nd VSS nm1p2_svt_lp L=6e-08 W=2.6e-07
MI29_MXNOE nm GN XI29_n1 VSS nm1p2_svt_lp L=6e-08 W=1.5e-07
MI29_MXNA1 XI29_n1 m VSS VSS nm1p2_svt_lp L=6e-08 W=1.5e-07
MI78_MXNA1 m nm XI78_n1 VSS nm1p2_svt_lp L=6e-08 W=3.1e-07
MI78_MXNA2 XI78_n1 SN VSS VSS nm1p2_svt_lp L=6e-08 W=3.1e-07
MI8_MXNA1 QN m VSS VSS nm1p2_svt_lp L=6e-08 W=4.2e-07
MI72_MXPA1 nclk_ GN VDD VDD pm1p2_svt_lp L=6e-08 W=2e-07
MI74_MXPA1 nd D VDD VDD pm1p2_svt_lp L=6e-08 W=3.3e-07
MI20_MXPOEN nm GN nd VDD pm1p2_svt_lp L=6e-08 W=2.6e-07
MI29_MXPOEN nm nclk_ XI29_p1 VDD pm1p2_svt_lp L=6e-08 W=1.5e-07
MI29_MXPA1 XI29_p1 m VDD VDD pm1p2_svt_lp L=6e-08 W=1.5e-07
MI78_MXPA1 m nm VDD VDD pm1p2_svt_lp L=6e-08 W=2.5e-07
MI78_MXPA2 m SN VDD VDD pm1p2_svt_lp L=6e-08 W=2.5e-07
MI8_MXPA1 QN m VDD VDD pm1p2_svt_lp L=6e-08 W=5.85e-07
.ENDS

.SUBCKT LATLSQNX2H9R QN VDD VSS D GN SN
MI72_MXNA1 nclk_ GN VSS VSS nm1p2_svt_lp L=6e-08 W=1.5e-07
MI74_MXNA1 nd D VSS VSS nm1p2_svt_lp L=6e-08 W=2.15e-07
MI20_MXNOE nm nclk_ nd VSS nm1p2_svt_lp L=6e-08 W=3.2e-07
MI29_MXNOE nm GN XI29_n1 VSS nm1p2_svt_lp L=6e-08 W=1.5e-07
MI29_MXNA1 XI29_n1 m VSS VSS nm1p2_svt_lp L=6e-08 W=1.5e-07
MI8_MXNA1 QN m VSS VSS nm1p2_svt_lp L=6e-08 W=4.2e-07
MI8_MXNA1_2 QN m VSS VSS nm1p2_svt_lp L=6e-08 W=4.2e-07
MI78_MXNA2 XI78_n1 SN VSS VSS nm1p2_svt_lp L=6e-08 W=4.1e-07
MI78_MXNA1 m nm XI78_n1 VSS nm1p2_svt_lp L=6e-08 W=4.1e-07
MI72_MXPA1 nclk_ GN VDD VDD pm1p2_svt_lp L=6e-08 W=2e-07
MI74_MXPA1 nd D VDD VDD pm1p2_svt_lp L=6e-08 W=3.5e-07
MI20_MXPOEN nm GN nd VDD pm1p2_svt_lp L=6e-08 W=3.2e-07
MI29_MXPOEN nm nclk_ XI29_p1 VDD pm1p2_svt_lp L=6e-08 W=1.5e-07
MI29_MXPA1 XI29_p1 m VDD VDD pm1p2_svt_lp L=6e-08 W=1.5e-07
MI8_MXPA1 QN m VDD VDD pm1p2_svt_lp L=6e-08 W=5.85e-07
MI8_MXPA1_2 QN m VDD VDD pm1p2_svt_lp L=6e-08 W=5.85e-07
MI78_MXPA2 m SN VDD VDD pm1p2_svt_lp L=6e-08 W=3.3e-07
MI78_MXPA1 m nm VDD VDD pm1p2_svt_lp L=6e-08 W=3.3e-07
.ENDS

.SUBCKT LATLSQNX3H9R QN VDD VSS D GN SN
MI72_MXNA1 nclk_ GN VSS VSS nm1p2_svt_lp L=6e-08 W=1.5e-07
MI74_MXNA1 nd D VSS VSS nm1p2_svt_lp L=6e-08 W=3e-07
MI20_MXNOE nm nclk_ nd VSS nm1p2_svt_lp L=6e-08 W=3.9e-07
MI29_MXNOE nm GN XI29_n1 VSS nm1p2_svt_lp L=6e-08 W=1.5e-07
MI29_MXNA1 XI29_n1 m VSS VSS nm1p2_svt_lp L=6e-08 W=1.5e-07
MI78_MXNA1 m nm XI78_n1 VSS nm1p2_svt_lp L=6e-08 W=4.5e-07
MI78_MXNA2 XI78_n1 SN VSS VSS nm1p2_svt_lp L=6e-08 W=4.5e-07
MI8_MXNA1 QN m VSS VSS nm1p2_svt_lp L=6e-08 W=4.2e-07
MI8_MXNA1_2 QN m VSS VSS nm1p2_svt_lp L=6e-08 W=4.2e-07
MI8_MXNA1_3 QN m VSS VSS nm1p2_svt_lp L=6e-08 W=4.2e-07
MI72_MXPA1 nclk_ GN VDD VDD pm1p2_svt_lp L=6e-08 W=2e-07
MI74_MXPA1 nd D VDD VDD pm1p2_svt_lp L=6e-08 W=4.4e-07
MI20_MXPOEN nm GN nd VDD pm1p2_svt_lp L=6e-08 W=3.9e-07
MI29_MXPOEN nm nclk_ XI29_p1 VDD pm1p2_svt_lp L=6e-08 W=1.5e-07
MI29_MXPA1 XI29_p1 m VDD VDD pm1p2_svt_lp L=6e-08 W=1.5e-07
MI78_MXPA1 m nm VDD VDD pm1p2_svt_lp L=6e-08 W=3.5e-07
MI78_MXPA2 m SN VDD VDD pm1p2_svt_lp L=6e-08 W=3.5e-07
MI8_MXPA1 QN m VDD VDD pm1p2_svt_lp L=6e-08 W=5.85e-07
MI8_MXPA1_2 QN m VDD VDD pm1p2_svt_lp L=6e-08 W=5.85e-07
MI8_MXPA1_3 QN m VDD VDD pm1p2_svt_lp L=6e-08 W=5.85e-07
.ENDS

.SUBCKT LATLSQNX4H9R QN VDD VSS D GN SN
MI72_MXNA1 nclk_ GN VSS VSS nm1p2_svt_lp L=6e-08 W=1.7e-07
MI74_MXNA1 nd D VSS VSS nm1p2_svt_lp L=6e-08 W=3.6e-07
MI20_MXNOE nm nclk_ nd VSS nm1p2_svt_lp L=6e-08 W=4.5e-07
MI29_MXNOE nm GN XI29_n1 VSS nm1p2_svt_lp L=6e-08 W=1.5e-07
MI29_MXNA1 XI29_n1 m VSS VSS nm1p2_svt_lp L=6e-08 W=1.5e-07
MI78_MXNA1 m nm XI78_n1 VSS nm1p2_svt_lp L=6e-08 W=4.6e-07
MI78_MXNA2 XI78_n1 SN VSS VSS nm1p2_svt_lp L=6e-08 W=4.6e-07
MI8_MXNA1 QN m VSS VSS nm1p2_svt_lp L=6e-08 W=4.2e-07
MI8_MXNA1_2 QN m VSS VSS nm1p2_svt_lp L=6e-08 W=4.2e-07
MI8_MXNA1_3 QN m VSS VSS nm1p2_svt_lp L=6e-08 W=4.2e-07
MI8_MXNA1_4 QN m VSS VSS nm1p2_svt_lp L=6e-08 W=4.2e-07
MI72_MXPA1 nclk_ GN VDD VDD pm1p2_svt_lp L=6e-08 W=2.4e-07
MI74_MXPA1 nd D VDD VDD pm1p2_svt_lp L=6e-08 W=5e-07
MI20_MXPOEN nm GN nd VDD pm1p2_svt_lp L=6e-08 W=4.5e-07
MI29_MXPOEN nm nclk_ XI29_p1 VDD pm1p2_svt_lp L=6e-08 W=1.5e-07
MI29_MXPA1 XI29_p1 m VDD VDD pm1p2_svt_lp L=6e-08 W=1.5e-07
MI78_MXPA1 m nm VDD VDD pm1p2_svt_lp L=6e-08 W=3.6e-07
MI78_MXPA2 m SN VDD VDD pm1p2_svt_lp L=6e-08 W=3.6e-07
MI8_MXPA1 QN m VDD VDD pm1p2_svt_lp L=6e-08 W=5.85e-07
MI8_MXPA1_2 QN m VDD VDD pm1p2_svt_lp L=6e-08 W=5.85e-07
MI8_MXPA1_3 QN m VDD VDD pm1p2_svt_lp L=6e-08 W=5.85e-07
MI8_MXPA1_4 QN m VDD VDD pm1p2_svt_lp L=6e-08 W=5.85e-07
.ENDS

.SUBCKT LATLSPQX0P5H9R Q VDD VSS D GN S
MI72_MXNA1 nclk_ GN VSS VSS nm1p2_svt_lp L=6e-08 W=1.5e-07
MXN0 nd D VSS VSS nm1p2_svt_lp L=6e-08 W=1.5e-07
MI70_MXNOE nm nclk_ nd VSS nm1p2_svt_lp L=6e-08 W=1.5e-07
MXN2 nm GN net23 VSS nm1p2_svt_lp L=6e-08 W=1.5e-07
MXN3 net23 m VSS VSS nm1p2_svt_lp L=6e-08 W=1.5e-07
MXN5 nm S VSS VSS nm1p2_svt_lp L=6e-08 W=1.5e-07
MI69_MXNA1 m nm VSS VSS nm1p2_svt_lp L=6e-08 W=1.2e-07
MI75_MXNA1 Q nm VSS VSS nm1p2_svt_lp L=6e-08 W=2.1e-07
MI72_MXPA1 nclk_ GN VDD VDD pm1p2_svt_lp L=6e-08 W=2e-07
MXP4 net048 S VDD VDD pm1p2_svt_lp L=6e-08 W=4.1e-07
MXP0 nd D net048 VDD pm1p2_svt_lp L=6e-08 W=4.1e-07
MI70_MXPOEN nm GN nd VDD pm1p2_svt_lp L=6e-08 W=1.5e-07
MXP3 nm nclk_ net33 VDD pm1p2_svt_lp L=6e-08 W=2e-07
MXP2 net33 m net043 VDD pm1p2_svt_lp L=6e-08 W=2e-07
MXP5 net043 S VDD VDD pm1p2_svt_lp L=6e-08 W=2e-07
MI69_MXPA1 m nm VDD VDD pm1p2_svt_lp L=6e-08 W=1.2e-07
MI75_MXPA1 Q nm VDD VDD pm1p2_svt_lp L=6e-08 W=2.95e-07
.ENDS

.SUBCKT LATLSPQX1H9R Q VDD VSS D GN S
MI72_MXNA1 nclk_ GN VSS VSS nm1p2_svt_lp L=6e-08 W=1.5e-07
MXN0 nd D VSS VSS nm1p2_svt_lp L=6e-08 W=2e-07
MI70_MXNOE nm nclk_ nd VSS nm1p2_svt_lp L=6e-08 W=2.6e-07
MXN2 nm GN net23 VSS nm1p2_svt_lp L=6e-08 W=1.5e-07
MXN3 net23 m VSS VSS nm1p2_svt_lp L=6e-08 W=1.5e-07
MXN5 nm S VSS VSS nm1p2_svt_lp L=6e-08 W=1.5e-07
MI69_MXNA1 m nm VSS VSS nm1p2_svt_lp L=6e-08 W=1.2e-07
MI75_MXNA1 Q nm VSS VSS nm1p2_svt_lp L=6e-08 W=4.2e-07
MI72_MXPA1 nclk_ GN VDD VDD pm1p2_svt_lp L=6e-08 W=2e-07
MXP4 net048 S VDD VDD pm1p2_svt_lp L=6e-08 W=5.7e-07
MXP0 nd D net048 VDD pm1p2_svt_lp L=6e-08 W=5.7e-07
MI70_MXPOEN nm GN nd VDD pm1p2_svt_lp L=6e-08 W=2.6e-07
MXP3 nm nclk_ net33 VDD pm1p2_svt_lp L=6e-08 W=2e-07
MXP2 net33 m net043 VDD pm1p2_svt_lp L=6e-08 W=2e-07
MXP5 net043 S VDD VDD pm1p2_svt_lp L=6e-08 W=2e-07
MI69_MXPA1 m nm VDD VDD pm1p2_svt_lp L=6e-08 W=1.2e-07
MI75_MXPA1 Q nm VDD VDD pm1p2_svt_lp L=6e-08 W=5.85e-07
.ENDS

.SUBCKT LATLSPQX2H9R Q VDD VSS D GN S
MI72_MXNA1 nclk_ GN VSS VSS nm1p2_svt_lp L=6e-08 W=1.5e-07
MXN0 nd D VSS VSS nm1p2_svt_lp L=6e-08 W=2e-07
MI70_MXNOE nm nclk_ nd VSS nm1p2_svt_lp L=6e-08 W=3e-07
MXN2 nm GN net23 VSS nm1p2_svt_lp L=6e-08 W=1.5e-07
MXN3 net23 m VSS VSS nm1p2_svt_lp L=6e-08 W=1.5e-07
MXN5 nm S VSS VSS nm1p2_svt_lp L=6e-08 W=1.5e-07
MI69_MXNA1 m nm VSS VSS nm1p2_svt_lp L=6e-08 W=1.2e-07
MI75_MXNA1 Q nm VSS VSS nm1p2_svt_lp L=6e-08 W=4.2e-07
MI75_MXNA1_2 Q nm VSS VSS nm1p2_svt_lp L=6e-08 W=4.2e-07
MI72_MXPA1 nclk_ GN VDD VDD pm1p2_svt_lp L=6e-08 W=2e-07
MXP4 net048 S VDD VDD pm1p2_svt_lp L=6e-08 W=5.85e-07
MXP0 nd D net048 VDD pm1p2_svt_lp L=6e-08 W=5.85e-07
MI70_MXPOEN nm GN nd VDD pm1p2_svt_lp L=6e-08 W=3.4e-07
MXP3 nm nclk_ net33 VDD pm1p2_svt_lp L=6e-08 W=2e-07
MXP2 net33 m net043 VDD pm1p2_svt_lp L=6e-08 W=2e-07
MXP5 net043 S VDD VDD pm1p2_svt_lp L=6e-08 W=2e-07
MI69_MXPA1 m nm VDD VDD pm1p2_svt_lp L=6e-08 W=1.2e-07
MI75_MXPA1 Q nm VDD VDD pm1p2_svt_lp L=6e-08 W=5.85e-07
MI75_MXPA1_2 Q nm VDD VDD pm1p2_svt_lp L=6e-08 W=5.85e-07
.ENDS

.SUBCKT LATLSPQX3H9R Q VDD VSS D GN S
MI72_MXNA1 nclk_ GN VSS VSS nm1p2_svt_lp L=6e-08 W=1.5e-07
MXN0 nd D VSS VSS nm1p2_svt_lp L=6e-08 W=4.1e-07
MI70_MXNOE nm nclk_ nd VSS nm1p2_svt_lp L=6e-08 W=3.9e-07
MXN2 nm GN net23 VSS nm1p2_svt_lp L=6e-08 W=1.5e-07
MXN3 net23 m VSS VSS nm1p2_svt_lp L=6e-08 W=1.5e-07
MXN5 nm S VSS VSS nm1p2_svt_lp L=6e-08 W=1.5e-07
MI69_MXNA1 m nm VSS VSS nm1p2_svt_lp L=6e-08 W=1.2e-07
MI75_MXNA1 Q nm VSS VSS nm1p2_svt_lp L=6e-08 W=4.2e-07
MI75_MXNA1_2 Q nm VSS VSS nm1p2_svt_lp L=6e-08 W=4.2e-07
MI75_MXNA1_3 Q nm VSS VSS nm1p2_svt_lp L=6e-08 W=4.2e-07
MI72_MXPA1 nclk_ GN VDD VDD pm1p2_svt_lp L=6e-08 W=2e-07
MXP4_2 net048__2 S VDD VDD pm1p2_svt_lp L=6e-08 W=5.85e-07
MXP0_2 nd D net048__2 VDD pm1p2_svt_lp L=6e-08 W=5.85e-07
MXP0 nd D net048 VDD pm1p2_svt_lp L=6e-08 W=5.85e-07
MXP4 net048 S VDD VDD pm1p2_svt_lp L=6e-08 W=5.85e-07
MI70_MXPOEN nm GN nd VDD pm1p2_svt_lp L=6e-08 W=3.9e-07
MXP3 nm nclk_ net33 VDD pm1p2_svt_lp L=6e-08 W=2e-07
MXP2 net33 m net043 VDD pm1p2_svt_lp L=6e-08 W=2e-07
MXP5 net043 S VDD VDD pm1p2_svt_lp L=6e-08 W=2e-07
MI69_MXPA1 m nm VDD VDD pm1p2_svt_lp L=6e-08 W=1.2e-07
MI75_MXPA1 Q nm VDD VDD pm1p2_svt_lp L=6e-08 W=5.85e-07
MI75_MXPA1_2 Q nm VDD VDD pm1p2_svt_lp L=6e-08 W=5.85e-07
MI75_MXPA1_3 Q nm VDD VDD pm1p2_svt_lp L=6e-08 W=5.85e-07
.ENDS

.SUBCKT FREEICGX0P5H9R ECK VDD VSS CK
MXN4 lo hi VSS VSS nm1p2_svt_lp L=6e-08 W=1.5e-07
MXN1 n1 hi VSS VSS nm1p2_svt_lp L=6e-08 W=1.5e-07
MXN0 neck CK n1 VSS nm1p2_svt_lp L=6e-08 W=1.5e-07
MI8_MXNA1 ECK neck VSS VSS nm1p2_svt_lp L=6e-08 W=1.5e-07
MXP4 hi lo VDD VDD pm1p2_svt_lp L=6e-08 W=1.5e-07
MXP5 hi hi VDD VDD pm1p2_svt_lp L=6e-08 W=2.1e-07
MXP0 neck hi VDD VDD pm1p2_svt_lp L=6e-08 W=1.5e-07
MXP1 neck CK VDD VDD pm1p2_svt_lp L=6e-08 W=2.3e-07
MI8_MXPA1 ECK neck VDD VDD pm1p2_svt_lp L=6e-08 W=2.95e-07
.ENDS

.SUBCKT FREEICGX0P6H9R ECK VDD VSS CK
MXN4 lo hi VSS VSS nm1p2_svt_lp L=6e-08 W=1.5e-07
MXN1 n1 hi VSS VSS nm1p2_svt_lp L=6e-08 W=1.5e-07
MXN0 neck CK n1 VSS nm1p2_svt_lp L=6e-08 W=1.5e-07
MI8_MXNA1 ECK neck VSS VSS nm1p2_svt_lp L=6e-08 W=1.5e-07
MXP4 hi lo VDD VDD pm1p2_svt_lp L=6e-08 W=1.5e-07
MXP5 hi hi VDD VDD pm1p2_svt_lp L=6e-08 W=2.1e-07
MXP0 neck hi VDD VDD pm1p2_svt_lp L=6e-08 W=1.5e-07
MXP1 neck CK VDD VDD pm1p2_svt_lp L=6e-08 W=2.5e-07
MI8_MXPA1 ECK neck VDD VDD pm1p2_svt_lp L=6e-08 W=3.7e-07
.ENDS

.SUBCKT FREEICGX0P7H9R ECK VDD VSS CK
MXN4 lo hi VSS VSS nm1p2_svt_lp L=6e-08 W=1.5e-07
MXN1 n1 hi VSS VSS nm1p2_svt_lp L=6e-08 W=1.5e-07
MXN0 neck CK n1 VSS nm1p2_svt_lp L=6e-08 W=1.5e-07
MI8_MXNA1 ECK neck VSS VSS nm1p2_svt_lp L=6e-08 W=1.65e-07
MXP4 hi lo VDD VDD pm1p2_svt_lp L=6e-08 W=1.5e-07
MXP5 hi hi VDD VDD pm1p2_svt_lp L=6e-08 W=2.1e-07
MXP0 neck hi VDD VDD pm1p2_svt_lp L=6e-08 W=1.5e-07
MXP1 neck CK VDD VDD pm1p2_svt_lp L=6e-08 W=2.5e-07
MI8_MXPA1 ECK neck VDD VDD pm1p2_svt_lp L=6e-08 W=4.15e-07
.ENDS

.SUBCKT FREEICGX0P8H9R ECK VDD VSS CK
MXN4 lo hi VSS VSS nm1p2_svt_lp L=6e-08 W=1.5e-07
MXN1 n1 hi VSS VSS nm1p2_svt_lp L=6e-08 W=1.5e-07
MXN0 neck CK n1 VSS nm1p2_svt_lp L=6e-08 W=1.5e-07
MI8_MXNA1 ECK neck VSS VSS nm1p2_svt_lp L=6e-08 W=2e-07
MXP4 hi lo VDD VDD pm1p2_svt_lp L=6e-08 W=1.5e-07
MXP5 hi hi VDD VDD pm1p2_svt_lp L=6e-08 W=2.1e-07
MXP0 neck hi VDD VDD pm1p2_svt_lp L=6e-08 W=1.5e-07
MXP1 neck CK VDD VDD pm1p2_svt_lp L=6e-08 W=2.5e-07
MI8_MXPA1 ECK neck VDD VDD pm1p2_svt_lp L=6e-08 W=4.9e-07
.ENDS

.SUBCKT FREEICGX1H9R ECK VDD VSS CK
MXN4 lo hi VSS VSS nm1p2_svt_lp L=6e-08 W=1.5e-07
MXN1 n1 hi VSS VSS nm1p2_svt_lp L=6e-08 W=1.5e-07
MXN0 neck CK n1 VSS nm1p2_svt_lp L=6e-08 W=1.5e-07
MI8_MXNA1 ECK neck VSS VSS nm1p2_svt_lp L=6e-08 W=2.35e-07
MXP4 hi lo VDD VDD pm1p2_svt_lp L=6e-08 W=1.5e-07
MXP5 hi hi VDD VDD pm1p2_svt_lp L=6e-08 W=2.1e-07
MXP0 neck hi VDD VDD pm1p2_svt_lp L=6e-08 W=1.5e-07
MXP1 neck CK VDD VDD pm1p2_svt_lp L=6e-08 W=2.5e-07
MI8_MXPA1 ECK neck VDD VDD pm1p2_svt_lp L=6e-08 W=5.85e-07
.ENDS

.SUBCKT FREEICGX1P2H9R ECK VDD VSS CK
MXN4 lo hi VSS VSS nm1p2_svt_lp L=6e-08 W=1.5e-07
MXN1 n1 hi VSS VSS nm1p2_svt_lp L=6e-08 W=1.8e-07
MXN0 neck CK n1 VSS nm1p2_svt_lp L=6e-08 W=1.8e-07
MI8_MXNA1 ECK neck VSS VSS nm1p2_svt_lp L=6e-08 W=2.8e-07
MXP4 hi lo VDD VDD pm1p2_svt_lp L=6e-08 W=1.5e-07
MXP5 hi hi VDD VDD pm1p2_svt_lp L=6e-08 W=2.1e-07
MXP0 neck hi VDD VDD pm1p2_svt_lp L=6e-08 W=1.5e-07
MXP1 neck CK VDD VDD pm1p2_svt_lp L=6e-08 W=2.9e-07
MI8_MXPA1 ECK neck VDD VDD pm1p2_svt_lp L=6e-08 W=3.5e-07
MI8_MXPA1_2 ECK neck VDD VDD pm1p2_svt_lp L=6e-08 W=3.5e-07
.ENDS

.SUBCKT FREEICGX1P4H9R ECK VDD VSS CK
MXN4 lo hi VSS VSS nm1p2_svt_lp L=6e-08 W=1.5e-07
MXN1 n1 hi VSS VSS nm1p2_svt_lp L=6e-08 W=1.95e-07
MXN0 neck CK n1 VSS nm1p2_svt_lp L=6e-08 W=1.95e-07
MI8_MXNA1 ECK neck VSS VSS nm1p2_svt_lp L=6e-08 W=3.3e-07
MXP4 hi lo VDD VDD pm1p2_svt_lp L=6e-08 W=1.5e-07
MXP5 hi hi VDD VDD pm1p2_svt_lp L=6e-08 W=2.1e-07
MXP0 neck hi VDD VDD pm1p2_svt_lp L=6e-08 W=1.5e-07
MXP1 neck CK VDD VDD pm1p2_svt_lp L=6e-08 W=3.3e-07
MI8_MXPA1 ECK neck VDD VDD pm1p2_svt_lp L=6e-08 W=4.15e-07
MI8_MXPA1_2 ECK neck VDD VDD pm1p2_svt_lp L=6e-08 W=4.15e-07
.ENDS

.SUBCKT FREEICGX1P7H9R ECK VDD VSS CK
MXN4 lo hi VSS VSS nm1p2_svt_lp L=6e-08 W=1.5e-07
MXN1 n1 hi VSS VSS nm1p2_svt_lp L=6e-08 W=2.2e-07
MXN0 neck CK n1 VSS nm1p2_svt_lp L=6e-08 W=2.2e-07
MI8_MXNA1 ECK neck VSS VSS nm1p2_svt_lp L=6e-08 W=4e-07
MXP4 hi lo VDD VDD pm1p2_svt_lp L=6e-08 W=1.5e-07
MXP5 hi hi VDD VDD pm1p2_svt_lp L=6e-08 W=2.1e-07
MXP0 neck hi VDD VDD pm1p2_svt_lp L=6e-08 W=1.5e-07
MXP1 neck CK VDD VDD pm1p2_svt_lp L=6e-08 W=3.5e-07
MI8_MXPA1 ECK neck VDD VDD pm1p2_svt_lp L=6e-08 W=4.9e-07
MI8_MXPA1_2 ECK neck VDD VDD pm1p2_svt_lp L=6e-08 W=4.9e-07
.ENDS

.SUBCKT FREEICGX2H9R ECK VDD VSS CK
MXN4 lo hi VSS VSS nm1p2_svt_lp L=6e-08 W=1.5e-07
MXN1 n1 hi VSS VSS nm1p2_svt_lp L=6e-08 W=2.45e-07
MXN0 neck CK n1 VSS nm1p2_svt_lp L=6e-08 W=2.45e-07
MI8_MXNA1 ECK neck VSS VSS nm1p2_svt_lp L=6e-08 W=4.7e-07
MXP4 hi lo VDD VDD pm1p2_svt_lp L=6e-08 W=1.5e-07
MXP5 hi hi VDD VDD pm1p2_svt_lp L=6e-08 W=2.1e-07
MXP0 neck hi VDD VDD pm1p2_svt_lp L=6e-08 W=1.5e-07
MXP1 neck CK VDD VDD pm1p2_svt_lp L=6e-08 W=4.1e-07
MI8_MXPA1 ECK neck VDD VDD pm1p2_svt_lp L=6e-08 W=5.85e-07
MI8_MXPA1_2 ECK neck VDD VDD pm1p2_svt_lp L=6e-08 W=5.85e-07
.ENDS

.SUBCKT FREEICGX2P5H9R ECK VDD VSS CK
MXN4 lo hi VSS VSS nm1p2_svt_lp L=6e-08 W=1.5e-07
MXN1 n1 hi VSS VSS nm1p2_svt_lp L=6e-08 W=3.4e-07
MXN0 neck CK n1 VSS nm1p2_svt_lp L=6e-08 W=3.4e-07
MI8_MXNA1 ECK neck VSS VSS nm1p2_svt_lp L=6e-08 W=3e-07
MI8_MXNA1_2 ECK neck VSS VSS nm1p2_svt_lp L=6e-08 W=3e-07
MXP4 hi lo VDD VDD pm1p2_svt_lp L=6e-08 W=1.5e-07
MXP5 hi hi VDD VDD pm1p2_svt_lp L=6e-08 W=2.1e-07
MXP0 neck hi VDD VDD pm1p2_svt_lp L=6e-08 W=1.5e-07
MXP1 neck CK VDD VDD pm1p2_svt_lp L=6e-08 W=5.45e-07
MI8_MXPA1 ECK neck VDD VDD pm1p2_svt_lp L=6e-08 W=4.9e-07
MI8_MXPA1_2 ECK neck VDD VDD pm1p2_svt_lp L=6e-08 W=4.9e-07
MI8_MXPA1_3 ECK neck VDD VDD pm1p2_svt_lp L=6e-08 W=4.9e-07
.ENDS

.SUBCKT FREEICGX3H9R ECK VDD VSS CK
MXN4 lo hi VSS VSS nm1p2_svt_lp L=6e-08 W=1.5e-07
MXN1 n1 hi VSS VSS nm1p2_svt_lp L=6e-08 W=3.4e-07
MXN0 neck CK n1 VSS nm1p2_svt_lp L=6e-08 W=3.4e-07
MI8_MXNA1 ECK neck VSS VSS nm1p2_svt_lp L=6e-08 W=3.55e-07
MI8_MXNA1_2 ECK neck VSS VSS nm1p2_svt_lp L=6e-08 W=3.55e-07
MXP4 hi lo VDD VDD pm1p2_svt_lp L=6e-08 W=1.5e-07
MXP5 hi hi VDD VDD pm1p2_svt_lp L=6e-08 W=2.1e-07
MXP0 neck hi VDD VDD pm1p2_svt_lp L=6e-08 W=1.5e-07
MXP1 neck CK VDD VDD pm1p2_svt_lp L=6e-08 W=5.85e-07
MI8_MXPA1 ECK neck VDD VDD pm1p2_svt_lp L=6e-08 W=5.85e-07
MI8_MXPA1_2 ECK neck VDD VDD pm1p2_svt_lp L=6e-08 W=5.85e-07
MI8_MXPA1_3 ECK neck VDD VDD pm1p2_svt_lp L=6e-08 W=5.85e-07
.ENDS

.SUBCKT FREEICGX3P5H9R ECK VDD VSS CK
MXN4 lo hi VSS VSS nm1p2_svt_lp L=6e-08 W=1.5e-07
MXN1_2 n1__2 hi VSS VSS nm1p2_svt_lp L=6e-08 W=2.25e-07
MXN0_2 neck CK n1__2 VSS nm1p2_svt_lp L=6e-08 W=2.25e-07
MXN0 neck CK n1 VSS nm1p2_svt_lp L=6e-08 W=2.25e-07
MXN1 n1 hi VSS VSS nm1p2_svt_lp L=6e-08 W=2.25e-07
MI8_MXNA1 ECK neck VSS VSS nm1p2_svt_lp L=6e-08 W=2.05e-07
MI8_MXNA1_2 ECK neck VSS VSS nm1p2_svt_lp L=6e-08 W=2.05e-07
MI8_MXNA1_3 ECK neck VSS VSS nm1p2_svt_lp L=6e-08 W=2.05e-07
MI8_MXNA1_4 ECK neck VSS VSS nm1p2_svt_lp L=6e-08 W=2.05e-07
MXP4 hi lo VDD VDD pm1p2_svt_lp L=6e-08 W=1.5e-07
MXP5 hi hi VDD VDD pm1p2_svt_lp L=6e-08 W=2.1e-07
MXP1 neck CK VDD VDD pm1p2_svt_lp L=6e-08 W=3.8e-07
MXP1_2 neck CK VDD VDD pm1p2_svt_lp L=6e-08 W=3.8e-07
MXP0 neck hi VDD VDD pm1p2_svt_lp L=6e-08 W=1.5e-07
MI8_MXPA1 ECK neck VDD VDD pm1p2_svt_lp L=6e-08 W=5.1e-07
MI8_MXPA1_2 ECK neck VDD VDD pm1p2_svt_lp L=6e-08 W=5.1e-07
MI8_MXPA1_3 ECK neck VDD VDD pm1p2_svt_lp L=6e-08 W=5.1e-07
MI8_MXPA1_4 ECK neck VDD VDD pm1p2_svt_lp L=6e-08 W=5.1e-07
.ENDS

.SUBCKT FREEICGX4H9R ECK VDD VSS CK
MXN4 lo hi VSS VSS nm1p2_svt_lp L=6e-08 W=1.5e-07
MXN1_2 n1__2 hi VSS VSS nm1p2_svt_lp L=6e-08 W=2.45e-07
MXN0_2 neck CK n1__2 VSS nm1p2_svt_lp L=6e-08 W=2.45e-07
MXN0 neck CK n1 VSS nm1p2_svt_lp L=6e-08 W=2.45e-07
MXN1 n1 hi VSS VSS nm1p2_svt_lp L=6e-08 W=2.45e-07
MI8_MXNA1 ECK neck VSS VSS nm1p2_svt_lp L=6e-08 W=2.35e-07
MI8_MXNA1_2 ECK neck VSS VSS nm1p2_svt_lp L=6e-08 W=2.35e-07
MI8_MXNA1_3 ECK neck VSS VSS nm1p2_svt_lp L=6e-08 W=2.35e-07
MI8_MXNA1_4 ECK neck VSS VSS nm1p2_svt_lp L=6e-08 W=2.35e-07
MXP4 hi lo VDD VDD pm1p2_svt_lp L=6e-08 W=1.5e-07
MXP5 hi hi VDD VDD pm1p2_svt_lp L=6e-08 W=2.1e-07
MXP1 neck CK VDD VDD pm1p2_svt_lp L=6e-08 W=4.2e-07
MXP1_2 neck CK VDD VDD pm1p2_svt_lp L=6e-08 W=4.2e-07
MXP0 neck hi VDD VDD pm1p2_svt_lp L=6e-08 W=1.5e-07
MI8_MXPA1 ECK neck VDD VDD pm1p2_svt_lp L=6e-08 W=5.85e-07
MI8_MXPA1_2 ECK neck VDD VDD pm1p2_svt_lp L=6e-08 W=5.85e-07
MI8_MXPA1_3 ECK neck VDD VDD pm1p2_svt_lp L=6e-08 W=5.85e-07
MI8_MXPA1_4 ECK neck VDD VDD pm1p2_svt_lp L=6e-08 W=5.85e-07
.ENDS

.SUBCKT FREEICGX5H9R ECK VDD VSS CK
MXN4 lo hi VSS VSS nm1p2_svt_lp L=6e-08 W=1.5e-07
MXN1_2 n1__2 hi VSS VSS nm1p2_svt_lp L=6e-08 W=3.15e-07
MXN0_2 neck CK n1__2 VSS nm1p2_svt_lp L=6e-08 W=3.15e-07
MXN0 neck CK n1 VSS nm1p2_svt_lp L=6e-08 W=3.15e-07
MXN1 n1 hi VSS VSS nm1p2_svt_lp L=6e-08 W=3.15e-07
MI8_MXNA1 ECK neck VSS VSS nm1p2_svt_lp L=6e-08 W=2.35e-07
MI8_MXNA1_2 ECK neck VSS VSS nm1p2_svt_lp L=6e-08 W=2.35e-07
MI8_MXNA1_3 ECK neck VSS VSS nm1p2_svt_lp L=6e-08 W=2.35e-07
MI8_MXNA1_4 ECK neck VSS VSS nm1p2_svt_lp L=6e-08 W=2.35e-07
MI8_MXNA1_5 ECK neck VSS VSS nm1p2_svt_lp L=6e-08 W=2.35e-07
MXP4 hi lo VDD VDD pm1p2_svt_lp L=6e-08 W=1.95e-07
MXP5 hi hi VDD VDD pm1p2_svt_lp L=6e-08 W=2.1e-07
MXP1 neck CK VDD VDD pm1p2_svt_lp L=6e-08 W=5.8e-07
MXP1_2 neck CK VDD VDD pm1p2_svt_lp L=6e-08 W=5.8e-07
MXP0 neck hi VDD VDD pm1p2_svt_lp L=6e-08 W=1.5e-07
MI8_MXPA1 ECK neck VDD VDD pm1p2_svt_lp L=6e-08 W=5.85e-07
MI8_MXPA1_2 ECK neck VDD VDD pm1p2_svt_lp L=6e-08 W=5.85e-07
MI8_MXPA1_3 ECK neck VDD VDD pm1p2_svt_lp L=6e-08 W=5.85e-07
MI8_MXPA1_4 ECK neck VDD VDD pm1p2_svt_lp L=6e-08 W=5.85e-07
MI8_MXPA1_5 ECK neck VDD VDD pm1p2_svt_lp L=6e-08 W=5.85e-07
.ENDS

.SUBCKT FREEICGX6H9R ECK VDD VSS CK
MXN4 lo hi VSS VSS nm1p2_svt_lp L=6e-08 W=1.5e-07
MXN1_2 n1__2 hi VSS VSS nm1p2_svt_lp L=6e-08 W=3.7e-07
MXN0_2 neck CK n1__2 VSS nm1p2_svt_lp L=6e-08 W=3.7e-07
MXN0 neck CK n1 VSS nm1p2_svt_lp L=6e-08 W=3.7e-07
MXN1 n1 hi VSS VSS nm1p2_svt_lp L=6e-08 W=3.7e-07
MI8_MXNA1 ECK neck VSS VSS nm1p2_svt_lp L=6e-08 W=2.35e-07
MI8_MXNA1_2 ECK neck VSS VSS nm1p2_svt_lp L=6e-08 W=2.35e-07
MI8_MXNA1_3 ECK neck VSS VSS nm1p2_svt_lp L=6e-08 W=2.35e-07
MI8_MXNA1_4 ECK neck VSS VSS nm1p2_svt_lp L=6e-08 W=2.35e-07
MI8_MXNA1_5 ECK neck VSS VSS nm1p2_svt_lp L=6e-08 W=2.35e-07
MI8_MXNA1_6 ECK neck VSS VSS nm1p2_svt_lp L=6e-08 W=2.35e-07
MXP4 hi lo VDD VDD pm1p2_svt_lp L=6e-08 W=2.25e-07
MXP5 hi hi VDD VDD pm1p2_svt_lp L=6e-08 W=2.1e-07
MXP1 neck CK VDD VDD pm1p2_svt_lp L=6e-08 W=6.6e-07
MXP1_2 neck CK VDD VDD pm1p2_svt_lp L=6e-08 W=6.6e-07
MXP0 neck hi VDD VDD pm1p2_svt_lp L=6e-08 W=1.5e-07
MI8_MXPA1 ECK neck VDD VDD pm1p2_svt_lp L=6e-08 W=5.85e-07
MI8_MXPA1_2 ECK neck VDD VDD pm1p2_svt_lp L=6e-08 W=5.85e-07
MI8_MXPA1_3 ECK neck VDD VDD pm1p2_svt_lp L=6e-08 W=5.85e-07
MI8_MXPA1_4 ECK neck VDD VDD pm1p2_svt_lp L=6e-08 W=5.85e-07
MI8_MXPA1_5 ECK neck VDD VDD pm1p2_svt_lp L=6e-08 W=5.85e-07
MI8_MXPA1_6 ECK neck VDD VDD pm1p2_svt_lp L=6e-08 W=5.85e-07
.ENDS

.SUBCKT FREEICGX7P5H9R ECK VDD VSS CK
MXN4 lo hi VSS VSS nm1p2_svt_lp L=6e-08 W=1.5e-07
MXN1_2 n1__2 hi VSS VSS nm1p2_svt_lp L=6e-08 W=4.7e-07
MXN0_2 neck CK n1__2 VSS nm1p2_svt_lp L=6e-08 W=4.7e-07
MXN0 neck CK n1 VSS nm1p2_svt_lp L=6e-08 W=4.7e-07
MXN1 n1 hi VSS VSS nm1p2_svt_lp L=6e-08 W=4.7e-07
MI8_MXNA1 ECK neck VSS VSS nm1p2_svt_lp L=6e-08 W=2.2e-07
MI8_MXNA1_2 ECK neck VSS VSS nm1p2_svt_lp L=6e-08 W=2.2e-07
MI8_MXNA1_3 ECK neck VSS VSS nm1p2_svt_lp L=6e-08 W=2.2e-07
MI8_MXNA1_4 ECK neck VSS VSS nm1p2_svt_lp L=6e-08 W=2.2e-07
MI8_MXNA1_5 ECK neck VSS VSS nm1p2_svt_lp L=6e-08 W=2.2e-07
MI8_MXNA1_6 ECK neck VSS VSS nm1p2_svt_lp L=6e-08 W=2.2e-07
MI8_MXNA1_7 ECK neck VSS VSS nm1p2_svt_lp L=6e-08 W=2.2e-07
MI8_MXNA1_8 ECK neck VSS VSS nm1p2_svt_lp L=6e-08 W=2.2e-07
MXP4 hi lo VDD VDD pm1p2_svt_lp L=6e-08 W=2.9e-07
MXP5 hi hi VDD VDD pm1p2_svt_lp L=6e-08 W=2.1e-07
MXP1 neck CK VDD VDD pm1p2_svt_lp L=6e-08 W=5.6e-07
MXP1_2 neck CK VDD VDD pm1p2_svt_lp L=6e-08 W=5.6e-07
MXP0 neck hi VDD VDD pm1p2_svt_lp L=6e-08 W=1.7e-07
MXP1_3 neck CK VDD VDD pm1p2_svt_lp L=6e-08 W=5.6e-07
MI8_MXPA1 ECK neck VDD VDD pm1p2_svt_lp L=6e-08 W=5.5e-07
MI8_MXPA1_2 ECK neck VDD VDD pm1p2_svt_lp L=6e-08 W=5.5e-07
MI8_MXPA1_3 ECK neck VDD VDD pm1p2_svt_lp L=6e-08 W=5.5e-07
MI8_MXPA1_4 ECK neck VDD VDD pm1p2_svt_lp L=6e-08 W=5.5e-07
MI8_MXPA1_5 ECK neck VDD VDD pm1p2_svt_lp L=6e-08 W=5.5e-07
MI8_MXPA1_6 ECK neck VDD VDD pm1p2_svt_lp L=6e-08 W=5.5e-07
MI8_MXPA1_7 ECK neck VDD VDD pm1p2_svt_lp L=6e-08 W=5.5e-07
MI8_MXPA1_8 ECK neck VDD VDD pm1p2_svt_lp L=6e-08 W=5.5e-07
.ENDS

.SUBCKT FREEICGX9H9R ECK VDD VSS CK
MXN4 lo hi VSS VSS nm1p2_svt_lp L=6e-08 W=1.5e-07
MXN1_2 n1__2 hi VSS VSS nm1p2_svt_lp L=6e-08 W=3.7e-07
MXN0_2 neck CK n1__2 VSS nm1p2_svt_lp L=6e-08 W=3.7e-07
MXN0_3 neck CK n1__3 VSS nm1p2_svt_lp L=6e-08 W=3.7e-07
MXN1_3 n1__3 hi VSS VSS nm1p2_svt_lp L=6e-08 W=3.7e-07
MXN1 n1 hi VSS VSS nm1p2_svt_lp L=6e-08 W=3.7e-07
MXN0 neck CK n1 VSS nm1p2_svt_lp L=6e-08 W=3.7e-07
MI8_MXNA1 ECK neck VSS VSS nm1p2_svt_lp L=6e-08 W=4.25e-07
MI8_MXNA1_2 ECK neck VSS VSS nm1p2_svt_lp L=6e-08 W=4.25e-07
MI8_MXNA1_3 ECK neck VSS VSS nm1p2_svt_lp L=6e-08 W=4.25e-07
MI8_MXNA1_4 ECK neck VSS VSS nm1p2_svt_lp L=6e-08 W=4.25e-07
MI8_MXNA1_5 ECK neck VSS VSS nm1p2_svt_lp L=6e-08 W=4.25e-07
MXP4 hi lo VDD VDD pm1p2_svt_lp L=6e-08 W=3.4e-07
MXP5 hi hi VDD VDD pm1p2_svt_lp L=6e-08 W=2.1e-07
MXP1 neck CK VDD VDD pm1p2_svt_lp L=6e-08 W=5.65e-07
MXP1_2 neck CK VDD VDD pm1p2_svt_lp L=6e-08 W=5.65e-07
MXP0 neck hi VDD VDD pm1p2_svt_lp L=6e-08 W=1.7e-07
MXP1_3 neck CK VDD VDD pm1p2_svt_lp L=6e-08 W=5.65e-07
MI8_MXPA1 ECK neck VDD VDD pm1p2_svt_lp L=6e-08 W=5.85e-07
MI8_MXPA1_2 ECK neck VDD VDD pm1p2_svt_lp L=6e-08 W=5.85e-07
MI8_MXPA1_3 ECK neck VDD VDD pm1p2_svt_lp L=6e-08 W=5.85e-07
MI8_MXPA1_4 ECK neck VDD VDD pm1p2_svt_lp L=6e-08 W=5.85e-07
MI8_MXPA1_5 ECK neck VDD VDD pm1p2_svt_lp L=6e-08 W=5.85e-07
MI8_MXPA1_6 ECK neck VDD VDD pm1p2_svt_lp L=6e-08 W=5.85e-07
MI8_MXPA1_7 ECK neck VDD VDD pm1p2_svt_lp L=6e-08 W=5.85e-07
MI8_MXPA1_8 ECK neck VDD VDD pm1p2_svt_lp L=6e-08 W=5.85e-07
MI8_MXPA1_9 ECK neck VDD VDD pm1p2_svt_lp L=6e-08 W=5.85e-07
.ENDS

.SUBCKT FREEICGX11H9R ECK VDD VSS CK
MXN4 lo hi VSS VSS nm1p2_svt_lp L=6e-08 W=1.5e-07
MXN1_2 n1__2 hi VSS VSS nm1p2_svt_lp L=6e-08 W=4.5e-07
MXN0_2 neck CK n1__2 VSS nm1p2_svt_lp L=6e-08 W=4.5e-07
MXN0_3 neck CK n1__3 VSS nm1p2_svt_lp L=6e-08 W=4.5e-07
MXN1_3 n1__3 hi VSS VSS nm1p2_svt_lp L=6e-08 W=4.5e-07
MXN1 n1 hi VSS VSS nm1p2_svt_lp L=6e-08 W=4.5e-07
MXN0 neck CK n1 VSS nm1p2_svt_lp L=6e-08 W=4.5e-07
MI8_MXNA1 ECK neck VSS VSS nm1p2_svt_lp L=6e-08 W=2.6e-07
MI8_MXNA1_2 ECK neck VSS VSS nm1p2_svt_lp L=6e-08 W=2.6e-07
MI8_MXNA1_3 ECK neck VSS VSS nm1p2_svt_lp L=6e-08 W=2.6e-07
MI8_MXNA1_4 ECK neck VSS VSS nm1p2_svt_lp L=6e-08 W=2.6e-07
MI8_MXNA1_5 ECK neck VSS VSS nm1p2_svt_lp L=6e-08 W=2.6e-07
MI8_MXNA1_6 ECK neck VSS VSS nm1p2_svt_lp L=6e-08 W=2.6e-07
MI8_MXNA1_7 ECK neck VSS VSS nm1p2_svt_lp L=6e-08 W=2.6e-07
MI8_MXNA1_8 ECK neck VSS VSS nm1p2_svt_lp L=6e-08 W=2.6e-07
MI8_MXNA1_9 ECK neck VSS VSS nm1p2_svt_lp L=6e-08 W=2.6e-07
MI8_MXNA1_10 ECK neck VSS VSS nm1p2_svt_lp L=6e-08 W=2.6e-07
MXP4 hi lo VDD VDD pm1p2_svt_lp L=6e-08 W=4.2e-07
MXP5 hi hi VDD VDD pm1p2_svt_lp L=6e-08 W=2.1e-07
MXP1 neck CK VDD VDD pm1p2_svt_lp L=6e-08 W=5.85e-07
MXP1_2 neck CK VDD VDD pm1p2_svt_lp L=6e-08 W=5.85e-07
MXP0 neck hi VDD VDD pm1p2_svt_lp L=6e-08 W=2.35e-07
MXP1_3 neck CK VDD VDD pm1p2_svt_lp L=6e-08 W=5.85e-07
MXP1_4 neck CK VDD VDD pm1p2_svt_lp L=6e-08 W=5.85e-07
MI8_MXPA1 ECK neck VDD VDD pm1p2_svt_lp L=6e-08 W=5.85e-07
MI8_MXPA1_2 ECK neck VDD VDD pm1p2_svt_lp L=6e-08 W=5.85e-07
MI8_MXPA1_3 ECK neck VDD VDD pm1p2_svt_lp L=6e-08 W=5.85e-07
MI8_MXPA1_4 ECK neck VDD VDD pm1p2_svt_lp L=6e-08 W=5.85e-07
MI8_MXPA1_5 ECK neck VDD VDD pm1p2_svt_lp L=6e-08 W=5.85e-07
MI8_MXPA1_6 ECK neck VDD VDD pm1p2_svt_lp L=6e-08 W=5.85e-07
MI8_MXPA1_7 ECK neck VDD VDD pm1p2_svt_lp L=6e-08 W=5.85e-07
MI8_MXPA1_8 ECK neck VDD VDD pm1p2_svt_lp L=6e-08 W=5.85e-07
MI8_MXPA1_9 ECK neck VDD VDD pm1p2_svt_lp L=6e-08 W=5.85e-07
MI8_MXPA1_10 ECK neck VDD VDD pm1p2_svt_lp L=6e-08 W=5.85e-07
MI8_MXPA1_11 ECK neck VDD VDD pm1p2_svt_lp L=6e-08 W=5.85e-07
.ENDS

.SUBCKT FREEICGX13H9R ECK VDD VSS CK
MXN4 lo hi VSS VSS nm1p2_svt_lp L=6e-08 W=1.5e-07
MXN1_2 n1__2 hi VSS VSS nm1p2_svt_lp L=6e-08 W=4e-07
MXN0_2 neck CK n1__2 VSS nm1p2_svt_lp L=6e-08 W=4e-07
MXN0_3 neck CK n1__3 VSS nm1p2_svt_lp L=6e-08 W=4e-07
MXN1_3 n1__3 hi VSS VSS nm1p2_svt_lp L=6e-08 W=4e-07
MXN1_4 n1__4 hi VSS VSS nm1p2_svt_lp L=6e-08 W=4e-07
MXN0_4 neck CK n1__4 VSS nm1p2_svt_lp L=6e-08 W=4e-07
MXN0 neck CK n1 VSS nm1p2_svt_lp L=6e-08 W=4e-07
MXN1 n1 hi VSS VSS nm1p2_svt_lp L=6e-08 W=4e-07
MI8_MXNA1 ECK neck VSS VSS nm1p2_svt_lp L=6e-08 W=2.35e-07
MI8_MXNA1_2 ECK neck VSS VSS nm1p2_svt_lp L=6e-08 W=2.35e-07
MI8_MXNA1_3 ECK neck VSS VSS nm1p2_svt_lp L=6e-08 W=2.35e-07
MI8_MXNA1_4 ECK neck VSS VSS nm1p2_svt_lp L=6e-08 W=2.35e-07
MI8_MXNA1_5 ECK neck VSS VSS nm1p2_svt_lp L=6e-08 W=2.35e-07
MI8_MXNA1_6 ECK neck VSS VSS nm1p2_svt_lp L=6e-08 W=2.35e-07
MI8_MXNA1_7 ECK neck VSS VSS nm1p2_svt_lp L=6e-08 W=2.35e-07
MI8_MXNA1_8 ECK neck VSS VSS nm1p2_svt_lp L=6e-08 W=2.35e-07
MI8_MXNA1_9 ECK neck VSS VSS nm1p2_svt_lp L=6e-08 W=2.35e-07
MI8_MXNA1_10 ECK neck VSS VSS nm1p2_svt_lp L=6e-08 W=2.35e-07
MI8_MXNA1_11 ECK neck VSS VSS nm1p2_svt_lp L=6e-08 W=2.35e-07
MI8_MXNA1_12 ECK neck VSS VSS nm1p2_svt_lp L=6e-08 W=2.35e-07
MI8_MXNA1_13 ECK neck VSS VSS nm1p2_svt_lp L=6e-08 W=2.35e-07
MXP4 hi lo VDD VDD pm1p2_svt_lp L=6e-08 W=4.95e-07
MXP5 hi hi VDD VDD pm1p2_svt_lp L=6e-08 W=2.1e-07
MXP1 neck CK VDD VDD pm1p2_svt_lp L=6e-08 W=5.35e-07
MXP1_2 neck CK VDD VDD pm1p2_svt_lp L=6e-08 W=5.35e-07
MXP0 neck hi VDD VDD pm1p2_svt_lp L=6e-08 W=2.65e-07
MXP1_3 neck CK VDD VDD pm1p2_svt_lp L=6e-08 W=5.35e-07
MXP1_4 neck CK VDD VDD pm1p2_svt_lp L=6e-08 W=5.35e-07
MXP1_5 neck CK VDD VDD pm1p2_svt_lp L=6e-08 W=5.35e-07
MI8_MXPA1 ECK neck VDD VDD pm1p2_svt_lp L=6e-08 W=5.85e-07
MI8_MXPA1_2 ECK neck VDD VDD pm1p2_svt_lp L=6e-08 W=5.85e-07
MI8_MXPA1_3 ECK neck VDD VDD pm1p2_svt_lp L=6e-08 W=5.85e-07
MI8_MXPA1_4 ECK neck VDD VDD pm1p2_svt_lp L=6e-08 W=5.85e-07
MI8_MXPA1_5 ECK neck VDD VDD pm1p2_svt_lp L=6e-08 W=5.85e-07
MI8_MXPA1_6 ECK neck VDD VDD pm1p2_svt_lp L=6e-08 W=5.85e-07
MI8_MXPA1_7 ECK neck VDD VDD pm1p2_svt_lp L=6e-08 W=5.85e-07
MI8_MXPA1_8 ECK neck VDD VDD pm1p2_svt_lp L=6e-08 W=5.85e-07
MI8_MXPA1_9 ECK neck VDD VDD pm1p2_svt_lp L=6e-08 W=5.85e-07
MI8_MXPA1_10 ECK neck VDD VDD pm1p2_svt_lp L=6e-08 W=5.85e-07
MI8_MXPA1_11 ECK neck VDD VDD pm1p2_svt_lp L=6e-08 W=5.85e-07
MI8_MXPA1_12 ECK neck VDD VDD pm1p2_svt_lp L=6e-08 W=5.85e-07
MI8_MXPA1_13 ECK neck VDD VDD pm1p2_svt_lp L=6e-08 W=5.85e-07
.ENDS

.SUBCKT FREEICGX16H9R ECK VDD VSS CK
MXN4 lo hi VSS VSS nm1p2_svt_lp L=6e-08 W=1.5e-07
MXN1_2 n1__2 hi VSS VSS nm1p2_svt_lp L=6e-08 W=3.3e-07
MXN0_2 neck CK n1__2 VSS nm1p2_svt_lp L=6e-08 W=3.3e-07
MXN0_3 neck CK n1__3 VSS nm1p2_svt_lp L=6e-08 W=3.3e-07
MXN1_3 n1__3 hi VSS VSS nm1p2_svt_lp L=6e-08 W=3.3e-07
MXN1_4 n1__4 hi VSS VSS nm1p2_svt_lp L=6e-08 W=3.3e-07
MXN0_4 neck CK n1__4 VSS nm1p2_svt_lp L=6e-08 W=3.3e-07
MXN0_5 neck CK n1__5 VSS nm1p2_svt_lp L=6e-08 W=3.3e-07
MXN1_5 n1__5 hi VSS VSS nm1p2_svt_lp L=6e-08 W=3.3e-07
MXN1 n1 hi VSS VSS nm1p2_svt_lp L=6e-08 W=3.3e-07
MXN0 neck CK n1 VSS nm1p2_svt_lp L=6e-08 W=3.3e-07
MI8_MXNA1 ECK neck VSS VSS nm1p2_svt_lp L=6e-08 W=4.7e-07
MI8_MXNA1_2 ECK neck VSS VSS nm1p2_svt_lp L=6e-08 W=4.7e-07
MI8_MXNA1_3 ECK neck VSS VSS nm1p2_svt_lp L=6e-08 W=4.7e-07
MI8_MXNA1_4 ECK neck VSS VSS nm1p2_svt_lp L=6e-08 W=4.7e-07
MI8_MXNA1_5 ECK neck VSS VSS nm1p2_svt_lp L=6e-08 W=4.7e-07
MI8_MXNA1_6 ECK neck VSS VSS nm1p2_svt_lp L=6e-08 W=4.7e-07
MI8_MXNA1_7 ECK neck VSS VSS nm1p2_svt_lp L=6e-08 W=4.7e-07
MI8_MXNA1_8 ECK neck VSS VSS nm1p2_svt_lp L=6e-08 W=4.7e-07
MXP4 hi lo VDD VDD pm1p2_svt_lp L=6e-08 W=5.85e-07
MXP5 hi hi VDD VDD pm1p2_svt_lp L=6e-08 W=2.1e-07
MXP1 neck CK VDD VDD pm1p2_svt_lp L=6e-08 W=5.85e-07
MXP1_2 neck CK VDD VDD pm1p2_svt_lp L=6e-08 W=5.85e-07
MXP1_3 neck CK VDD VDD pm1p2_svt_lp L=6e-08 W=5.85e-07
MXP1_4 neck CK VDD VDD pm1p2_svt_lp L=6e-08 W=5.85e-07
MXP0 neck hi VDD VDD pm1p2_svt_lp L=6e-08 W=2.9e-07
MXP1_5 neck CK VDD VDD pm1p2_svt_lp L=6e-08 W=5.85e-07
MI8_MXPA1 ECK neck VDD VDD pm1p2_svt_lp L=6e-08 W=5.85e-07
MI8_MXPA1_2 ECK neck VDD VDD pm1p2_svt_lp L=6e-08 W=5.85e-07
MI8_MXPA1_3 ECK neck VDD VDD pm1p2_svt_lp L=6e-08 W=5.85e-07
MI8_MXPA1_4 ECK neck VDD VDD pm1p2_svt_lp L=6e-08 W=5.85e-07
MI8_MXPA1_5 ECK neck VDD VDD pm1p2_svt_lp L=6e-08 W=5.85e-07
MI8_MXPA1_6 ECK neck VDD VDD pm1p2_svt_lp L=6e-08 W=5.85e-07
MI8_MXPA1_7 ECK neck VDD VDD pm1p2_svt_lp L=6e-08 W=5.85e-07
MI8_MXPA1_8 ECK neck VDD VDD pm1p2_svt_lp L=6e-08 W=5.85e-07
MI8_MXPA1_9 ECK neck VDD VDD pm1p2_svt_lp L=6e-08 W=5.85e-07
MI8_MXPA1_10 ECK neck VDD VDD pm1p2_svt_lp L=6e-08 W=5.85e-07
MI8_MXPA1_11 ECK neck VDD VDD pm1p2_svt_lp L=6e-08 W=5.85e-07
MI8_MXPA1_12 ECK neck VDD VDD pm1p2_svt_lp L=6e-08 W=5.85e-07
MI8_MXPA1_13 ECK neck VDD VDD pm1p2_svt_lp L=6e-08 W=5.85e-07
MI8_MXPA1_14 ECK neck VDD VDD pm1p2_svt_lp L=6e-08 W=5.85e-07
MI8_MXPA1_15 ECK neck VDD VDD pm1p2_svt_lp L=6e-08 W=5.85e-07
MI8_MXPA1_16 ECK neck VDD VDD pm1p2_svt_lp L=6e-08 W=5.85e-07
.ENDS

.SUBCKT PREICGX0P5H9R ECK VDD VSS CK E SE
MI78_MXNA2 ne SE VSS VSS nm1p2_svt_lp L=6e-08 W=2.7e-07
MI78_MXNA1 ne E VSS VSS nm1p2_svt_lp L=6e-08 W=2.7e-07
MI20_MXNOE nm nck ne VSS nm1p2_svt_lp L=6e-08 W=2.7e-07
MI29_MXNOE nm CK XI29_n1 VSS nm1p2_svt_lp L=6e-08 W=1.5e-07
MI29_MXNA1 XI29_n1 m VSS VSS nm1p2_svt_lp L=6e-08 W=1.5e-07
MI74_MXNA1 m nm VSS VSS nm1p2_svt_lp L=6e-08 W=1.6e-07
MXN1 n1 m VSS VSS nm1p2_svt_lp L=6e-08 W=1.5e-07
MXN0 neck CK n1 VSS nm1p2_svt_lp L=6e-08 W=1.5e-07
MI72_MXNA1 nck CK VSS VSS nm1p2_svt_lp L=6e-08 W=1.5e-07
MI8_MXNA1 ECK neck VSS VSS nm1p2_svt_lp L=6e-08 W=1.5e-07
MI78_MXPA2 XI78_p1 SE VDD VDD pm1p2_svt_lp L=6e-08 W=3.35e-07
MI78_MXPA2_2 XI78_p1 SE VDD VDD pm1p2_svt_lp L=6e-08 W=3.35e-07
MI78_MXPA1 ne E XI78_p1 VDD pm1p2_svt_lp L=6e-08 W=3.35e-07
MI20_MXPOEN nm CK ne VDD pm1p2_svt_lp L=6e-08 W=2.7e-07
MI29_MXPOEN nm nck XI29_p1 VDD pm1p2_svt_lp L=6e-08 W=1.5e-07
MI29_MXPA1 XI29_p1 m VDD VDD pm1p2_svt_lp L=6e-08 W=1.5e-07
MI74_MXPA1 m nm VDD VDD pm1p2_svt_lp L=6e-08 W=2.25e-07
MXP0 neck m VDD VDD pm1p2_svt_lp L=6e-08 W=1.5e-07
MXP1 neck CK VDD VDD pm1p2_svt_lp L=6e-08 W=2.3e-07
MI72_MXPA1 nck CK VDD VDD pm1p2_svt_lp L=6e-08 W=2.1e-07
MI8_MXPA1 ECK neck VDD VDD pm1p2_svt_lp L=6e-08 W=2.95e-07
.ENDS

.SUBCKT PREICGX0P6H9R ECK VDD VSS CK E SE
MI78_MXNA2 ne SE VSS VSS nm1p2_svt_lp L=6e-08 W=2.7e-07
MI78_MXNA1 ne E VSS VSS nm1p2_svt_lp L=6e-08 W=2.7e-07
MI20_MXNOE nm nck ne VSS nm1p2_svt_lp L=6e-08 W=2.7e-07
MI29_MXNOE nm CK XI29_n1 VSS nm1p2_svt_lp L=6e-08 W=1.5e-07
MI29_MXNA1 XI29_n1 m VSS VSS nm1p2_svt_lp L=6e-08 W=1.5e-07
MI74_MXNA1 m nm VSS VSS nm1p2_svt_lp L=6e-08 W=1.6e-07
MXN1 n1 m VSS VSS nm1p2_svt_lp L=6e-08 W=1.5e-07
MXN0 neck CK n1 VSS nm1p2_svt_lp L=6e-08 W=1.5e-07
MI72_MXNA1 nck CK VSS VSS nm1p2_svt_lp L=6e-08 W=1.5e-07
MI8_MXNA1 ECK neck VSS VSS nm1p2_svt_lp L=6e-08 W=1.5e-07
MI78_MXPA2 XI78_p1 SE VDD VDD pm1p2_svt_lp L=6e-08 W=3.35e-07
MI78_MXPA2_2 XI78_p1 SE VDD VDD pm1p2_svt_lp L=6e-08 W=3.35e-07
MI78_MXPA1 ne E XI78_p1 VDD pm1p2_svt_lp L=6e-08 W=3.35e-07
MI20_MXPOEN nm CK ne VDD pm1p2_svt_lp L=6e-08 W=2.7e-07
MI29_MXPOEN nm nck XI29_p1 VDD pm1p2_svt_lp L=6e-08 W=1.5e-07
MI29_MXPA1 XI29_p1 m VDD VDD pm1p2_svt_lp L=6e-08 W=1.5e-07
MI74_MXPA1 m nm VDD VDD pm1p2_svt_lp L=6e-08 W=2.25e-07
MXP0 neck m VDD VDD pm1p2_svt_lp L=6e-08 W=1.5e-07
MXP1 neck CK VDD VDD pm1p2_svt_lp L=6e-08 W=2.5e-07
MI72_MXPA1 nck CK VDD VDD pm1p2_svt_lp L=6e-08 W=2e-07
MI8_MXPA1 ECK neck VDD VDD pm1p2_svt_lp L=6e-08 W=3.7e-07
.ENDS

.SUBCKT PREICGX0P7H9R ECK VDD VSS CK E SE
MI78_MXNA2 ne SE VSS VSS nm1p2_svt_lp L=6e-08 W=2.7e-07
MI78_MXNA1 ne E VSS VSS nm1p2_svt_lp L=6e-08 W=2.7e-07
MI20_MXNOE nm nck ne VSS nm1p2_svt_lp L=6e-08 W=2.7e-07
MI29_MXNOE nm CK XI29_n1 VSS nm1p2_svt_lp L=6e-08 W=1.5e-07
MI29_MXNA1 XI29_n1 m VSS VSS nm1p2_svt_lp L=6e-08 W=1.5e-07
MI74_MXNA1 m nm VSS VSS nm1p2_svt_lp L=6e-08 W=1.6e-07
MXN1 n1 m VSS VSS nm1p2_svt_lp L=6e-08 W=1.5e-07
MXN0 neck CK n1 VSS nm1p2_svt_lp L=6e-08 W=1.5e-07
MI72_MXNA1 nck CK VSS VSS nm1p2_svt_lp L=6e-08 W=1.5e-07
MI8_MXNA1 ECK neck VSS VSS nm1p2_svt_lp L=6e-08 W=1.65e-07
MI78_MXPA2 XI78_p1 SE VDD VDD pm1p2_svt_lp L=6e-08 W=3.35e-07
MI78_MXPA2_2 XI78_p1 SE VDD VDD pm1p2_svt_lp L=6e-08 W=3.35e-07
MI78_MXPA1 ne E XI78_p1 VDD pm1p2_svt_lp L=6e-08 W=3.35e-07
MI20_MXPOEN nm CK ne VDD pm1p2_svt_lp L=6e-08 W=2.7e-07
MI29_MXPOEN nm nck XI29_p1 VDD pm1p2_svt_lp L=6e-08 W=1.5e-07
MI29_MXPA1 XI29_p1 m VDD VDD pm1p2_svt_lp L=6e-08 W=1.5e-07
MI74_MXPA1 m nm VDD VDD pm1p2_svt_lp L=6e-08 W=2.25e-07
MXP0 neck m VDD VDD pm1p2_svt_lp L=6e-08 W=1.5e-07
MXP1 neck CK VDD VDD pm1p2_svt_lp L=6e-08 W=2.5e-07
MI72_MXPA1 nck CK VDD VDD pm1p2_svt_lp L=6e-08 W=2.1e-07
MI8_MXPA1 ECK neck VDD VDD pm1p2_svt_lp L=6e-08 W=4.15e-07
.ENDS

.SUBCKT PREICGX0P8H9R ECK VDD VSS CK E SE
MI78_MXNA2 ne SE VSS VSS nm1p2_svt_lp L=6e-08 W=2.7e-07
MI78_MXNA1 ne E VSS VSS nm1p2_svt_lp L=6e-08 W=2.7e-07
MI20_MXNOE nm nck ne VSS nm1p2_svt_lp L=6e-08 W=2.7e-07
MI29_MXNOE nm CK XI29_n1 VSS nm1p2_svt_lp L=6e-08 W=1.5e-07
MI29_MXNA1 XI29_n1 m VSS VSS nm1p2_svt_lp L=6e-08 W=1.5e-07
MI74_MXNA1 m nm VSS VSS nm1p2_svt_lp L=6e-08 W=1.6e-07
MXN1 n1 m VSS VSS nm1p2_svt_lp L=6e-08 W=1.5e-07
MXN0 neck CK n1 VSS nm1p2_svt_lp L=6e-08 W=1.5e-07
MI72_MXNA1 nck CK VSS VSS nm1p2_svt_lp L=6e-08 W=1.5e-07
MI8_MXNA1 ECK neck VSS VSS nm1p2_svt_lp L=6e-08 W=2e-07
MI78_MXPA2 XI78_p1 SE VDD VDD pm1p2_svt_lp L=6e-08 W=3.35e-07
MI78_MXPA2_2 XI78_p1 SE VDD VDD pm1p2_svt_lp L=6e-08 W=3.35e-07
MI78_MXPA1 ne E XI78_p1 VDD pm1p2_svt_lp L=6e-08 W=3.35e-07
MI20_MXPOEN nm CK ne VDD pm1p2_svt_lp L=6e-08 W=2.7e-07
MI29_MXPOEN nm nck XI29_p1 VDD pm1p2_svt_lp L=6e-08 W=1.5e-07
MI29_MXPA1 XI29_p1 m VDD VDD pm1p2_svt_lp L=6e-08 W=1.5e-07
MI74_MXPA1 m nm VDD VDD pm1p2_svt_lp L=6e-08 W=2.25e-07
MXP0 neck m VDD VDD pm1p2_svt_lp L=6e-08 W=1.5e-07
MXP1 neck CK VDD VDD pm1p2_svt_lp L=6e-08 W=2.5e-07
MI72_MXPA1 nck CK VDD VDD pm1p2_svt_lp L=6e-08 W=2.1e-07
MI8_MXPA1 ECK neck VDD VDD pm1p2_svt_lp L=6e-08 W=4.9e-07
.ENDS

.SUBCKT PREICGX1H9R ECK VDD VSS CK E SE
MI78_MXNA2 ne SE VSS VSS nm1p2_svt_lp L=6e-08 W=2.7e-07
MI78_MXNA1 ne E VSS VSS nm1p2_svt_lp L=6e-08 W=2.7e-07
MI20_MXNOE nm nck ne VSS nm1p2_svt_lp L=6e-08 W=2.7e-07
MI29_MXNOE nm CK XI29_n1 VSS nm1p2_svt_lp L=6e-08 W=1.5e-07
MI29_MXNA1 XI29_n1 m VSS VSS nm1p2_svt_lp L=6e-08 W=1.5e-07
MI74_MXNA1 m nm VSS VSS nm1p2_svt_lp L=6e-08 W=1.6e-07
MXN1 n1 m VSS VSS nm1p2_svt_lp L=6e-08 W=1.5e-07
MXN0 neck CK n1 VSS nm1p2_svt_lp L=6e-08 W=1.5e-07
MI72_MXNA1 nck CK VSS VSS nm1p2_svt_lp L=6e-08 W=1.5e-07
MI8_MXNA1 ECK neck VSS VSS nm1p2_svt_lp L=6e-08 W=2.35e-07
MI78_MXPA2 XI78_p1 SE VDD VDD pm1p2_svt_lp L=6e-08 W=3.35e-07
MI78_MXPA2_2 XI78_p1 SE VDD VDD pm1p2_svt_lp L=6e-08 W=3.35e-07
MI78_MXPA1 ne E XI78_p1 VDD pm1p2_svt_lp L=6e-08 W=3.35e-07
MI20_MXPOEN nm CK ne VDD pm1p2_svt_lp L=6e-08 W=2.7e-07
MI29_MXPOEN nm nck XI29_p1 VDD pm1p2_svt_lp L=6e-08 W=1.5e-07
MI29_MXPA1 XI29_p1 m VDD VDD pm1p2_svt_lp L=6e-08 W=1.5e-07
MI74_MXPA1 m nm VDD VDD pm1p2_svt_lp L=6e-08 W=2.25e-07
MXP0 neck m VDD VDD pm1p2_svt_lp L=6e-08 W=1.5e-07
MXP1 neck CK VDD VDD pm1p2_svt_lp L=6e-08 W=2.5e-07
MI72_MXPA1 nck CK VDD VDD pm1p2_svt_lp L=6e-08 W=2.1e-07
MI8_MXPA1 ECK neck VDD VDD pm1p2_svt_lp L=6e-08 W=5.85e-07
.ENDS

.SUBCKT PREICGX1P2H9R ECK VDD VSS CK E SE
MI78_MXNA2 ne SE VSS VSS nm1p2_svt_lp L=6e-08 W=2.8e-07
MI78_MXNA1 ne E VSS VSS nm1p2_svt_lp L=6e-08 W=2.8e-07
MI20_MXNOE nm nck ne VSS nm1p2_svt_lp L=6e-08 W=2.8e-07
MI29_MXNOE nm CK XI29_n1 VSS nm1p2_svt_lp L=6e-08 W=1.5e-07
MI29_MXNA1 XI29_n1 m VSS VSS nm1p2_svt_lp L=6e-08 W=1.5e-07
MI74_MXNA1 m nm VSS VSS nm1p2_svt_lp L=6e-08 W=1.6e-07
MXN1 n1 m VSS VSS nm1p2_svt_lp L=6e-08 W=1.8e-07
MXN0 neck CK n1 VSS nm1p2_svt_lp L=6e-08 W=1.8e-07
MI72_MXNA1 nck CK VSS VSS nm1p2_svt_lp L=6e-08 W=1.5e-07
MI8_MXNA1 ECK neck VSS VSS nm1p2_svt_lp L=6e-08 W=2.8e-07
MI78_MXPA2 XI78_p1 SE VDD VDD pm1p2_svt_lp L=6e-08 W=3.35e-07
MI78_MXPA2_2 XI78_p1 SE VDD VDD pm1p2_svt_lp L=6e-08 W=3.35e-07
MI78_MXPA1 ne E XI78_p1 VDD pm1p2_svt_lp L=6e-08 W=3.35e-07
MI20_MXPOEN nm CK ne VDD pm1p2_svt_lp L=6e-08 W=2.8e-07
MI29_MXPOEN nm nck XI29_p1 VDD pm1p2_svt_lp L=6e-08 W=1.5e-07
MI29_MXPA1 XI29_p1 m VDD VDD pm1p2_svt_lp L=6e-08 W=1.5e-07
MI74_MXPA1 m nm VDD VDD pm1p2_svt_lp L=6e-08 W=2.25e-07
MXP0 neck m VDD VDD pm1p2_svt_lp L=6e-08 W=1.5e-07
MXP1 neck CK VDD VDD pm1p2_svt_lp L=6e-08 W=2.9e-07
MI72_MXPA1 nck CK VDD VDD pm1p2_svt_lp L=6e-08 W=2.1e-07
MI8_MXPA1 ECK neck VDD VDD pm1p2_svt_lp L=6e-08 W=3.5e-07
MI8_MXPA1_2 ECK neck VDD VDD pm1p2_svt_lp L=6e-08 W=3.5e-07
.ENDS

.SUBCKT PREICGX1P4H9R ECK VDD VSS CK E SE
MI78_MXNA2 ne SE VSS VSS nm1p2_svt_lp L=6e-08 W=2.8e-07
MI78_MXNA1 ne E VSS VSS nm1p2_svt_lp L=6e-08 W=2.8e-07
MI20_MXNOE nm nck ne VSS nm1p2_svt_lp L=6e-08 W=2.8e-07
MI29_MXNOE nm CK XI29_n1 VSS nm1p2_svt_lp L=6e-08 W=1.5e-07
MI29_MXNA1 XI29_n1 m VSS VSS nm1p2_svt_lp L=6e-08 W=1.5e-07
MI74_MXNA1 m nm VSS VSS nm1p2_svt_lp L=6e-08 W=1.6e-07
MXN1 n1 m VSS VSS nm1p2_svt_lp L=6e-08 W=1.95e-07
MXN0 neck CK n1 VSS nm1p2_svt_lp L=6e-08 W=1.95e-07
MI72_MXNA1 nck CK VSS VSS nm1p2_svt_lp L=6e-08 W=1.5e-07
MI8_MXNA1 ECK neck VSS VSS nm1p2_svt_lp L=6e-08 W=3.3e-07
MI78_MXPA2 XI78_p1 SE VDD VDD pm1p2_svt_lp L=6e-08 W=3.35e-07
MI78_MXPA2_2 XI78_p1 SE VDD VDD pm1p2_svt_lp L=6e-08 W=3.35e-07
MI78_MXPA1 ne E XI78_p1 VDD pm1p2_svt_lp L=6e-08 W=3.35e-07
MI20_MXPOEN nm CK ne VDD pm1p2_svt_lp L=6e-08 W=2.8e-07
MI29_MXPOEN nm nck XI29_p1 VDD pm1p2_svt_lp L=6e-08 W=1.5e-07
MI29_MXPA1 XI29_p1 m VDD VDD pm1p2_svt_lp L=6e-08 W=1.5e-07
MI74_MXPA1 m nm VDD VDD pm1p2_svt_lp L=6e-08 W=2.25e-07
MXP0 neck m VDD VDD pm1p2_svt_lp L=6e-08 W=1.5e-07
MXP1 neck CK VDD VDD pm1p2_svt_lp L=6e-08 W=3.3e-07
MI72_MXPA1 nck CK VDD VDD pm1p2_svt_lp L=6e-08 W=2.1e-07
MI8_MXPA1 ECK neck VDD VDD pm1p2_svt_lp L=6e-08 W=4.15e-07
MI8_MXPA1_2 ECK neck VDD VDD pm1p2_svt_lp L=6e-08 W=4.15e-07
.ENDS

.SUBCKT PREICGX1P7H9R ECK VDD VSS CK E SE
MI78_MXNA2 ne SE VSS VSS nm1p2_svt_lp L=6e-08 W=2.8e-07
MI78_MXNA1 ne E VSS VSS nm1p2_svt_lp L=6e-08 W=2.8e-07
MI20_MXNOE nm nck ne VSS nm1p2_svt_lp L=6e-08 W=2.8e-07
MI29_MXNOE nm CK XI29_n1 VSS nm1p2_svt_lp L=6e-08 W=1.5e-07
MI29_MXNA1 XI29_n1 m VSS VSS nm1p2_svt_lp L=6e-08 W=1.5e-07
MI74_MXNA1 m nm VSS VSS nm1p2_svt_lp L=6e-08 W=1.65e-07
MXN1 n1 m VSS VSS nm1p2_svt_lp L=6e-08 W=2.2e-07
MXN0 neck CK n1 VSS nm1p2_svt_lp L=6e-08 W=2.2e-07
MI72_MXNA1 nck CK VSS VSS nm1p2_svt_lp L=6e-08 W=1.55e-07
MI8_MXNA1 ECK neck VSS VSS nm1p2_svt_lp L=6e-08 W=4e-07
MI78_MXPA2 XI78_p1 SE VDD VDD pm1p2_svt_lp L=6e-08 W=3.35e-07
MI78_MXPA2_2 XI78_p1 SE VDD VDD pm1p2_svt_lp L=6e-08 W=3.35e-07
MI78_MXPA1 ne E XI78_p1 VDD pm1p2_svt_lp L=6e-08 W=3.35e-07
MI20_MXPOEN nm CK ne VDD pm1p2_svt_lp L=6e-08 W=2.8e-07
MI29_MXPOEN nm nck XI29_p1 VDD pm1p2_svt_lp L=6e-08 W=1.5e-07
MI29_MXPA1 XI29_p1 m VDD VDD pm1p2_svt_lp L=6e-08 W=1.5e-07
MI74_MXPA1 m nm VDD VDD pm1p2_svt_lp L=6e-08 W=2.3e-07
MXP0 neck m VDD VDD pm1p2_svt_lp L=6e-08 W=1.5e-07
MXP1 neck CK VDD VDD pm1p2_svt_lp L=6e-08 W=3.5e-07
MI72_MXPA1 nck CK VDD VDD pm1p2_svt_lp L=6e-08 W=2.15e-07
MI8_MXPA1 ECK neck VDD VDD pm1p2_svt_lp L=6e-08 W=4.9e-07
MI8_MXPA1_2 ECK neck VDD VDD pm1p2_svt_lp L=6e-08 W=4.9e-07
.ENDS

.SUBCKT PREICGX2H9R ECK VDD VSS CK E SE
MI78_MXNA2 ne SE VSS VSS nm1p2_svt_lp L=6e-08 W=2.8e-07
MI78_MXNA1 ne E VSS VSS nm1p2_svt_lp L=6e-08 W=2.8e-07
MI20_MXNOE nm nck ne VSS nm1p2_svt_lp L=6e-08 W=2.8e-07
MI29_MXNOE nm CK XI29_n1 VSS nm1p2_svt_lp L=6e-08 W=1.5e-07
MI29_MXNA1 XI29_n1 m VSS VSS nm1p2_svt_lp L=6e-08 W=1.5e-07
MI74_MXNA1 m nm VSS VSS nm1p2_svt_lp L=6e-08 W=1.7e-07
MXN1 n1 m VSS VSS nm1p2_svt_lp L=6e-08 W=2.45e-07
MXN0 neck CK n1 VSS nm1p2_svt_lp L=6e-08 W=2.45e-07
MI72_MXNA1 nck CK VSS VSS nm1p2_svt_lp L=6e-08 W=1.6e-07
MI8_MXNA1 ECK neck VSS VSS nm1p2_svt_lp L=6e-08 W=4.7e-07
MI78_MXPA2 XI78_p1 SE VDD VDD pm1p2_svt_lp L=6e-08 W=3.35e-07
MI78_MXPA2_2 XI78_p1 SE VDD VDD pm1p2_svt_lp L=6e-08 W=3.35e-07
MI78_MXPA1 ne E XI78_p1 VDD pm1p2_svt_lp L=6e-08 W=3.35e-07
MI20_MXPOEN nm CK ne VDD pm1p2_svt_lp L=6e-08 W=2.8e-07
MI29_MXPOEN nm nck XI29_p1 VDD pm1p2_svt_lp L=6e-08 W=1.5e-07
MI29_MXPA1 XI29_p1 m VDD VDD pm1p2_svt_lp L=6e-08 W=1.5e-07
MI74_MXPA1 m nm VDD VDD pm1p2_svt_lp L=6e-08 W=2.4e-07
MXP0 neck m VDD VDD pm1p2_svt_lp L=6e-08 W=1.5e-07
MXP1 neck CK VDD VDD pm1p2_svt_lp L=6e-08 W=4.1e-07
MI72_MXPA1 nck CK VDD VDD pm1p2_svt_lp L=6e-08 W=2.25e-07
MI8_MXPA1 ECK neck VDD VDD pm1p2_svt_lp L=6e-08 W=5.85e-07
MI8_MXPA1_2 ECK neck VDD VDD pm1p2_svt_lp L=6e-08 W=5.85e-07
.ENDS

.SUBCKT PREICGX2P5H9R ECK VDD VSS CK E SE
MI78_MXNA2 ne SE VSS VSS nm1p2_svt_lp L=6e-08 W=2.85e-07
MI78_MXNA1 ne E VSS VSS nm1p2_svt_lp L=6e-08 W=2.85e-07
MI20_MXNOE nm nck ne VSS nm1p2_svt_lp L=6e-08 W=2.85e-07
MI29_MXNOE nm CK XI29_n1 VSS nm1p2_svt_lp L=6e-08 W=1.5e-07
MI29_MXNA1 XI29_n1 m VSS VSS nm1p2_svt_lp L=6e-08 W=1.5e-07
MI74_MXNA1 m nm VSS VSS nm1p2_svt_lp L=6e-08 W=1.75e-07
MXN1 n1 m VSS VSS nm1p2_svt_lp L=6e-08 W=3.4e-07
MXN0 neck CK n1 VSS nm1p2_svt_lp L=6e-08 W=3.4e-07
MI72_MXNA1 nck CK VSS VSS nm1p2_svt_lp L=6e-08 W=1.5e-07
MI8_MXNA1 ECK neck VSS VSS nm1p2_svt_lp L=6e-08 W=3e-07
MI8_MXNA1_2 ECK neck VSS VSS nm1p2_svt_lp L=6e-08 W=3e-07
MI78_MXPA2 XI78_p1 SE VDD VDD pm1p2_svt_lp L=6e-08 W=3.4e-07
MI78_MXPA2_2 XI78_p1 SE VDD VDD pm1p2_svt_lp L=6e-08 W=3.4e-07
MI78_MXPA1 ne E XI78_p1 VDD pm1p2_svt_lp L=6e-08 W=3.4e-07
MI20_MXPOEN nm CK ne VDD pm1p2_svt_lp L=6e-08 W=2.85e-07
MI29_MXPOEN nm nck XI29_p1 VDD pm1p2_svt_lp L=6e-08 W=1.5e-07
MI29_MXPA1 XI29_p1 m VDD VDD pm1p2_svt_lp L=6e-08 W=1.5e-07
MI74_MXPA1 m nm VDD VDD pm1p2_svt_lp L=6e-08 W=2.45e-07
MXP0 neck m VDD VDD pm1p2_svt_lp L=6e-08 W=1.5e-07
MXP1 neck CK VDD VDD pm1p2_svt_lp L=6e-08 W=5.45e-07
MI72_MXPA1 nck CK VDD VDD pm1p2_svt_lp L=6e-08 W=2.1e-07
MI8_MXPA1 ECK neck VDD VDD pm1p2_svt_lp L=6e-08 W=4.9e-07
MI8_MXPA1_2 ECK neck VDD VDD pm1p2_svt_lp L=6e-08 W=4.9e-07
MI8_MXPA1_3 ECK neck VDD VDD pm1p2_svt_lp L=6e-08 W=4.9e-07
.ENDS

.SUBCKT PREICGX3H9R ECK VDD VSS CK E SE
MI78_MXNA2 ne SE VSS VSS nm1p2_svt_lp L=6e-08 W=2.85e-07
MI78_MXNA1 ne E VSS VSS nm1p2_svt_lp L=6e-08 W=2.85e-07
MI20_MXNOE nm nck ne VSS nm1p2_svt_lp L=6e-08 W=2.85e-07
MI29_MXNOE nm CK XI29_n1 VSS nm1p2_svt_lp L=6e-08 W=1.5e-07
MI29_MXNA1 XI29_n1 m VSS VSS nm1p2_svt_lp L=6e-08 W=1.5e-07
MI74_MXNA1 m nm VSS VSS nm1p2_svt_lp L=6e-08 W=1.75e-07
MXN1 n1 m VSS VSS nm1p2_svt_lp L=6e-08 W=3.4e-07
MXN0 neck CK n1 VSS nm1p2_svt_lp L=6e-08 W=3.4e-07
MI72_MXNA1 nck CK VSS VSS nm1p2_svt_lp L=6e-08 W=1.6e-07
MI8_MXNA1 ECK neck VSS VSS nm1p2_svt_lp L=6e-08 W=2.35e-07
MI8_MXNA1_2 ECK neck VSS VSS nm1p2_svt_lp L=6e-08 W=2.35e-07
MI8_MXNA1_3 ECK neck VSS VSS nm1p2_svt_lp L=6e-08 W=2.35e-07
MI78_MXPA2 XI78_p1 SE VDD VDD pm1p2_svt_lp L=6e-08 W=3.4e-07
MI78_MXPA2_2 XI78_p1 SE VDD VDD pm1p2_svt_lp L=6e-08 W=3.4e-07
MI78_MXPA1 ne E XI78_p1 VDD pm1p2_svt_lp L=6e-08 W=3.4e-07
MI20_MXPOEN nm CK ne VDD pm1p2_svt_lp L=6e-08 W=2.85e-07
MI29_MXPOEN nm nck XI29_p1 VDD pm1p2_svt_lp L=6e-08 W=1.5e-07
MI29_MXPA1 XI29_p1 m VDD VDD pm1p2_svt_lp L=6e-08 W=1.5e-07
MI74_MXPA1 m nm VDD VDD pm1p2_svt_lp L=6e-08 W=2.45e-07
MXP0 neck m VDD VDD pm1p2_svt_lp L=6e-08 W=1.5e-07
MXP1 neck CK VDD VDD pm1p2_svt_lp L=6e-08 W=5.85e-07
MI72_MXPA1 nck CK VDD VDD pm1p2_svt_lp L=6e-08 W=2.25e-07
MI8_MXPA1 ECK neck VDD VDD pm1p2_svt_lp L=6e-08 W=5.85e-07
MI8_MXPA1_2 ECK neck VDD VDD pm1p2_svt_lp L=6e-08 W=5.85e-07
MI8_MXPA1_3 ECK neck VDD VDD pm1p2_svt_lp L=6e-08 W=5.85e-07
.ENDS

.SUBCKT PREICGX3P5H9R ECK VDD VSS CK E SE
MI78_MXNA2 ne SE VSS VSS nm1p2_svt_lp L=6e-08 W=2.9e-07
MI78_MXNA1 ne E VSS VSS nm1p2_svt_lp L=6e-08 W=2.9e-07
MI20_MXNOE nm nck ne VSS nm1p2_svt_lp L=6e-08 W=2.9e-07
MI29_MXNOE nm CK XI29_n1 VSS nm1p2_svt_lp L=6e-08 W=1.5e-07
MI29_MXNA1 XI29_n1 m VSS VSS nm1p2_svt_lp L=6e-08 W=1.5e-07
MI74_MXNA1 m nm VSS VSS nm1p2_svt_lp L=6e-08 W=1.85e-07
MI72_MXNA1 nck CK VSS VSS nm1p2_svt_lp L=6e-08 W=1.6e-07
MXN1 n1 m VSS VSS nm1p2_svt_lp L=6e-08 W=4.5e-07
MXN0 neck CK n1 VSS nm1p2_svt_lp L=6e-08 W=4.5e-07
MI8_MXNA1 ECK neck VSS VSS nm1p2_svt_lp L=6e-08 W=1.8e-07
MI8_MXNA1_2 ECK neck VSS VSS nm1p2_svt_lp L=6e-08 W=1.8e-07
MI8_MXNA1_3 ECK neck VSS VSS nm1p2_svt_lp L=6e-08 W=1.8e-07
MI8_MXNA1_4 ECK neck VSS VSS nm1p2_svt_lp L=6e-08 W=1.8e-07
MI78_MXPA2 XI78_p1 SE VDD VDD pm1p2_svt_lp L=6e-08 W=3.45e-07
MI78_MXPA2_2 XI78_p1 SE VDD VDD pm1p2_svt_lp L=6e-08 W=3.45e-07
MI78_MXPA1 ne E XI78_p1 VDD pm1p2_svt_lp L=6e-08 W=3.45e-07
MI20_MXPOEN nm CK ne VDD pm1p2_svt_lp L=6e-08 W=2.9e-07
MI29_MXPOEN nm nck XI29_p1 VDD pm1p2_svt_lp L=6e-08 W=1.5e-07
MI29_MXPA1 XI29_p1 m VDD VDD pm1p2_svt_lp L=6e-08 W=1.5e-07
MI74_MXPA1 m nm VDD VDD pm1p2_svt_lp L=6e-08 W=2.6e-07
MI72_MXPA1 nck CK VDD VDD pm1p2_svt_lp L=6e-08 W=2.25e-07
MXP0 neck m VDD VDD pm1p2_svt_lp L=6e-08 W=1.5e-07
MXP1 neck CK VDD VDD pm1p2_svt_lp L=6e-08 W=3.8e-07
MXP1_2 neck CK VDD VDD pm1p2_svt_lp L=6e-08 W=3.8e-07
MI8_MXPA1 ECK neck VDD VDD pm1p2_svt_lp L=6e-08 W=5.1e-07
MI8_MXPA1_2 ECK neck VDD VDD pm1p2_svt_lp L=6e-08 W=5.1e-07
MI8_MXPA1_3 ECK neck VDD VDD pm1p2_svt_lp L=6e-08 W=5.1e-07
MI8_MXPA1_4 ECK neck VDD VDD pm1p2_svt_lp L=6e-08 W=5.1e-07
.ENDS

.SUBCKT PREICGX4H9R ECK VDD VSS CK E SE
MI78_MXNA2 ne SE VSS VSS nm1p2_svt_lp L=6e-08 W=2.9e-07
MI78_MXNA1 ne E VSS VSS nm1p2_svt_lp L=6e-08 W=2.9e-07
MI20_MXNOE nm nck ne VSS nm1p2_svt_lp L=6e-08 W=2.9e-07
MI29_MXNOE nm CK XI29_n1 VSS nm1p2_svt_lp L=6e-08 W=1.5e-07
MI29_MXNA1 XI29_n1 m VSS VSS nm1p2_svt_lp L=6e-08 W=1.5e-07
MI74_MXNA1 m nm VSS VSS nm1p2_svt_lp L=6e-08 W=1.85e-07
MI72_MXNA1 nck CK VSS VSS nm1p2_svt_lp L=6e-08 W=1.6e-07
MXN1 n1 m VSS VSS nm1p2_svt_lp L=6e-08 W=4.9e-07
MXN0 neck CK n1 VSS nm1p2_svt_lp L=6e-08 W=4.9e-07
MI8_MXNA1 ECK neck VSS VSS nm1p2_svt_lp L=6e-08 W=2.1e-07
MI8_MXNA1_2 ECK neck VSS VSS nm1p2_svt_lp L=6e-08 W=2.1e-07
MI8_MXNA1_3 ECK neck VSS VSS nm1p2_svt_lp L=6e-08 W=2.1e-07
MI8_MXNA1_4 ECK neck VSS VSS nm1p2_svt_lp L=6e-08 W=2.1e-07
MI78_MXPA2 XI78_p1 SE VDD VDD pm1p2_svt_lp L=6e-08 W=3.45e-07
MI78_MXPA2_2 XI78_p1 SE VDD VDD pm1p2_svt_lp L=6e-08 W=3.45e-07
MI78_MXPA1 ne E XI78_p1 VDD pm1p2_svt_lp L=6e-08 W=3.45e-07
MI20_MXPOEN nm CK ne VDD pm1p2_svt_lp L=6e-08 W=2.9e-07
MI29_MXPOEN nm nck XI29_p1 VDD pm1p2_svt_lp L=6e-08 W=1.5e-07
MI29_MXPA1 XI29_p1 m VDD VDD pm1p2_svt_lp L=6e-08 W=1.5e-07
MI74_MXPA1 m nm VDD VDD pm1p2_svt_lp L=6e-08 W=2.6e-07
MI72_MXPA1 nck CK VDD VDD pm1p2_svt_lp L=6e-08 W=2.25e-07
MXP0 neck m VDD VDD pm1p2_svt_lp L=6e-08 W=1.5e-07
MXP1 neck CK VDD VDD pm1p2_svt_lp L=6e-08 W=4.2e-07
MXP1_2 neck CK VDD VDD pm1p2_svt_lp L=6e-08 W=4.2e-07
MI8_MXPA1 ECK neck VDD VDD pm1p2_svt_lp L=6e-08 W=5.85e-07
MI8_MXPA1_2 ECK neck VDD VDD pm1p2_svt_lp L=6e-08 W=5.85e-07
MI8_MXPA1_3 ECK neck VDD VDD pm1p2_svt_lp L=6e-08 W=5.85e-07
MI8_MXPA1_4 ECK neck VDD VDD pm1p2_svt_lp L=6e-08 W=5.85e-07
.ENDS

.SUBCKT PREICGX5H9R ECK VDD VSS CK E SE
MI78_MXNA2 ne SE VSS VSS nm1p2_svt_lp L=6e-08 W=2.9e-07
MI78_MXNA1 ne E VSS VSS nm1p2_svt_lp L=6e-08 W=2.9e-07
MI20_MXNOE nm nck ne VSS nm1p2_svt_lp L=6e-08 W=2.9e-07
MI29_MXNOE nm CK XI29_n1 VSS nm1p2_svt_lp L=6e-08 W=1.5e-07
MI29_MXNA1 XI29_n1 m VSS VSS nm1p2_svt_lp L=6e-08 W=1.5e-07
MI74_MXNA1 m nm VSS VSS nm1p2_svt_lp L=6e-08 W=2.15e-07
MI72_MXNA1 nck CK VSS VSS nm1p2_svt_lp L=6e-08 W=1.6e-07
MXN1_2 n1__2 m VSS VSS nm1p2_svt_lp L=6e-08 W=3.15e-07
MXN0_2 neck CK n1__2 VSS nm1p2_svt_lp L=6e-08 W=3.15e-07
MXN0 neck CK n1 VSS nm1p2_svt_lp L=6e-08 W=3.15e-07
MXN1 n1 m VSS VSS nm1p2_svt_lp L=6e-08 W=3.15e-07
MI8_MXNA1 ECK neck VSS VSS nm1p2_svt_lp L=6e-08 W=3.95e-07
MI8_MXNA1_2 ECK neck VSS VSS nm1p2_svt_lp L=6e-08 W=3.95e-07
MI8_MXNA1_3 ECK neck VSS VSS nm1p2_svt_lp L=6e-08 W=3.95e-07
MI78_MXPA2 XI78_p1 SE VDD VDD pm1p2_svt_lp L=6e-08 W=3.5e-07
MI78_MXPA2_2 XI78_p1 SE VDD VDD pm1p2_svt_lp L=6e-08 W=3.5e-07
MI78_MXPA1 ne E XI78_p1 VDD pm1p2_svt_lp L=6e-08 W=3.5e-07
MI20_MXPOEN nm CK ne VDD pm1p2_svt_lp L=6e-08 W=2.9e-07
MI29_MXPOEN nm nck XI29_p1 VDD pm1p2_svt_lp L=6e-08 W=1.5e-07
MI29_MXPA1 XI29_p1 m VDD VDD pm1p2_svt_lp L=6e-08 W=1.5e-07
MI74_MXPA1 m nm VDD VDD pm1p2_svt_lp L=6e-08 W=3e-07
MI72_MXPA1 nck CK VDD VDD pm1p2_svt_lp L=6e-08 W=2.25e-07
MXP0 neck m VDD VDD pm1p2_svt_lp L=6e-08 W=1.5e-07
MXP1 neck CK VDD VDD pm1p2_svt_lp L=6e-08 W=5.8e-07
MXP1_2 neck CK VDD VDD pm1p2_svt_lp L=6e-08 W=5.8e-07
MI8_MXPA1 ECK neck VDD VDD pm1p2_svt_lp L=6e-08 W=5.85e-07
MI8_MXPA1_2 ECK neck VDD VDD pm1p2_svt_lp L=6e-08 W=5.85e-07
MI8_MXPA1_3 ECK neck VDD VDD pm1p2_svt_lp L=6e-08 W=5.85e-07
MI8_MXPA1_4 ECK neck VDD VDD pm1p2_svt_lp L=6e-08 W=5.85e-07
MI8_MXPA1_5 ECK neck VDD VDD pm1p2_svt_lp L=6e-08 W=5.85e-07
.ENDS

.SUBCKT PREICGX6H9R ECK VDD VSS CK E SE
MI78_MXNA2 ne SE VSS VSS nm1p2_svt_lp L=6e-08 W=3.05e-07
MI78_MXNA1 ne E VSS VSS nm1p2_svt_lp L=6e-08 W=3.05e-07
MI20_MXNOE nm nck ne VSS nm1p2_svt_lp L=6e-08 W=3.05e-07
MI29_MXNOE nm CK XI29_n1 VSS nm1p2_svt_lp L=6e-08 W=1.5e-07
MI29_MXNA1 XI29_n1 m VSS VSS nm1p2_svt_lp L=6e-08 W=1.5e-07
MI74_MXNA1 m nm VSS VSS nm1p2_svt_lp L=6e-08 W=2.3e-07
MI72_MXNA1 nck CK VSS VSS nm1p2_svt_lp L=6e-08 W=1.6e-07
MXN1_2 n1__2 m VSS VSS nm1p2_svt_lp L=6e-08 W=3.7e-07
MXN0_2 neck CK n1__2 VSS nm1p2_svt_lp L=6e-08 W=3.7e-07
MXN0 neck CK n1 VSS nm1p2_svt_lp L=6e-08 W=3.7e-07
MXN1 n1 m VSS VSS nm1p2_svt_lp L=6e-08 W=3.7e-07
MI8_MXNA1 ECK neck VSS VSS nm1p2_svt_lp L=6e-08 W=2.35e-07
MI8_MXNA1_2 ECK neck VSS VSS nm1p2_svt_lp L=6e-08 W=2.35e-07
MI8_MXNA1_3 ECK neck VSS VSS nm1p2_svt_lp L=6e-08 W=2.35e-07
MI8_MXNA1_4 ECK neck VSS VSS nm1p2_svt_lp L=6e-08 W=2.35e-07
MI8_MXNA1_5 ECK neck VSS VSS nm1p2_svt_lp L=6e-08 W=2.35e-07
MI8_MXNA1_6 ECK neck VSS VSS nm1p2_svt_lp L=6e-08 W=2.35e-07
MI78_MXPA2 XI78_p1 SE VDD VDD pm1p2_svt_lp L=6e-08 W=3.65e-07
MI78_MXPA2_2 XI78_p1 SE VDD VDD pm1p2_svt_lp L=6e-08 W=3.65e-07
MI78_MXPA1 ne E XI78_p1 VDD pm1p2_svt_lp L=6e-08 W=3.65e-07
MI20_MXPOEN nm CK ne VDD pm1p2_svt_lp L=6e-08 W=3.05e-07
MI29_MXPOEN nm nck XI29_p1 VDD pm1p2_svt_lp L=6e-08 W=1.5e-07
MI29_MXPA1 XI29_p1 m VDD VDD pm1p2_svt_lp L=6e-08 W=1.5e-07
MI74_MXPA1 m nm VDD VDD pm1p2_svt_lp L=6e-08 W=3.2e-07
MI72_MXPA1 nck CK VDD VDD pm1p2_svt_lp L=6e-08 W=2.25e-07
MXP0 neck m VDD VDD pm1p2_svt_lp L=6e-08 W=1.5e-07
MXP1 neck CK VDD VDD pm1p2_svt_lp L=6e-08 W=6.6e-07
MXP1_2 neck CK VDD VDD pm1p2_svt_lp L=6e-08 W=6.6e-07
MI8_MXPA1 ECK neck VDD VDD pm1p2_svt_lp L=6e-08 W=5.85e-07
MI8_MXPA1_2 ECK neck VDD VDD pm1p2_svt_lp L=6e-08 W=5.85e-07
MI8_MXPA1_3 ECK neck VDD VDD pm1p2_svt_lp L=6e-08 W=5.85e-07
MI8_MXPA1_4 ECK neck VDD VDD pm1p2_svt_lp L=6e-08 W=5.85e-07
MI8_MXPA1_5 ECK neck VDD VDD pm1p2_svt_lp L=6e-08 W=5.85e-07
MI8_MXPA1_6 ECK neck VDD VDD pm1p2_svt_lp L=6e-08 W=5.85e-07
.ENDS

.SUBCKT PREICGX7P5H9R ECK VDD VSS CK E SE
MI78_MXNA2 ne SE VSS VSS nm1p2_svt_lp L=6e-08 W=3.15e-07
MI78_MXNA1 ne E VSS VSS nm1p2_svt_lp L=6e-08 W=3.15e-07
MI20_MXNOE nm nck ne VSS nm1p2_svt_lp L=6e-08 W=3.15e-07
MI29_MXNOE nm CK XI29_n1 VSS nm1p2_svt_lp L=6e-08 W=1.5e-07
MI29_MXNA1 XI29_n1 m VSS VSS nm1p2_svt_lp L=6e-08 W=1.5e-07
MI74_MXNA1 m nm VSS VSS nm1p2_svt_lp L=6e-08 W=2.6e-07
MI72_MXNA1 nck CK VSS VSS nm1p2_svt_lp L=6e-08 W=1.6e-07
MXN1_2 n1__2 m VSS VSS nm1p2_svt_lp L=6e-08 W=3.15e-07
MXN0_2 neck CK n1__2 VSS nm1p2_svt_lp L=6e-08 W=3.15e-07
MXN0_3 neck CK n1__3 VSS nm1p2_svt_lp L=6e-08 W=3.15e-07
MXN1_3 n1__3 m VSS VSS nm1p2_svt_lp L=6e-08 W=3.15e-07
MXN1 n1 m VSS VSS nm1p2_svt_lp L=6e-08 W=3.15e-07
MXN0 neck CK n1 VSS nm1p2_svt_lp L=6e-08 W=3.15e-07
MI8_MXNA1 ECK neck VSS VSS nm1p2_svt_lp L=6e-08 W=4.4e-07
MI8_MXNA1_2 ECK neck VSS VSS nm1p2_svt_lp L=6e-08 W=4.4e-07
MI8_MXNA1_3 ECK neck VSS VSS nm1p2_svt_lp L=6e-08 W=4.4e-07
MI8_MXNA1_4 ECK neck VSS VSS nm1p2_svt_lp L=6e-08 W=4.4e-07
MI78_MXPA2 XI78_p1 SE VDD VDD pm1p2_svt_lp L=6e-08 W=3.75e-07
MI78_MXPA2_2 XI78_p1 SE VDD VDD pm1p2_svt_lp L=6e-08 W=3.75e-07
MI78_MXPA1 ne E XI78_p1 VDD pm1p2_svt_lp L=6e-08 W=3.75e-07
MI20_MXPOEN nm CK ne VDD pm1p2_svt_lp L=6e-08 W=3.15e-07
MI29_MXPOEN nm nck XI29_p1 VDD pm1p2_svt_lp L=6e-08 W=1.5e-07
MI29_MXPA1 XI29_p1 m VDD VDD pm1p2_svt_lp L=6e-08 W=1.5e-07
MI74_MXPA1 m nm VDD VDD pm1p2_svt_lp L=6e-08 W=3.65e-07
MI72_MXPA1 nck CK VDD VDD pm1p2_svt_lp L=6e-08 W=2.25e-07
MXP0 neck m VDD VDD pm1p2_svt_lp L=6e-08 W=1.65e-07
MXP1 neck CK VDD VDD pm1p2_svt_lp L=6e-08 W=5.6e-07
MXP1_2 neck CK VDD VDD pm1p2_svt_lp L=6e-08 W=5.6e-07
MXP1_3 neck CK VDD VDD pm1p2_svt_lp L=6e-08 W=5.6e-07
MI8_MXPA1 ECK neck VDD VDD pm1p2_svt_lp L=6e-08 W=5.5e-07
MI8_MXPA1_2 ECK neck VDD VDD pm1p2_svt_lp L=6e-08 W=5.5e-07
MI8_MXPA1_3 ECK neck VDD VDD pm1p2_svt_lp L=6e-08 W=5.5e-07
MI8_MXPA1_4 ECK neck VDD VDD pm1p2_svt_lp L=6e-08 W=5.5e-07
MI8_MXPA1_5 ECK neck VDD VDD pm1p2_svt_lp L=6e-08 W=5.5e-07
MI8_MXPA1_6 ECK neck VDD VDD pm1p2_svt_lp L=6e-08 W=5.5e-07
MI8_MXPA1_7 ECK neck VDD VDD pm1p2_svt_lp L=6e-08 W=5.5e-07
MI8_MXPA1_8 ECK neck VDD VDD pm1p2_svt_lp L=6e-08 W=5.5e-07
.ENDS

.SUBCKT PREICGX9H9R ECK VDD VSS CK E SE
MI78_MXNA2 ne SE VSS VSS nm1p2_svt_lp L=6e-08 W=3.65e-07
MI78_MXNA1 ne E VSS VSS nm1p2_svt_lp L=6e-08 W=3.65e-07
MI20_MXNOE nm nck ne VSS nm1p2_svt_lp L=6e-08 W=3.65e-07
MI29_MXNOE nm CK XI29_n1 VSS nm1p2_svt_lp L=6e-08 W=1.5e-07
MI29_MXNA1 XI29_n1 m VSS VSS nm1p2_svt_lp L=6e-08 W=1.5e-07
MI74_MXNA1 m nm VSS VSS nm1p2_svt_lp L=6e-08 W=2.75e-07
MI72_MXNA1 nck CK VSS VSS nm1p2_svt_lp L=6e-08 W=1.65e-07
MXN1_2 n1__2 m VSS VSS nm1p2_svt_lp L=6e-08 W=3.7e-07
MXN0_2 neck CK n1__2 VSS nm1p2_svt_lp L=6e-08 W=3.7e-07
MXN0_3 neck CK n1__3 VSS nm1p2_svt_lp L=6e-08 W=3.7e-07
MXN1_3 n1__3 m VSS VSS nm1p2_svt_lp L=6e-08 W=3.7e-07
MXN1 n1 m VSS VSS nm1p2_svt_lp L=6e-08 W=3.7e-07
MXN0 neck CK n1 VSS nm1p2_svt_lp L=6e-08 W=3.7e-07
MI8_MXNA1 ECK neck VSS VSS nm1p2_svt_lp L=6e-08 W=2.65e-07
MI8_MXNA1_2 ECK neck VSS VSS nm1p2_svt_lp L=6e-08 W=2.65e-07
MI8_MXNA1_3 ECK neck VSS VSS nm1p2_svt_lp L=6e-08 W=2.65e-07
MI8_MXNA1_4 ECK neck VSS VSS nm1p2_svt_lp L=6e-08 W=2.65e-07
MI8_MXNA1_5 ECK neck VSS VSS nm1p2_svt_lp L=6e-08 W=2.65e-07
MI8_MXNA1_6 ECK neck VSS VSS nm1p2_svt_lp L=6e-08 W=2.65e-07
MI8_MXNA1_7 ECK neck VSS VSS nm1p2_svt_lp L=6e-08 W=2.65e-07
MI8_MXNA1_8 ECK neck VSS VSS nm1p2_svt_lp L=6e-08 W=2.65e-07
MI78_MXPA2 XI78_p1 SE VDD VDD pm1p2_svt_lp L=6e-08 W=4.35e-07
MI78_MXPA2_2 XI78_p1 SE VDD VDD pm1p2_svt_lp L=6e-08 W=4.35e-07
MI78_MXPA1 ne E XI78_p1 VDD pm1p2_svt_lp L=6e-08 W=4.35e-07
MI20_MXPOEN nm CK ne VDD pm1p2_svt_lp L=6e-08 W=3.65e-07
MI29_MXPOEN nm nck XI29_p1 VDD pm1p2_svt_lp L=6e-08 W=1.5e-07
MI29_MXPA1 XI29_p1 m VDD VDD pm1p2_svt_lp L=6e-08 W=1.5e-07
MI74_MXPA1 m nm VDD VDD pm1p2_svt_lp L=6e-08 W=3.85e-07
MI72_MXPA1 nck CK VDD VDD pm1p2_svt_lp L=6e-08 W=2.3e-07
MXP0 neck m VDD VDD pm1p2_svt_lp L=6e-08 W=2e-07
MXP1 neck CK VDD VDD pm1p2_svt_lp L=6e-08 W=4.95e-07
MXP1_2 neck CK VDD VDD pm1p2_svt_lp L=6e-08 W=4.95e-07
MXP1_3 neck CK VDD VDD pm1p2_svt_lp L=6e-08 W=4.95e-07
MXP1_4 neck CK VDD VDD pm1p2_svt_lp L=6e-08 W=4.95e-07
MI8_MXPA1 ECK neck VDD VDD pm1p2_svt_lp L=6e-08 W=5.85e-07
MI8_MXPA1_2 ECK neck VDD VDD pm1p2_svt_lp L=6e-08 W=5.85e-07
MI8_MXPA1_3 ECK neck VDD VDD pm1p2_svt_lp L=6e-08 W=5.85e-07
MI8_MXPA1_4 ECK neck VDD VDD pm1p2_svt_lp L=6e-08 W=5.85e-07
MI8_MXPA1_5 ECK neck VDD VDD pm1p2_svt_lp L=6e-08 W=5.85e-07
MI8_MXPA1_6 ECK neck VDD VDD pm1p2_svt_lp L=6e-08 W=5.85e-07
MI8_MXPA1_7 ECK neck VDD VDD pm1p2_svt_lp L=6e-08 W=5.85e-07
MI8_MXPA1_8 ECK neck VDD VDD pm1p2_svt_lp L=6e-08 W=5.85e-07
MI8_MXPA1_9 ECK neck VDD VDD pm1p2_svt_lp L=6e-08 W=5.85e-07
.ENDS

.SUBCKT PREICGX11H9R ECK VDD VSS CK E SE
MI78_MXNA2 ne SE VSS VSS nm1p2_svt_lp L=6e-08 W=3.8e-07
MI78_MXNA1 ne E VSS VSS nm1p2_svt_lp L=6e-08 W=3.8e-07
MI20_MXNOE nm nck ne VSS nm1p2_svt_lp L=6e-08 W=3.8e-07
MI29_MXNOE nm CK XI29_n1 VSS nm1p2_svt_lp L=6e-08 W=1.5e-07
MI29_MXNA1 XI29_n1 m VSS VSS nm1p2_svt_lp L=6e-08 W=1.5e-07
MI74_MXNA1 m nm VSS VSS nm1p2_svt_lp L=6e-08 W=3.4e-07
MI72_MXNA1 nck CK VSS VSS nm1p2_svt_lp L=6e-08 W=1.65e-07
MXN1_2 n1__2 m VSS VSS nm1p2_svt_lp L=6e-08 W=4.5e-07
MXN0_2 neck CK n1__2 VSS nm1p2_svt_lp L=6e-08 W=4.5e-07
MXN0_3 neck CK n1__3 VSS nm1p2_svt_lp L=6e-08 W=4.5e-07
MXN1_3 n1__3 m VSS VSS nm1p2_svt_lp L=6e-08 W=4.5e-07
MXN1 n1 m VSS VSS nm1p2_svt_lp L=6e-08 W=4.5e-07
MXN0 neck CK n1 VSS nm1p2_svt_lp L=6e-08 W=4.5e-07
MI8_MXNA1 ECK neck VSS VSS nm1p2_svt_lp L=6e-08 W=3.7e-07
MI8_MXNA1_2 ECK neck VSS VSS nm1p2_svt_lp L=6e-08 W=3.7e-07
MI8_MXNA1_3 ECK neck VSS VSS nm1p2_svt_lp L=6e-08 W=3.7e-07
MI8_MXNA1_4 ECK neck VSS VSS nm1p2_svt_lp L=6e-08 W=3.7e-07
MI8_MXNA1_5 ECK neck VSS VSS nm1p2_svt_lp L=6e-08 W=3.7e-07
MI8_MXNA1_6 ECK neck VSS VSS nm1p2_svt_lp L=6e-08 W=3.7e-07
MI8_MXNA1_7 ECK neck VSS VSS nm1p2_svt_lp L=6e-08 W=3.7e-07
MI78_MXPA2 XI78_p1 SE VDD VDD pm1p2_svt_lp L=6e-08 W=4.5e-07
MI78_MXPA2_2 XI78_p1 SE VDD VDD pm1p2_svt_lp L=6e-08 W=4.5e-07
MI78_MXPA1 ne E XI78_p1 VDD pm1p2_svt_lp L=6e-08 W=4.5e-07
MI20_MXPOEN nm CK ne VDD pm1p2_svt_lp L=6e-08 W=3.8e-07
MI29_MXPOEN nm nck XI29_p1 VDD pm1p2_svt_lp L=6e-08 W=1.5e-07
MI29_MXPA1 XI29_p1 m VDD VDD pm1p2_svt_lp L=6e-08 W=1.5e-07
MI74_MXPA1 m nm VDD VDD pm1p2_svt_lp L=6e-08 W=4.75e-07
MI72_MXPA1 nck CK VDD VDD pm1p2_svt_lp L=6e-08 W=2.3e-07
MXP0 neck m VDD VDD pm1p2_svt_lp L=6e-08 W=2.35e-07
MXP1 neck CK VDD VDD pm1p2_svt_lp L=6e-08 W=5.85e-07
MXP1_2 neck CK VDD VDD pm1p2_svt_lp L=6e-08 W=5.85e-07
MXP1_3 neck CK VDD VDD pm1p2_svt_lp L=6e-08 W=5.85e-07
MXP1_4 neck CK VDD VDD pm1p2_svt_lp L=6e-08 W=5.85e-07
MI8_MXPA1 ECK neck VDD VDD pm1p2_svt_lp L=6e-08 W=5.85e-07
MI8_MXPA1_2 ECK neck VDD VDD pm1p2_svt_lp L=6e-08 W=5.85e-07
MI8_MXPA1_3 ECK neck VDD VDD pm1p2_svt_lp L=6e-08 W=5.85e-07
MI8_MXPA1_4 ECK neck VDD VDD pm1p2_svt_lp L=6e-08 W=5.85e-07
MI8_MXPA1_5 ECK neck VDD VDD pm1p2_svt_lp L=6e-08 W=5.85e-07
MI8_MXPA1_6 ECK neck VDD VDD pm1p2_svt_lp L=6e-08 W=5.85e-07
MI8_MXPA1_7 ECK neck VDD VDD pm1p2_svt_lp L=6e-08 W=5.85e-07
MI8_MXPA1_8 ECK neck VDD VDD pm1p2_svt_lp L=6e-08 W=5.85e-07
MI8_MXPA1_9 ECK neck VDD VDD pm1p2_svt_lp L=6e-08 W=5.85e-07
MI8_MXPA1_10 ECK neck VDD VDD pm1p2_svt_lp L=6e-08 W=5.85e-07
MI8_MXPA1_11 ECK neck VDD VDD pm1p2_svt_lp L=6e-08 W=5.85e-07
.ENDS

.SUBCKT PREICGX13H9R ECK VDD VSS CK E SE
MI78_MXNA2 ne SE VSS VSS nm1p2_svt_lp L=6e-08 W=3.9e-07
MI78_MXNA1 ne E VSS VSS nm1p2_svt_lp L=6e-08 W=3.9e-07
MI20_MXNOE nm nck ne VSS nm1p2_svt_lp L=6e-08 W=3.9e-07
MI29_MXNOE nm CK XI29_n1 VSS nm1p2_svt_lp L=6e-08 W=1.5e-07
MI29_MXNA1 XI29_n1 m VSS VSS nm1p2_svt_lp L=6e-08 W=1.5e-07
MI74_MXNA1 m nm VSS VSS nm1p2_svt_lp L=6e-08 W=3.65e-07
MI72_MXNA1 nck CK VSS VSS nm1p2_svt_lp L=6e-08 W=1.7e-07
MXN1_2 n1__2 m VSS VSS nm1p2_svt_lp L=6e-08 W=4e-07
MXN0_2 neck CK n1__2 VSS nm1p2_svt_lp L=6e-08 W=4e-07
MXN0_3 neck CK n1__3 VSS nm1p2_svt_lp L=6e-08 W=4e-07
MXN1_3 n1__3 m VSS VSS nm1p2_svt_lp L=6e-08 W=4e-07
MXN1_4 n1__4 m VSS VSS nm1p2_svt_lp L=6e-08 W=4e-07
MXN0_4 neck CK n1__4 VSS nm1p2_svt_lp L=6e-08 W=4e-07
MXN0 neck CK n1 VSS nm1p2_svt_lp L=6e-08 W=4e-07
MXN1 n1 m VSS VSS nm1p2_svt_lp L=6e-08 W=4e-07
MI8_MXNA1 ECK neck VSS VSS nm1p2_svt_lp L=6e-08 W=2.35e-07
MI8_MXNA1_2 ECK neck VSS VSS nm1p2_svt_lp L=6e-08 W=2.35e-07
MI8_MXNA1_3 ECK neck VSS VSS nm1p2_svt_lp L=6e-08 W=2.35e-07
MI8_MXNA1_4 ECK neck VSS VSS nm1p2_svt_lp L=6e-08 W=2.35e-07
MI8_MXNA1_5 ECK neck VSS VSS nm1p2_svt_lp L=6e-08 W=2.35e-07
MI8_MXNA1_6 ECK neck VSS VSS nm1p2_svt_lp L=6e-08 W=2.35e-07
MI8_MXNA1_7 ECK neck VSS VSS nm1p2_svt_lp L=6e-08 W=2.35e-07
MI8_MXNA1_8 ECK neck VSS VSS nm1p2_svt_lp L=6e-08 W=2.35e-07
MI8_MXNA1_9 ECK neck VSS VSS nm1p2_svt_lp L=6e-08 W=2.35e-07
MI8_MXNA1_10 ECK neck VSS VSS nm1p2_svt_lp L=6e-08 W=2.35e-07
MI8_MXNA1_11 ECK neck VSS VSS nm1p2_svt_lp L=6e-08 W=2.35e-07
MI8_MXNA1_12 ECK neck VSS VSS nm1p2_svt_lp L=6e-08 W=2.35e-07
MI8_MXNA1_13 ECK neck VSS VSS nm1p2_svt_lp L=6e-08 W=2.35e-07
MI78_MXPA2 XI78_p1 SE VDD VDD pm1p2_svt_lp L=6e-08 W=4.65e-07
MI78_MXPA2_2 XI78_p1 SE VDD VDD pm1p2_svt_lp L=6e-08 W=4.65e-07
MI78_MXPA1 ne E XI78_p1 VDD pm1p2_svt_lp L=6e-08 W=4.65e-07
MI20_MXPOEN nm CK ne VDD pm1p2_svt_lp L=6e-08 W=3.9e-07
MI29_MXPOEN nm nck XI29_p1 VDD pm1p2_svt_lp L=6e-08 W=1.5e-07
MI29_MXPA1 XI29_p1 m VDD VDD pm1p2_svt_lp L=6e-08 W=1.5e-07
MI74_MXPA1 m nm VDD VDD pm1p2_svt_lp L=6e-08 W=5.1e-07
MI72_MXPA1 nck CK VDD VDD pm1p2_svt_lp L=6e-08 W=2.4e-07
MXP0 neck m VDD VDD pm1p2_svt_lp L=6e-08 W=2.65e-07
MXP1 neck CK VDD VDD pm1p2_svt_lp L=6e-08 W=5.35e-07
MXP1_2 neck CK VDD VDD pm1p2_svt_lp L=6e-08 W=5.35e-07
MXP1_3 neck CK VDD VDD pm1p2_svt_lp L=6e-08 W=5.35e-07
MXP1_4 neck CK VDD VDD pm1p2_svt_lp L=6e-08 W=5.35e-07
MXP1_5 neck CK VDD VDD pm1p2_svt_lp L=6e-08 W=5.35e-07
MI8_MXPA1 ECK neck VDD VDD pm1p2_svt_lp L=6e-08 W=5.85e-07
MI8_MXPA1_2 ECK neck VDD VDD pm1p2_svt_lp L=6e-08 W=5.85e-07
MI8_MXPA1_3 ECK neck VDD VDD pm1p2_svt_lp L=6e-08 W=5.85e-07
MI8_MXPA1_4 ECK neck VDD VDD pm1p2_svt_lp L=6e-08 W=5.85e-07
MI8_MXPA1_5 ECK neck VDD VDD pm1p2_svt_lp L=6e-08 W=5.85e-07
MI8_MXPA1_6 ECK neck VDD VDD pm1p2_svt_lp L=6e-08 W=5.85e-07
MI8_MXPA1_7 ECK neck VDD VDD pm1p2_svt_lp L=6e-08 W=5.85e-07
MI8_MXPA1_8 ECK neck VDD VDD pm1p2_svt_lp L=6e-08 W=5.85e-07
MI8_MXPA1_9 ECK neck VDD VDD pm1p2_svt_lp L=6e-08 W=5.85e-07
MI8_MXPA1_10 ECK neck VDD VDD pm1p2_svt_lp L=6e-08 W=5.85e-07
MI8_MXPA1_11 ECK neck VDD VDD pm1p2_svt_lp L=6e-08 W=5.85e-07
MI8_MXPA1_12 ECK neck VDD VDD pm1p2_svt_lp L=6e-08 W=5.85e-07
MI8_MXPA1_13 ECK neck VDD VDD pm1p2_svt_lp L=6e-08 W=5.85e-07
.ENDS

.SUBCKT PREICGX16H9R ECK VDD VSS CK E SE
MI78_MXNA2 ne SE VSS VSS nm1p2_svt_lp L=6e-08 W=4.4e-07
MI78_MXNA1 ne E VSS VSS nm1p2_svt_lp L=6e-08 W=4.4e-07
MI20_MXNOE nm nck ne VSS nm1p2_svt_lp L=6e-08 W=4.4e-07
MI29_MXNOE nm CK XI29_n1 VSS nm1p2_svt_lp L=6e-08 W=1.5e-07
MI29_MXNA1 XI29_n1 m VSS VSS nm1p2_svt_lp L=6e-08 W=1.5e-07
MI74_MXNA1 m nm VSS VSS nm1p2_svt_lp L=6e-08 W=4.05e-07
MI72_MXNA1 nck CK VSS VSS nm1p2_svt_lp L=6e-08 W=1.75e-07
MXN1_2 n1__2 m VSS VSS nm1p2_svt_lp L=6e-08 W=4.15e-07
MXN0_2 neck CK n1__2 VSS nm1p2_svt_lp L=6e-08 W=4.15e-07
MXN0_3 neck CK n1__3 VSS nm1p2_svt_lp L=6e-08 W=4.15e-07
MXN1_3 n1__3 m VSS VSS nm1p2_svt_lp L=6e-08 W=4.15e-07
MXN1_4 n1__4 m VSS VSS nm1p2_svt_lp L=6e-08 W=4.15e-07
MXN0_4 neck CK n1__4 VSS nm1p2_svt_lp L=6e-08 W=4.15e-07
MXN0 neck CK n1 VSS nm1p2_svt_lp L=6e-08 W=4.15e-07
MXN1 n1 m VSS VSS nm1p2_svt_lp L=6e-08 W=4.15e-07
MI8_MXNA1 ECK neck VSS VSS nm1p2_svt_lp L=6e-08 W=2.35e-07
MI8_MXNA1_2 ECK neck VSS VSS nm1p2_svt_lp L=6e-08 W=2.35e-07
MI8_MXNA1_3 ECK neck VSS VSS nm1p2_svt_lp L=6e-08 W=2.35e-07
MI8_MXNA1_4 ECK neck VSS VSS nm1p2_svt_lp L=6e-08 W=2.35e-07
MI8_MXNA1_5 ECK neck VSS VSS nm1p2_svt_lp L=6e-08 W=2.35e-07
MI8_MXNA1_6 ECK neck VSS VSS nm1p2_svt_lp L=6e-08 W=2.35e-07
MI8_MXNA1_7 ECK neck VSS VSS nm1p2_svt_lp L=6e-08 W=2.35e-07
MI8_MXNA1_8 ECK neck VSS VSS nm1p2_svt_lp L=6e-08 W=2.35e-07
MI8_MXNA1_9 ECK neck VSS VSS nm1p2_svt_lp L=6e-08 W=2.35e-07
MI8_MXNA1_10 ECK neck VSS VSS nm1p2_svt_lp L=6e-08 W=2.35e-07
MI8_MXNA1_11 ECK neck VSS VSS nm1p2_svt_lp L=6e-08 W=2.35e-07
MI8_MXNA1_12 ECK neck VSS VSS nm1p2_svt_lp L=6e-08 W=2.35e-07
MI8_MXNA1_13 ECK neck VSS VSS nm1p2_svt_lp L=6e-08 W=2.35e-07
MI8_MXNA1_14 ECK neck VSS VSS nm1p2_svt_lp L=6e-08 W=2.35e-07
MI8_MXNA1_15 ECK neck VSS VSS nm1p2_svt_lp L=6e-08 W=2.35e-07
MI8_MXNA1_16 ECK neck VSS VSS nm1p2_svt_lp L=6e-08 W=2.35e-07
MI78_MXPA2 XI78_p1 SE VDD VDD pm1p2_svt_lp L=6e-08 W=5.25e-07
MI78_MXPA2_2 XI78_p1 SE VDD VDD pm1p2_svt_lp L=6e-08 W=5.25e-07
MI78_MXPA1 ne E XI78_p1 VDD pm1p2_svt_lp L=6e-08 W=5.25e-07
MI20_MXPOEN nm CK ne VDD pm1p2_svt_lp L=6e-08 W=4.4e-07
MI29_MXPOEN nm nck XI29_p1 VDD pm1p2_svt_lp L=6e-08 W=1.5e-07
MI29_MXPA1 XI29_p1 m VDD VDD pm1p2_svt_lp L=6e-08 W=1.5e-07
MI74_MXPA1 m nm VDD VDD pm1p2_svt_lp L=6e-08 W=5.65e-07
MI72_MXPA1 nck CK VDD VDD pm1p2_svt_lp L=6e-08 W=2.45e-07
MXP0 neck m VDD VDD pm1p2_svt_lp L=6e-08 W=2.9e-07
MXP1 neck CK VDD VDD pm1p2_svt_lp L=6e-08 W=5.85e-07
MXP1_2 neck CK VDD VDD pm1p2_svt_lp L=6e-08 W=5.85e-07
MXP1_3 neck CK VDD VDD pm1p2_svt_lp L=6e-08 W=5.85e-07
MXP1_4 neck CK VDD VDD pm1p2_svt_lp L=6e-08 W=5.85e-07
MXP1_5 neck CK VDD VDD pm1p2_svt_lp L=6e-08 W=5.85e-07
MI8_MXPA1 ECK neck VDD VDD pm1p2_svt_lp L=6e-08 W=5.85e-07
MI8_MXPA1_2 ECK neck VDD VDD pm1p2_svt_lp L=6e-08 W=5.85e-07
MI8_MXPA1_3 ECK neck VDD VDD pm1p2_svt_lp L=6e-08 W=5.85e-07
MI8_MXPA1_4 ECK neck VDD VDD pm1p2_svt_lp L=6e-08 W=5.85e-07
MI8_MXPA1_5 ECK neck VDD VDD pm1p2_svt_lp L=6e-08 W=5.85e-07
MI8_MXPA1_6 ECK neck VDD VDD pm1p2_svt_lp L=6e-08 W=5.85e-07
MI8_MXPA1_7 ECK neck VDD VDD pm1p2_svt_lp L=6e-08 W=5.85e-07
MI8_MXPA1_8 ECK neck VDD VDD pm1p2_svt_lp L=6e-08 W=5.85e-07
MI8_MXPA1_9 ECK neck VDD VDD pm1p2_svt_lp L=6e-08 W=5.85e-07
MI8_MXPA1_10 ECK neck VDD VDD pm1p2_svt_lp L=6e-08 W=5.85e-07
MI8_MXPA1_11 ECK neck VDD VDD pm1p2_svt_lp L=6e-08 W=5.85e-07
MI8_MXPA1_12 ECK neck VDD VDD pm1p2_svt_lp L=6e-08 W=5.85e-07
MI8_MXPA1_13 ECK neck VDD VDD pm1p2_svt_lp L=6e-08 W=5.85e-07
MI8_MXPA1_14 ECK neck VDD VDD pm1p2_svt_lp L=6e-08 W=5.85e-07
MI8_MXPA1_15 ECK neck VDD VDD pm1p2_svt_lp L=6e-08 W=5.85e-07
MI8_MXPA1_16 ECK neck VDD VDD pm1p2_svt_lp L=6e-08 W=5.85e-07
.ENDS

.SUBCKT POSTICGX0P5H9R ECK VDD VSS CK E SEN
MI72_MXNA1 nck CK VSS VSS nm1p2_svt_lp L=6e-08 W=1.5e-07
MI74_MXNA1 ne E VSS VSS nm1p2_svt_lp L=6e-08 W=2e-07
MI20_MXNOE nm nck ne VSS nm1p2_svt_lp L=6e-08 W=2e-07
MI29_MXNOE nm CK XI29_n1 VSS nm1p2_svt_lp L=6e-08 W=1.5e-07
MI29_MXNA1 XI29_n1 m VSS VSS nm1p2_svt_lp L=6e-08 W=1.5e-07
MI1_MXNA2 XI1_n1 SEN VSS VSS nm1p2_svt_lp L=6e-08 W=2.55e-07
MI1_MXNA1 m nm XI1_n1 VSS nm1p2_svt_lp L=6e-08 W=2.55e-07
MXN0 neck CK n1 VSS nm1p2_svt_lp L=6e-08 W=1.5e-07
MXN1 n1 m VSS VSS nm1p2_svt_lp L=6e-08 W=1.5e-07
MI8_MXNA1 ECK neck VSS VSS nm1p2_svt_lp L=6e-08 W=1.5e-07
MI72_MXPA1 nck CK VDD VDD pm1p2_svt_lp L=6e-08 W=2.1e-07
MI74_MXPA1 ne E VDD VDD pm1p2_svt_lp L=6e-08 W=2.8e-07
MI20_MXPOEN nm CK ne VDD pm1p2_svt_lp L=6e-08 W=2e-07
MI29_MXPOEN nm nck XI29_p1 VDD pm1p2_svt_lp L=6e-08 W=1.5e-07
MI29_MXPA1 XI29_p1 m VDD VDD pm1p2_svt_lp L=6e-08 W=1.5e-07
MI1_MXPA2 m SEN VDD VDD pm1p2_svt_lp L=6e-08 W=2.05e-07
MI1_MXPA1 m nm VDD VDD pm1p2_svt_lp L=6e-08 W=2.05e-07
MXP1 neck CK VDD VDD pm1p2_svt_lp L=6e-08 W=2.3e-07
MXP0 neck m VDD VDD pm1p2_svt_lp L=6e-08 W=1.5e-07
MI8_MXPA1 ECK neck VDD VDD pm1p2_svt_lp L=6e-08 W=3.25e-07
.ENDS

.SUBCKT POSTICGX0P6H9R ECK VDD VSS CK E SEN
MI72_MXNA1 nck CK VSS VSS nm1p2_svt_lp L=6e-08 W=1.5e-07
MI74_MXNA1 ne E VSS VSS nm1p2_svt_lp L=6e-08 W=2e-07
MI20_MXNOE nm nck ne VSS nm1p2_svt_lp L=6e-08 W=2e-07
MI29_MXNOE nm CK XI29_n1 VSS nm1p2_svt_lp L=6e-08 W=1.5e-07
MI29_MXNA1 XI29_n1 m VSS VSS nm1p2_svt_lp L=6e-08 W=1.5e-07
MI1_MXNA2 XI1_n1 SEN VSS VSS nm1p2_svt_lp L=6e-08 W=2.55e-07
MI1_MXNA1 m nm XI1_n1 VSS nm1p2_svt_lp L=6e-08 W=2.55e-07
MXN0 neck CK n1 VSS nm1p2_svt_lp L=6e-08 W=1.5e-07
MXN1 n1 m VSS VSS nm1p2_svt_lp L=6e-08 W=1.5e-07
MI8_MXNA1 ECK neck VSS VSS nm1p2_svt_lp L=6e-08 W=1.5e-07
MI72_MXPA1 nck CK VDD VDD pm1p2_svt_lp L=6e-08 W=2.1e-07
MI74_MXPA1 ne E VDD VDD pm1p2_svt_lp L=6e-08 W=2.8e-07
MI20_MXPOEN nm CK ne VDD pm1p2_svt_lp L=6e-08 W=2e-07
MI29_MXPOEN nm nck XI29_p1 VDD pm1p2_svt_lp L=6e-08 W=1.5e-07
MI29_MXPA1 XI29_p1 m VDD VDD pm1p2_svt_lp L=6e-08 W=1.5e-07
MI1_MXPA2 m SEN VDD VDD pm1p2_svt_lp L=6e-08 W=2.05e-07
MI1_MXPA1 m nm VDD VDD pm1p2_svt_lp L=6e-08 W=2.05e-07
MXP1 neck CK VDD VDD pm1p2_svt_lp L=6e-08 W=2.5e-07
MXP0 neck m VDD VDD pm1p2_svt_lp L=6e-08 W=1.5e-07
MI8_MXPA1 ECK neck VDD VDD pm1p2_svt_lp L=6e-08 W=3.7e-07
.ENDS

.SUBCKT POSTICGX0P7H9R ECK VDD VSS CK E SEN
MI72_MXNA1 nck CK VSS VSS nm1p2_svt_lp L=6e-08 W=1.5e-07
MI74_MXNA1 ne E VSS VSS nm1p2_svt_lp L=6e-08 W=2e-07
MI20_MXNOE nm nck ne VSS nm1p2_svt_lp L=6e-08 W=2e-07
MI29_MXNOE nm CK XI29_n1 VSS nm1p2_svt_lp L=6e-08 W=1.5e-07
MI29_MXNA1 XI29_n1 m VSS VSS nm1p2_svt_lp L=6e-08 W=1.5e-07
MI1_MXNA2 XI1_n1 SEN VSS VSS nm1p2_svt_lp L=6e-08 W=2.55e-07
MI1_MXNA1 m nm XI1_n1 VSS nm1p2_svt_lp L=6e-08 W=2.55e-07
MXN0 neck CK n1 VSS nm1p2_svt_lp L=6e-08 W=1.5e-07
MXN1 n1 m VSS VSS nm1p2_svt_lp L=6e-08 W=1.5e-07
MI8_MXNA1 ECK neck VSS VSS nm1p2_svt_lp L=6e-08 W=1.65e-07
MI72_MXPA1 nck CK VDD VDD pm1p2_svt_lp L=6e-08 W=2.1e-07
MI74_MXPA1 ne E VDD VDD pm1p2_svt_lp L=6e-08 W=2.8e-07
MI20_MXPOEN nm CK ne VDD pm1p2_svt_lp L=6e-08 W=2e-07
MI29_MXPOEN nm nck XI29_p1 VDD pm1p2_svt_lp L=6e-08 W=1.5e-07
MI29_MXPA1 XI29_p1 m VDD VDD pm1p2_svt_lp L=6e-08 W=1.5e-07
MI1_MXPA2 m SEN VDD VDD pm1p2_svt_lp L=6e-08 W=2.05e-07
MI1_MXPA1 m nm VDD VDD pm1p2_svt_lp L=6e-08 W=2.05e-07
MXP1 neck CK VDD VDD pm1p2_svt_lp L=6e-08 W=2.5e-07
MXP0 neck m VDD VDD pm1p2_svt_lp L=6e-08 W=1.5e-07
MI8_MXPA1 ECK neck VDD VDD pm1p2_svt_lp L=6e-08 W=4.15e-07
.ENDS

.SUBCKT POSTICGX0P8H9R ECK VDD VSS CK E SEN
MI72_MXNA1 nck CK VSS VSS nm1p2_svt_lp L=6e-08 W=1.5e-07
MI74_MXNA1 ne E VSS VSS nm1p2_svt_lp L=6e-08 W=2e-07
MI20_MXNOE nm nck ne VSS nm1p2_svt_lp L=6e-08 W=2e-07
MI29_MXNOE nm CK XI29_n1 VSS nm1p2_svt_lp L=6e-08 W=1.5e-07
MI29_MXNA1 XI29_n1 m VSS VSS nm1p2_svt_lp L=6e-08 W=1.5e-07
MI1_MXNA2 XI1_n1 SEN VSS VSS nm1p2_svt_lp L=6e-08 W=2.55e-07
MI1_MXNA1 m nm XI1_n1 VSS nm1p2_svt_lp L=6e-08 W=2.55e-07
MXN0 neck CK n1 VSS nm1p2_svt_lp L=6e-08 W=1.5e-07
MXN1 n1 m VSS VSS nm1p2_svt_lp L=6e-08 W=1.5e-07
MI8_MXNA1 ECK neck VSS VSS nm1p2_svt_lp L=6e-08 W=2e-07
MI72_MXPA1 nck CK VDD VDD pm1p2_svt_lp L=6e-08 W=2.1e-07
MI74_MXPA1 ne E VDD VDD pm1p2_svt_lp L=6e-08 W=2.8e-07
MI20_MXPOEN nm CK ne VDD pm1p2_svt_lp L=6e-08 W=2e-07
MI29_MXPOEN nm nck XI29_p1 VDD pm1p2_svt_lp L=6e-08 W=1.5e-07
MI29_MXPA1 XI29_p1 m VDD VDD pm1p2_svt_lp L=6e-08 W=1.5e-07
MI1_MXPA2 m SEN VDD VDD pm1p2_svt_lp L=6e-08 W=2.05e-07
MI1_MXPA1 m nm VDD VDD pm1p2_svt_lp L=6e-08 W=2.05e-07
MXP1 neck CK VDD VDD pm1p2_svt_lp L=6e-08 W=2.5e-07
MXP0 neck m VDD VDD pm1p2_svt_lp L=6e-08 W=1.5e-07
MI8_MXPA1 ECK neck VDD VDD pm1p2_svt_lp L=6e-08 W=4.9e-07
.ENDS

.SUBCKT POSTICGX1H9R ECK VDD VSS CK E SEN
MI72_MXNA1 nck CK VSS VSS nm1p2_svt_lp L=6e-08 W=1.5e-07
MI74_MXNA1 ne E VSS VSS nm1p2_svt_lp L=6e-08 W=2e-07
MI20_MXNOE nm nck ne VSS nm1p2_svt_lp L=6e-08 W=2e-07
MI29_MXNOE nm CK XI29_n1 VSS nm1p2_svt_lp L=6e-08 W=1.5e-07
MI29_MXNA1 XI29_n1 m VSS VSS nm1p2_svt_lp L=6e-08 W=1.5e-07
MI1_MXNA2 XI1_n1 SEN VSS VSS nm1p2_svt_lp L=6e-08 W=2.55e-07
MI1_MXNA1 m nm XI1_n1 VSS nm1p2_svt_lp L=6e-08 W=2.55e-07
MXN0 neck CK n1 VSS nm1p2_svt_lp L=6e-08 W=1.5e-07
MXN1 n1 m VSS VSS nm1p2_svt_lp L=6e-08 W=1.5e-07
MI8_MXNA1 ECK neck VSS VSS nm1p2_svt_lp L=6e-08 W=2.35e-07
MI72_MXPA1 nck CK VDD VDD pm1p2_svt_lp L=6e-08 W=2.1e-07
MI74_MXPA1 ne E VDD VDD pm1p2_svt_lp L=6e-08 W=2.8e-07
MI20_MXPOEN nm CK ne VDD pm1p2_svt_lp L=6e-08 W=2e-07
MI29_MXPOEN nm nck XI29_p1 VDD pm1p2_svt_lp L=6e-08 W=1.5e-07
MI29_MXPA1 XI29_p1 m VDD VDD pm1p2_svt_lp L=6e-08 W=1.5e-07
MI1_MXPA2 m SEN VDD VDD pm1p2_svt_lp L=6e-08 W=2.05e-07
MI1_MXPA1 m nm VDD VDD pm1p2_svt_lp L=6e-08 W=2.05e-07
MXP1 neck CK VDD VDD pm1p2_svt_lp L=6e-08 W=2.5e-07
MXP0 neck m VDD VDD pm1p2_svt_lp L=6e-08 W=1.5e-07
MI8_MXPA1 ECK neck VDD VDD pm1p2_svt_lp L=6e-08 W=5.85e-07
.ENDS

.SUBCKT POSTICGX1P2H9R ECK VDD VSS CK E SEN
MI72_MXNA1 nck CK VSS VSS nm1p2_svt_lp L=6e-08 W=1.5e-07
MI74_MXNA1 ne E VSS VSS nm1p2_svt_lp L=6e-08 W=2e-07
MI20_MXNOE nm nck ne VSS nm1p2_svt_lp L=6e-08 W=2e-07
MI29_MXNOE nm CK XI29_n1 VSS nm1p2_svt_lp L=6e-08 W=1.5e-07
MI29_MXNA1 XI29_n1 m VSS VSS nm1p2_svt_lp L=6e-08 W=1.5e-07
MI1_MXNA2 XI1_n1 SEN VSS VSS nm1p2_svt_lp L=6e-08 W=2.6e-07
MI1_MXNA1 m nm XI1_n1 VSS nm1p2_svt_lp L=6e-08 W=2.6e-07
MXN0 neck CK n1 VSS nm1p2_svt_lp L=6e-08 W=1.8e-07
MXN1 n1 m VSS VSS nm1p2_svt_lp L=6e-08 W=1.8e-07
MI8_MXNA1 ECK neck VSS VSS nm1p2_svt_lp L=6e-08 W=2.8e-07
MI72_MXPA1 nck CK VDD VDD pm1p2_svt_lp L=6e-08 W=2.1e-07
MI74_MXPA1 ne E VDD VDD pm1p2_svt_lp L=6e-08 W=2.8e-07
MI20_MXPOEN nm CK ne VDD pm1p2_svt_lp L=6e-08 W=2e-07
MI29_MXPOEN nm nck XI29_p1 VDD pm1p2_svt_lp L=6e-08 W=1.5e-07
MI29_MXPA1 XI29_p1 m VDD VDD pm1p2_svt_lp L=6e-08 W=1.5e-07
MI1_MXPA2 m SEN VDD VDD pm1p2_svt_lp L=6e-08 W=2.05e-07
MI1_MXPA1 m nm VDD VDD pm1p2_svt_lp L=6e-08 W=2.05e-07
MXP1 neck CK VDD VDD pm1p2_svt_lp L=6e-08 W=2.9e-07
MXP0 neck m VDD VDD pm1p2_svt_lp L=6e-08 W=1.5e-07
MI8_MXPA1 ECK neck VDD VDD pm1p2_svt_lp L=6e-08 W=3.5e-07
MI8_MXPA1_2 ECK neck VDD VDD pm1p2_svt_lp L=6e-08 W=3.5e-07
.ENDS

.SUBCKT POSTICGX1P4H9R ECK VDD VSS CK E SEN
MI72_MXNA1 nck CK VSS VSS nm1p2_svt_lp L=6e-08 W=1.5e-07
MI74_MXNA1 ne E VSS VSS nm1p2_svt_lp L=6e-08 W=2e-07
MI20_MXNOE nm nck ne VSS nm1p2_svt_lp L=6e-08 W=2e-07
MI29_MXNOE nm CK XI29_n1 VSS nm1p2_svt_lp L=6e-08 W=1.5e-07
MI29_MXNA1 XI29_n1 m VSS VSS nm1p2_svt_lp L=6e-08 W=1.5e-07
MI1_MXNA2 XI1_n1 SEN VSS VSS nm1p2_svt_lp L=6e-08 W=2.6e-07
MI1_MXNA1 m nm XI1_n1 VSS nm1p2_svt_lp L=6e-08 W=2.6e-07
MXN0 neck CK n1 VSS nm1p2_svt_lp L=6e-08 W=1.95e-07
MXN1 n1 m VSS VSS nm1p2_svt_lp L=6e-08 W=1.95e-07
MI8_MXNA1 ECK neck VSS VSS nm1p2_svt_lp L=6e-08 W=3.3e-07
MI72_MXPA1 nck CK VDD VDD pm1p2_svt_lp L=6e-08 W=2.1e-07
MI74_MXPA1 ne E VDD VDD pm1p2_svt_lp L=6e-08 W=2.8e-07
MI20_MXPOEN nm CK ne VDD pm1p2_svt_lp L=6e-08 W=2e-07
MI29_MXPOEN nm nck XI29_p1 VDD pm1p2_svt_lp L=6e-08 W=1.5e-07
MI29_MXPA1 XI29_p1 m VDD VDD pm1p2_svt_lp L=6e-08 W=1.5e-07
MI1_MXPA2 m SEN VDD VDD pm1p2_svt_lp L=6e-08 W=2.05e-07
MI1_MXPA1 m nm VDD VDD pm1p2_svt_lp L=6e-08 W=2.05e-07
MXP1 neck CK VDD VDD pm1p2_svt_lp L=6e-08 W=3.3e-07
MXP0 neck m VDD VDD pm1p2_svt_lp L=6e-08 W=1.5e-07
MI8_MXPA1 ECK neck VDD VDD pm1p2_svt_lp L=6e-08 W=4.15e-07
MI8_MXPA1_2 ECK neck VDD VDD pm1p2_svt_lp L=6e-08 W=4.15e-07
.ENDS

.SUBCKT POSTICGX1P7H9R ECK VDD VSS CK E SEN
MI72_MXNA1 nck CK VSS VSS nm1p2_svt_lp L=6e-08 W=1.5e-07
MI74_MXNA1 ne E VSS VSS nm1p2_svt_lp L=6e-08 W=2.1e-07
MI20_MXNOE nm nck ne VSS nm1p2_svt_lp L=6e-08 W=2.1e-07
MI29_MXNOE nm CK XI29_n1 VSS nm1p2_svt_lp L=6e-08 W=1.5e-07
MI29_MXNA1 XI29_n1 m VSS VSS nm1p2_svt_lp L=6e-08 W=1.5e-07
MI1_MXNA2 XI1_n1 SEN VSS VSS nm1p2_svt_lp L=6e-08 W=2.65e-07
MI1_MXNA1 m nm XI1_n1 VSS nm1p2_svt_lp L=6e-08 W=2.65e-07
MXN0 neck CK n1 VSS nm1p2_svt_lp L=6e-08 W=2.2e-07
MXN1 n1 m VSS VSS nm1p2_svt_lp L=6e-08 W=2.2e-07
MI8_MXNA1 ECK neck VSS VSS nm1p2_svt_lp L=6e-08 W=4e-07
MI72_MXPA1 nck CK VDD VDD pm1p2_svt_lp L=6e-08 W=2.1e-07
MI74_MXPA1 ne E VDD VDD pm1p2_svt_lp L=6e-08 W=3e-07
MI20_MXPOEN nm CK ne VDD pm1p2_svt_lp L=6e-08 W=2.1e-07
MI29_MXPOEN nm nck XI29_p1 VDD pm1p2_svt_lp L=6e-08 W=1.5e-07
MI29_MXPA1 XI29_p1 m VDD VDD pm1p2_svt_lp L=6e-08 W=1.5e-07
MI1_MXPA2 m SEN VDD VDD pm1p2_svt_lp L=6e-08 W=2.1e-07
MI1_MXPA1 m nm VDD VDD pm1p2_svt_lp L=6e-08 W=2.1e-07
MXP1 neck CK VDD VDD pm1p2_svt_lp L=6e-08 W=3.5e-07
MXP0 neck m VDD VDD pm1p2_svt_lp L=6e-08 W=1.5e-07
MI8_MXPA1 ECK neck VDD VDD pm1p2_svt_lp L=6e-08 W=4.4e-07
MI8_MXPA1_2 ECK neck VDD VDD pm1p2_svt_lp L=6e-08 W=4.4e-07
.ENDS

.SUBCKT POSTICGX2H9R ECK VDD VSS CK E SEN
MI72_MXNA1 nck CK VSS VSS nm1p2_svt_lp L=6e-08 W=1.5e-07
MI74_MXNA1 ne E VSS VSS nm1p2_svt_lp L=6e-08 W=2.1e-07
MI20_MXNOE nm nck ne VSS nm1p2_svt_lp L=6e-08 W=2.1e-07
MI29_MXNOE nm CK XI29_n1 VSS nm1p2_svt_lp L=6e-08 W=1.5e-07
MI29_MXNA1 XI29_n1 m VSS VSS nm1p2_svt_lp L=6e-08 W=1.5e-07
MI1_MXNA2 XI1_n1 SEN VSS VSS nm1p2_svt_lp L=6e-08 W=2.7e-07
MI1_MXNA1 m nm XI1_n1 VSS nm1p2_svt_lp L=6e-08 W=2.7e-07
MXN0 neck CK n1 VSS nm1p2_svt_lp L=6e-08 W=2.45e-07
MXN1 n1 m VSS VSS nm1p2_svt_lp L=6e-08 W=2.45e-07
MI8_MXNA1 ECK neck VSS VSS nm1p2_svt_lp L=6e-08 W=4.7e-07
MI72_MXPA1 nck CK VDD VDD pm1p2_svt_lp L=6e-08 W=2.1e-07
MI74_MXPA1 ne E VDD VDD pm1p2_svt_lp L=6e-08 W=3e-07
MI20_MXPOEN nm CK ne VDD pm1p2_svt_lp L=6e-08 W=2.1e-07
MI29_MXPOEN nm nck XI29_p1 VDD pm1p2_svt_lp L=6e-08 W=1.5e-07
MI29_MXPA1 XI29_p1 m VDD VDD pm1p2_svt_lp L=6e-08 W=1.5e-07
MI1_MXPA2 m SEN VDD VDD pm1p2_svt_lp L=6e-08 W=2.15e-07
MI1_MXPA1 m nm VDD VDD pm1p2_svt_lp L=6e-08 W=2.15e-07
MXP1 neck CK VDD VDD pm1p2_svt_lp L=6e-08 W=3.7e-07
MXP0 neck m VDD VDD pm1p2_svt_lp L=6e-08 W=1.5e-07
MI8_MXPA1 ECK neck VDD VDD pm1p2_svt_lp L=6e-08 W=5.85e-07
MI8_MXPA1_2 ECK neck VDD VDD pm1p2_svt_lp L=6e-08 W=5.85e-07
.ENDS

.SUBCKT POSTICGX2P5H9R ECK VDD VSS CK E SEN
MI72_MXNA1 nck CK VSS VSS nm1p2_svt_lp L=6e-08 W=1.5e-07
MI74_MXNA1 ne E VSS VSS nm1p2_svt_lp L=6e-08 W=2.15e-07
MI20_MXNOE nm nck ne VSS nm1p2_svt_lp L=6e-08 W=2.15e-07
MI29_MXNOE nm CK XI29_n1 VSS nm1p2_svt_lp L=6e-08 W=1.5e-07
MI29_MXNA1 XI29_n1 m VSS VSS nm1p2_svt_lp L=6e-08 W=1.5e-07
MI1_MXNA2 XI1_n1 SEN VSS VSS nm1p2_svt_lp L=6e-08 W=2.85e-07
MI1_MXNA1 m nm XI1_n1 VSS nm1p2_svt_lp L=6e-08 W=2.85e-07
MXN0 neck CK n1 VSS nm1p2_svt_lp L=6e-08 W=3.4e-07
MXN1 n1 m VSS VSS nm1p2_svt_lp L=6e-08 W=3.4e-07
MI8_MXNA1 ECK neck VSS VSS nm1p2_svt_lp L=6e-08 W=3e-07
MI8_MXNA1_2 ECK neck VSS VSS nm1p2_svt_lp L=6e-08 W=3e-07
MI72_MXPA1 nck CK VDD VDD pm1p2_svt_lp L=6e-08 W=2.1e-07
MI74_MXPA1 ne E VDD VDD pm1p2_svt_lp L=6e-08 W=3e-07
MI20_MXPOEN nm CK ne VDD pm1p2_svt_lp L=6e-08 W=2.15e-07
MI29_MXPOEN nm nck XI29_p1 VDD pm1p2_svt_lp L=6e-08 W=1.5e-07
MI29_MXPA1 XI29_p1 m VDD VDD pm1p2_svt_lp L=6e-08 W=1.5e-07
MI1_MXPA2 m SEN VDD VDD pm1p2_svt_lp L=6e-08 W=2.25e-07
MI1_MXPA1 m nm VDD VDD pm1p2_svt_lp L=6e-08 W=2.25e-07
MXP1 neck CK VDD VDD pm1p2_svt_lp L=6e-08 W=5.45e-07
MXP0 neck m VDD VDD pm1p2_svt_lp L=6e-08 W=1.5e-07
MI8_MXPA1 ECK neck VDD VDD pm1p2_svt_lp L=6e-08 W=4.45e-07
MI8_MXPA1_2 ECK neck VDD VDD pm1p2_svt_lp L=6e-08 W=4.45e-07
MI8_MXPA1_3 ECK neck VDD VDD pm1p2_svt_lp L=6e-08 W=5.8e-07
.ENDS

.SUBCKT POSTICGX3H9R ECK VDD VSS CK E SEN
MI72_MXNA1 nck CK VSS VSS nm1p2_svt_lp L=6e-08 W=1.5e-07
MI74_MXNA1 ne E VSS VSS nm1p2_svt_lp L=6e-08 W=2.15e-07
MI20_MXNOE nm nck ne VSS nm1p2_svt_lp L=6e-08 W=2.15e-07
MI29_MXNOE nm CK XI29_n1 VSS nm1p2_svt_lp L=6e-08 W=1.5e-07
MI29_MXNA1 XI29_n1 m VSS VSS nm1p2_svt_lp L=6e-08 W=1.5e-07
MI1_MXNA2 XI1_n1 SEN VSS VSS nm1p2_svt_lp L=6e-08 W=2.9e-07
MI1_MXNA1 m nm XI1_n1 VSS nm1p2_svt_lp L=6e-08 W=2.9e-07
MXN0 neck CK n1 VSS nm1p2_svt_lp L=6e-08 W=3.4e-07
MXN1 n1 m VSS VSS nm1p2_svt_lp L=6e-08 W=3.4e-07
MI8_MXNA1 ECK neck VSS VSS nm1p2_svt_lp L=6e-08 W=3.5e-07
MI8_MXNA1_2 ECK neck VSS VSS nm1p2_svt_lp L=6e-08 W=3.55e-07
MI72_MXPA1 nck CK VDD VDD pm1p2_svt_lp L=6e-08 W=2.1e-07
MI74_MXPA1 ne E VDD VDD pm1p2_svt_lp L=6e-08 W=3e-07
MI20_MXPOEN nm CK ne VDD pm1p2_svt_lp L=6e-08 W=2.15e-07
MI29_MXPOEN nm nck XI29_p1 VDD pm1p2_svt_lp L=6e-08 W=1.5e-07
MI29_MXPA1 XI29_p1 m VDD VDD pm1p2_svt_lp L=6e-08 W=1.5e-07
MI1_MXPA2 m SEN VDD VDD pm1p2_svt_lp L=6e-08 W=2.3e-07
MI1_MXPA1 m nm VDD VDD pm1p2_svt_lp L=6e-08 W=2.3e-07
MXP1 neck CK VDD VDD pm1p2_svt_lp L=6e-08 W=5.85e-07
MXP0 neck m VDD VDD pm1p2_svt_lp L=6e-08 W=1.5e-07
MI8_MXPA1 ECK neck VDD VDD pm1p2_svt_lp L=6e-08 W=5.85e-07
MI8_MXPA1_2 ECK neck VDD VDD pm1p2_svt_lp L=6e-08 W=5.85e-07
MI8_MXPA1_3 ECK neck VDD VDD pm1p2_svt_lp L=6e-08 W=5.85e-07
.ENDS

.SUBCKT POSTICGX3P5H9R ECK VDD VSS CK E SEN
MI72_MXNA1 nck CK VSS VSS nm1p2_svt_lp L=6e-08 W=1.5e-07
MI74_MXNA1 ne E VSS VSS nm1p2_svt_lp L=6e-08 W=2.3e-07
MI20_MXNOE nm nck ne VSS nm1p2_svt_lp L=6e-08 W=2.3e-07
MI29_MXNOE nm CK XI29_n1 VSS nm1p2_svt_lp L=6e-08 W=1.5e-07
MI29_MXNA1 XI29_n1 m VSS VSS nm1p2_svt_lp L=6e-08 W=1.5e-07
MI1_MXNA1 m nm XI1_n1 VSS nm1p2_svt_lp L=6e-08 W=3.25e-07
MI1_MXNA2 XI1_n1 SEN VSS VSS nm1p2_svt_lp L=6e-08 W=3.25e-07
MXN0 neck CK n1 VSS nm1p2_svt_lp L=6e-08 W=4.5e-07
MXN1 n1 m VSS VSS nm1p2_svt_lp L=6e-08 W=4.5e-07
MI8_MXNA1 ECK neck VSS VSS nm1p2_svt_lp L=6e-08 W=4.1e-07
MI8_MXNA1_2 ECK neck VSS VSS nm1p2_svt_lp L=6e-08 W=4.1e-07
MI72_MXPA1 nck CK VDD VDD pm1p2_svt_lp L=6e-08 W=2.1e-07
MI74_MXPA1 ne E VDD VDD pm1p2_svt_lp L=6e-08 W=3.2e-07
MI20_MXPOEN nm CK ne VDD pm1p2_svt_lp L=6e-08 W=2.3e-07
MI29_MXPOEN nm nck XI29_p1 VDD pm1p2_svt_lp L=6e-08 W=1.5e-07
MI29_MXPA1 XI29_p1 m VDD VDD pm1p2_svt_lp L=6e-08 W=1.5e-07
MI1_MXPA1 m nm VDD VDD pm1p2_svt_lp L=6e-08 W=2.6e-07
MI1_MXPA2 m SEN VDD VDD pm1p2_svt_lp L=6e-08 W=2.6e-07
MXP1 neck CK VDD VDD pm1p2_svt_lp L=6e-08 W=3.8e-07
MXP1_2 neck CK VDD VDD pm1p2_svt_lp L=6e-08 W=3.8e-07
MXP0 neck m VDD VDD pm1p2_svt_lp L=6e-08 W=1.5e-07
MI8_MXPA1 ECK neck VDD VDD pm1p2_svt_lp L=6e-08 W=5.1e-07
MI8_MXPA1_2 ECK neck VDD VDD pm1p2_svt_lp L=6e-08 W=5.1e-07
MI8_MXPA1_3 ECK neck VDD VDD pm1p2_svt_lp L=6e-08 W=5.1e-07
MI8_MXPA1_4 ECK neck VDD VDD pm1p2_svt_lp L=6e-08 W=5.1e-07
.ENDS

.SUBCKT POSTICGX4H9R ECK VDD VSS CK E SEN
MI72_MXNA1 nck CK VSS VSS nm1p2_svt_lp L=6e-08 W=1.5e-07
MI74_MXNA1 ne E VSS VSS nm1p2_svt_lp L=6e-08 W=2.3e-07
MI20_MXNOE nm nck ne VSS nm1p2_svt_lp L=6e-08 W=2.3e-07
MI29_MXNOE nm CK XI29_n1 VSS nm1p2_svt_lp L=6e-08 W=1.5e-07
MI29_MXNA1 XI29_n1 m VSS VSS nm1p2_svt_lp L=6e-08 W=1.5e-07
MI1_MXNA1 m nm XI1_n1 VSS nm1p2_svt_lp L=6e-08 W=3.35e-07
MI1_MXNA2 XI1_n1 SEN VSS VSS nm1p2_svt_lp L=6e-08 W=3.35e-07
MXN1_2 n1__2 m VSS VSS nm1p2_svt_lp L=6e-08 W=2.45e-07
MXN0_2 neck CK n1__2 VSS nm1p2_svt_lp L=6e-08 W=2.45e-07
MXN0 neck CK n1 VSS nm1p2_svt_lp L=6e-08 W=2.45e-07
MXN1 n1 m VSS VSS nm1p2_svt_lp L=6e-08 W=2.45e-07
MI8_MXNA1 ECK neck VSS VSS nm1p2_svt_lp L=6e-08 W=4.7e-07
MI8_MXNA1_2 ECK neck VSS VSS nm1p2_svt_lp L=6e-08 W=4.7e-07
MI72_MXPA1 nck CK VDD VDD pm1p2_svt_lp L=6e-08 W=2.1e-07
MI74_MXPA1 ne E VDD VDD pm1p2_svt_lp L=6e-08 W=3.2e-07
MI20_MXPOEN nm CK ne VDD pm1p2_svt_lp L=6e-08 W=2.3e-07
MI29_MXPOEN nm nck XI29_p1 VDD pm1p2_svt_lp L=6e-08 W=1.5e-07
MI29_MXPA1 XI29_p1 m VDD VDD pm1p2_svt_lp L=6e-08 W=1.5e-07
MI1_MXPA1 m nm VDD VDD pm1p2_svt_lp L=6e-08 W=2.7e-07
MI1_MXPA2 m SEN VDD VDD pm1p2_svt_lp L=6e-08 W=2.7e-07
MXP1 neck CK VDD VDD pm1p2_svt_lp L=6e-08 W=4.2e-07
MXP1_2 neck CK VDD VDD pm1p2_svt_lp L=6e-08 W=4.2e-07
MXP0 neck m VDD VDD pm1p2_svt_lp L=6e-08 W=1.5e-07
MI8_MXPA1 ECK neck VDD VDD pm1p2_svt_lp L=6e-08 W=5.85e-07
MI8_MXPA1_2 ECK neck VDD VDD pm1p2_svt_lp L=6e-08 W=5.85e-07
MI8_MXPA1_3 ECK neck VDD VDD pm1p2_svt_lp L=6e-08 W=5.85e-07
MI8_MXPA1_4 ECK neck VDD VDD pm1p2_svt_lp L=6e-08 W=5.85e-07
.ENDS

.SUBCKT POSTICGX5H9R ECK VDD VSS CK E SEN
MI72_MXNA1 nck CK VSS VSS nm1p2_svt_lp L=6e-08 W=1.5e-07
MI74_MXNA1 ne E VSS VSS nm1p2_svt_lp L=6e-08 W=2.35e-07
MI20_MXNOE nm nck ne VSS nm1p2_svt_lp L=6e-08 W=2.35e-07
MI29_MXNOE nm CK XI29_n1 VSS nm1p2_svt_lp L=6e-08 W=1.5e-07
MI29_MXNA1 XI29_n1 m VSS VSS nm1p2_svt_lp L=6e-08 W=1.5e-07
MI1_MXNA1 m nm XI1_n1 VSS nm1p2_svt_lp L=6e-08 W=3.6e-07
MI1_MXNA2 XI1_n1 SEN VSS VSS nm1p2_svt_lp L=6e-08 W=3.6e-07
MXN1_2 n1__2 m VSS VSS nm1p2_svt_lp L=6e-08 W=3.1e-07
MXN0_2 neck CK n1__2 VSS nm1p2_svt_lp L=6e-08 W=3.1e-07
MXN0 neck CK n1 VSS nm1p2_svt_lp L=6e-08 W=3.15e-07
MXN1 n1 m VSS VSS nm1p2_svt_lp L=6e-08 W=3.15e-07
MI8_MXNA1 ECK neck VSS VSS nm1p2_svt_lp L=6e-08 W=3.95e-07
MI8_MXNA1_2 ECK neck VSS VSS nm1p2_svt_lp L=6e-08 W=3.9e-07
MI8_MXNA1_3 ECK neck VSS VSS nm1p2_svt_lp L=6e-08 W=3.9e-07
MI72_MXPA1 nck CK VDD VDD pm1p2_svt_lp L=6e-08 W=2.1e-07
MI74_MXPA1 ne E VDD VDD pm1p2_svt_lp L=6e-08 W=3.3e-07
MI20_MXPOEN nm CK ne VDD pm1p2_svt_lp L=6e-08 W=2.35e-07
MI29_MXPOEN nm nck XI29_p1 VDD pm1p2_svt_lp L=6e-08 W=1.5e-07
MI29_MXPA1 XI29_p1 m VDD VDD pm1p2_svt_lp L=6e-08 W=1.5e-07
MI1_MXPA1 m nm VDD VDD pm1p2_svt_lp L=6e-08 W=2.9e-07
MI1_MXPA2 m SEN VDD VDD pm1p2_svt_lp L=6e-08 W=2.9e-07
MXP1 neck CK VDD VDD pm1p2_svt_lp L=6e-08 W=4.75e-07
MXP1_2 neck CK VDD VDD pm1p2_svt_lp L=6e-08 W=4.7e-07
MXP0 neck m VDD VDD pm1p2_svt_lp L=6e-08 W=1.5e-07
MI8_MXPA1 ECK neck VDD VDD pm1p2_svt_lp L=6e-08 W=5.85e-07
MI8_MXPA1_2 ECK neck VDD VDD pm1p2_svt_lp L=6e-08 W=5.85e-07
MI8_MXPA1_3 ECK neck VDD VDD pm1p2_svt_lp L=6e-08 W=5.85e-07
MI8_MXPA1_4 ECK neck VDD VDD pm1p2_svt_lp L=6e-08 W=5.85e-07
MI8_MXPA1_5 ECK neck VDD VDD pm1p2_svt_lp L=6e-08 W=5.85e-07
.ENDS

.SUBCKT POSTICGX6H9R ECK VDD VSS CK E SEN
MI72_MXNA1 nck CK VSS VSS nm1p2_svt_lp L=6e-08 W=1.5e-07
MI74_MXNA1 ne E VSS VSS nm1p2_svt_lp L=6e-08 W=2.4e-07
MI20_MXNOE nm nck ne VSS nm1p2_svt_lp L=6e-08 W=2.4e-07
MI29_MXNOE nm CK XI29_n1 VSS nm1p2_svt_lp L=6e-08 W=1.5e-07
MI29_MXNA1 XI29_n1 m VSS VSS nm1p2_svt_lp L=6e-08 W=1.5e-07
MI1_MXNA1 m nm XI1_n1 VSS nm1p2_svt_lp L=6e-08 W=3.8e-07
MI1_MXNA2 XI1_n1 SEN VSS VSS nm1p2_svt_lp L=6e-08 W=3.8e-07
MXN1_2 n1__2 m VSS VSS nm1p2_svt_lp L=6e-08 W=3.7e-07
MXN0_2 neck CK n1__2 VSS nm1p2_svt_lp L=6e-08 W=3.7e-07
MXN0 neck CK n1 VSS nm1p2_svt_lp L=6e-08 W=3.7e-07
MXN1 n1 m VSS VSS nm1p2_svt_lp L=6e-08 W=3.7e-07
MI8_MXNA1 ECK neck VSS VSS nm1p2_svt_lp L=6e-08 W=4.7e-07
MI8_MXNA1_2 ECK neck VSS VSS nm1p2_svt_lp L=6e-08 W=4.7e-07
MI8_MXNA1_3 ECK neck VSS VSS nm1p2_svt_lp L=6e-08 W=4.7e-07
MI72_MXPA1 nck CK VDD VDD pm1p2_svt_lp L=6e-08 W=2.1e-07
MI74_MXPA1 ne E VDD VDD pm1p2_svt_lp L=6e-08 W=3.35e-07
MI20_MXPOEN nm CK ne VDD pm1p2_svt_lp L=6e-08 W=2.4e-07
MI29_MXPOEN nm nck XI29_p1 VDD pm1p2_svt_lp L=6e-08 W=1.5e-07
MI29_MXPA1 XI29_p1 m VDD VDD pm1p2_svt_lp L=6e-08 W=1.5e-07
MI1_MXPA1 m nm VDD VDD pm1p2_svt_lp L=6e-08 W=3.05e-07
MI1_MXPA2 m SEN VDD VDD pm1p2_svt_lp L=6e-08 W=3.05e-07
MXP1 neck CK VDD VDD pm1p2_svt_lp L=6e-08 W=6.6e-07
MXP1_2 neck CK VDD VDD pm1p2_svt_lp L=6e-08 W=6.6e-07
MXP0 neck m VDD VDD pm1p2_svt_lp L=6e-08 W=1.5e-07
MI8_MXPA1 ECK neck VDD VDD pm1p2_svt_lp L=6e-08 W=5.85e-07
MI8_MXPA1_2 ECK neck VDD VDD pm1p2_svt_lp L=6e-08 W=5.85e-07
MI8_MXPA1_3 ECK neck VDD VDD pm1p2_svt_lp L=6e-08 W=5.85e-07
MI8_MXPA1_4 ECK neck VDD VDD pm1p2_svt_lp L=6e-08 W=5.85e-07
MI8_MXPA1_5 ECK neck VDD VDD pm1p2_svt_lp L=6e-08 W=5.85e-07
MI8_MXPA1_6 ECK neck VDD VDD pm1p2_svt_lp L=6e-08 W=5.85e-07
.ENDS

.SUBCKT POSTICGX7P5H9R ECK VDD VSS CK E SEN
MI72_MXNA1 nck CK VSS VSS nm1p2_svt_lp L=6e-08 W=1.5e-07
MI74_MXNA1 ne E VSS VSS nm1p2_svt_lp L=6e-08 W=2.8e-07
MI20_MXNOE nm nck ne VSS nm1p2_svt_lp L=6e-08 W=2.8e-07
MI29_MXNOE nm CK XI29_n1 VSS nm1p2_svt_lp L=6e-08 W=1.5e-07
MI29_MXNA1 XI29_n1 m VSS VSS nm1p2_svt_lp L=6e-08 W=1.5e-07
MI1_MXNA1 m nm XI1_n1 VSS nm1p2_svt_lp L=6e-08 W=4.55e-07
MI1_MXNA2 XI1_n1 SEN VSS VSS nm1p2_svt_lp L=6e-08 W=4.55e-07
MXN1_2 n1__2 m VSS VSS nm1p2_svt_lp L=6e-08 W=4.7e-07
MXN0_2 neck CK n1__2 VSS nm1p2_svt_lp L=6e-08 W=4.7e-07
MXN0 neck CK n1 VSS nm1p2_svt_lp L=6e-08 W=4.7e-07
MXN1 n1 m VSS VSS nm1p2_svt_lp L=6e-08 W=4.7e-07
MI8_MXNA1 ECK neck VSS VSS nm1p2_svt_lp L=6e-08 W=4.4e-07
MI8_MXNA1_2 ECK neck VSS VSS nm1p2_svt_lp L=6e-08 W=4.4e-07
MI8_MXNA1_3 ECK neck VSS VSS nm1p2_svt_lp L=6e-08 W=4.4e-07
MI8_MXNA1_4 ECK neck VSS VSS nm1p2_svt_lp L=6e-08 W=4.4e-07
MI72_MXPA1 nck CK VDD VDD pm1p2_svt_lp L=6e-08 W=2.1e-07
MI74_MXPA1 ne E VDD VDD pm1p2_svt_lp L=6e-08 W=3.9e-07
MI20_MXPOEN nm CK ne VDD pm1p2_svt_lp L=6e-08 W=2.8e-07
MI29_MXPOEN nm nck XI29_p1 VDD pm1p2_svt_lp L=6e-08 W=1.5e-07
MI29_MXPA1 XI29_p1 m VDD VDD pm1p2_svt_lp L=6e-08 W=1.5e-07
MI1_MXPA1 m nm VDD VDD pm1p2_svt_lp L=6e-08 W=3.65e-07
MI1_MXPA2 m SEN VDD VDD pm1p2_svt_lp L=6e-08 W=3.65e-07
MXP1 neck CK VDD VDD pm1p2_svt_lp L=6e-08 W=5.6e-07
MXP1_2 neck CK VDD VDD pm1p2_svt_lp L=6e-08 W=5.6e-07
MXP1_3 neck CK VDD VDD pm1p2_svt_lp L=6e-08 W=5.6e-07
MXP0 neck m VDD VDD pm1p2_svt_lp L=6e-08 W=1.5e-07
MI8_MXPA1 ECK neck VDD VDD pm1p2_svt_lp L=6e-08 W=5.5e-07
MI8_MXPA1_2 ECK neck VDD VDD pm1p2_svt_lp L=6e-08 W=5.5e-07
MI8_MXPA1_3 ECK neck VDD VDD pm1p2_svt_lp L=6e-08 W=5.5e-07
MI8_MXPA1_4 ECK neck VDD VDD pm1p2_svt_lp L=6e-08 W=5.5e-07
MI8_MXPA1_5 ECK neck VDD VDD pm1p2_svt_lp L=6e-08 W=5.5e-07
MI8_MXPA1_6 ECK neck VDD VDD pm1p2_svt_lp L=6e-08 W=5.5e-07
MI8_MXPA1_7 ECK neck VDD VDD pm1p2_svt_lp L=6e-08 W=5.5e-07
MI8_MXPA1_8 ECK neck VDD VDD pm1p2_svt_lp L=6e-08 W=5.5e-07
.ENDS

.SUBCKT POSTICGX9H9R ECK VDD VSS CK E SEN
MI72_MXNA1 nck CK VSS VSS nm1p2_svt_lp L=6e-08 W=1.5e-07
MI74_MXNA1 ne E VSS VSS nm1p2_svt_lp L=6e-08 W=2.85e-07
MI20_MXNOE nm nck ne VSS nm1p2_svt_lp L=6e-08 W=2.85e-07
MI29_MXNOE nm CK XI29_n1 VSS nm1p2_svt_lp L=6e-08 W=1.5e-07
MI29_MXNA1 XI29_n1 m VSS VSS nm1p2_svt_lp L=6e-08 W=1.5e-07
MI1_MXNA2 XI1_n1 SEN VSS VSS nm1p2_svt_lp L=6e-08 W=4.85e-07
MI1_MXNA1 m nm XI1_n1 VSS nm1p2_svt_lp L=6e-08 W=4.85e-07
MXN0_2 neck CK n1__2 VSS nm1p2_svt_lp L=6e-08 W=3.65e-07
MXN1_2 n1__2 m VSS VSS nm1p2_svt_lp L=6e-08 W=3.65e-07
MXN1_3 n1__3 m VSS VSS nm1p2_svt_lp L=6e-08 W=3.75e-07
MXN0_3 neck CK n1__3 VSS nm1p2_svt_lp L=6e-08 W=3.75e-07
MXN0 neck CK n1 VSS nm1p2_svt_lp L=6e-08 W=3.75e-07
MXN1 n1 m VSS VSS nm1p2_svt_lp L=6e-08 W=3.75e-07
MI8_MXNA1 ECK neck VSS VSS nm1p2_svt_lp L=6e-08 W=4.25e-07
MI8_MXNA1_2 ECK neck VSS VSS nm1p2_svt_lp L=6e-08 W=4.25e-07
MI8_MXNA1_3 ECK neck VSS VSS nm1p2_svt_lp L=6e-08 W=4.25e-07
MI8_MXNA1_4 ECK neck VSS VSS nm1p2_svt_lp L=6e-08 W=4.25e-07
MI8_MXNA1_5 ECK neck VSS VSS nm1p2_svt_lp L=6e-08 W=4.15e-07
MI72_MXPA1 nck CK VDD VDD pm1p2_svt_lp L=6e-08 W=2.1e-07
MI74_MXPA1 ne E VDD VDD pm1p2_svt_lp L=6e-08 W=4e-07
MI20_MXPOEN nm CK ne VDD pm1p2_svt_lp L=6e-08 W=2.85e-07
MI29_MXPOEN nm nck XI29_p1 VDD pm1p2_svt_lp L=6e-08 W=1.5e-07
MI29_MXPA1 XI29_p1 m VDD VDD pm1p2_svt_lp L=6e-08 W=1.5e-07
MI1_MXPA2 m SEN VDD VDD pm1p2_svt_lp L=6e-08 W=3.9e-07
MI1_MXPA1 m nm VDD VDD pm1p2_svt_lp L=6e-08 W=3.9e-07
MXP1 neck CK VDD VDD pm1p2_svt_lp L=6e-08 W=4.95e-07
MXP1_2 neck CK VDD VDD pm1p2_svt_lp L=6e-08 W=4.95e-07
MXP0 neck m VDD VDD pm1p2_svt_lp L=6e-08 W=1.7e-07
MXP1_3 neck CK VDD VDD pm1p2_svt_lp L=6e-08 W=4.95e-07
MXP1_4 neck CK VDD VDD pm1p2_svt_lp L=6e-08 W=4.95e-07
MI8_MXPA1 ECK neck VDD VDD pm1p2_svt_lp L=6e-08 W=5.85e-07
MI8_MXPA1_2 ECK neck VDD VDD pm1p2_svt_lp L=6e-08 W=5.85e-07
MI8_MXPA1_3 ECK neck VDD VDD pm1p2_svt_lp L=6e-08 W=5.85e-07
MI8_MXPA1_4 ECK neck VDD VDD pm1p2_svt_lp L=6e-08 W=5.85e-07
MI8_MXPA1_5 ECK neck VDD VDD pm1p2_svt_lp L=6e-08 W=5.85e-07
MI8_MXPA1_6 ECK neck VDD VDD pm1p2_svt_lp L=6e-08 W=5.85e-07
MI8_MXPA1_7 ECK neck VDD VDD pm1p2_svt_lp L=6e-08 W=5.85e-07
MI8_MXPA1_8 ECK neck VDD VDD pm1p2_svt_lp L=6e-08 W=5.85e-07
MI8_MXPA1_9 ECK neck VDD VDD pm1p2_svt_lp L=6e-08 W=5.85e-07
.ENDS

.SUBCKT POSTICGX11H9R ECK VDD VSS CK E SEN
MI72_MXNA1 nck CK VSS VSS nm1p2_svt_lp L=6e-08 W=1.7e-07
MI74_MXNA1 ne E VSS VSS nm1p2_svt_lp L=6e-08 W=3.1e-07
MI20_MXNOE nm nck ne VSS nm1p2_svt_lp L=6e-08 W=3.1e-07
MI29_MXNOE nm CK XI29_n1 VSS nm1p2_svt_lp L=6e-08 W=1.5e-07
MI29_MXNA1 XI29_n1 m VSS VSS nm1p2_svt_lp L=6e-08 W=1.5e-07
MI1_MXNA2_2 XI1_n1__2 SEN VSS VSS nm1p2_svt_lp L=6e-08 W=2.95e-07
MI1_MXNA1_2 m nm XI1_n1__2 VSS nm1p2_svt_lp L=6e-08 W=2.95e-07
MI1_MXNA1 m nm XI1_n1 VSS nm1p2_svt_lp L=6e-08 W=2.95e-07
MI1_MXNA2 XI1_n1 SEN VSS VSS nm1p2_svt_lp L=6e-08 W=2.95e-07
MXN1_2 n1__2 m VSS VSS nm1p2_svt_lp L=6e-08 W=2.7e-07
MXN0_2 neck CK n1__2 VSS nm1p2_svt_lp L=6e-08 W=2.7e-07
MXN0_3 neck CK n1__3 VSS nm1p2_svt_lp L=6e-08 W=2.7e-07
MXN1_3 n1__3 m VSS VSS nm1p2_svt_lp L=6e-08 W=2.7e-07
MXN1_4 n1__4 m VSS VSS nm1p2_svt_lp L=6e-08 W=2.7e-07
MXN0_4 neck CK n1__4 VSS nm1p2_svt_lp L=6e-08 W=2.7e-07
MXN0_5 neck CK n1__5 VSS nm1p2_svt_lp L=6e-08 W=2.7e-07
MXN1_5 n1__5 m VSS VSS nm1p2_svt_lp L=6e-08 W=2.7e-07
MXN1 n1 m VSS VSS nm1p2_svt_lp L=6e-08 W=2.7e-07
MXN0 neck CK n1 VSS nm1p2_svt_lp L=6e-08 W=2.7e-07
MI8_MXNA1 ECK neck VSS VSS nm1p2_svt_lp L=6e-08 W=2.35e-07
MI8_MXNA1_2 ECK neck VSS VSS nm1p2_svt_lp L=6e-08 W=2.35e-07
MI8_MXNA1_3 ECK neck VSS VSS nm1p2_svt_lp L=6e-08 W=2.35e-07
MI8_MXNA1_4 ECK neck VSS VSS nm1p2_svt_lp L=6e-08 W=2.35e-07
MI8_MXNA1_5 ECK neck VSS VSS nm1p2_svt_lp L=6e-08 W=2.35e-07
MI8_MXNA1_6 ECK neck VSS VSS nm1p2_svt_lp L=6e-08 W=2.35e-07
MI8_MXNA1_7 ECK neck VSS VSS nm1p2_svt_lp L=6e-08 W=2.35e-07
MI8_MXNA1_8 ECK neck VSS VSS nm1p2_svt_lp L=6e-08 W=2.35e-07
MI8_MXNA1_9 ECK neck VSS VSS nm1p2_svt_lp L=6e-08 W=2.35e-07
MI8_MXNA1_10 ECK neck VSS VSS nm1p2_svt_lp L=6e-08 W=2.35e-07
MI8_MXNA1_11 ECK neck VSS VSS nm1p2_svt_lp L=6e-08 W=2.35e-07
MI72_MXPA1 nck CK VDD VDD pm1p2_svt_lp L=6e-08 W=2.35e-07
MI74_MXPA1 ne E VDD VDD pm1p2_svt_lp L=6e-08 W=4.35e-07
MI20_MXPOEN nm CK ne VDD pm1p2_svt_lp L=6e-08 W=3.1e-07
MI29_MXPOEN nm nck XI29_p1 VDD pm1p2_svt_lp L=6e-08 W=1.5e-07
MI29_MXPA1 XI29_p1 m VDD VDD pm1p2_svt_lp L=6e-08 W=1.5e-07
MI1_MXPA2 m SEN VDD VDD pm1p2_svt_lp L=6e-08 W=2.35e-07
MI1_MXPA1 m nm VDD VDD pm1p2_svt_lp L=6e-08 W=2.35e-07
MI1_MXPA1_2 m nm VDD VDD pm1p2_svt_lp L=6e-08 W=2.35e-07
MI1_MXPA2_2 m SEN VDD VDD pm1p2_svt_lp L=6e-08 W=2.35e-07
MXP1 neck CK VDD VDD pm1p2_svt_lp L=6e-08 W=4.5e-07
MXP1_2 neck CK VDD VDD pm1p2_svt_lp L=6e-08 W=4.5e-07
MXP1_3 neck CK VDD VDD pm1p2_svt_lp L=6e-08 W=4.5e-07
MXP1_4 neck CK VDD VDD pm1p2_svt_lp L=6e-08 W=4.5e-07
MXP0 neck m VDD VDD pm1p2_svt_lp L=6e-08 W=2.05e-07
MXP1_5 neck CK VDD VDD pm1p2_svt_lp L=6e-08 W=5.4e-07
MI8_MXPA1 ECK neck VDD VDD pm1p2_svt_lp L=6e-08 W=5.85e-07
MI8_MXPA1_2 ECK neck VDD VDD pm1p2_svt_lp L=6e-08 W=5.85e-07
MI8_MXPA1_3 ECK neck VDD VDD pm1p2_svt_lp L=6e-08 W=5.85e-07
MI8_MXPA1_4 ECK neck VDD VDD pm1p2_svt_lp L=6e-08 W=5.85e-07
MI8_MXPA1_5 ECK neck VDD VDD pm1p2_svt_lp L=6e-08 W=5.85e-07
MI8_MXPA1_6 ECK neck VDD VDD pm1p2_svt_lp L=6e-08 W=5.85e-07
MI8_MXPA1_7 ECK neck VDD VDD pm1p2_svt_lp L=6e-08 W=5.85e-07
MI8_MXPA1_8 ECK neck VDD VDD pm1p2_svt_lp L=6e-08 W=5.85e-07
MI8_MXPA1_9 ECK neck VDD VDD pm1p2_svt_lp L=6e-08 W=5.85e-07
MI8_MXPA1_10 ECK neck VDD VDD pm1p2_svt_lp L=6e-08 W=5.85e-07
MI8_MXPA1_11 ECK neck VDD VDD pm1p2_svt_lp L=6e-08 W=5.85e-07
.ENDS

.SUBCKT POSTICGX13H9R ECK VDD VSS CK E SEN
MI72_MXNA1 nck CK VSS VSS nm1p2_svt_lp L=6e-08 W=1.7e-07
MI74_MXNA1 ne E VSS VSS nm1p2_svt_lp L=6e-08 W=3.3e-07
MI20_MXNOE nm nck ne VSS nm1p2_svt_lp L=6e-08 W=3.3e-07
MI29_MXNOE nm CK XI29_n1 VSS nm1p2_svt_lp L=6e-08 W=1.5e-07
MI29_MXNA1 XI29_n1 m VSS VSS nm1p2_svt_lp L=6e-08 W=1.5e-07
MI1_MXNA2_2 XI1_n1__2 SEN VSS VSS nm1p2_svt_lp L=6e-08 W=3.25e-07
MI1_MXNA1_2 m nm XI1_n1__2 VSS nm1p2_svt_lp L=6e-08 W=3.25e-07
MI1_MXNA1 m nm XI1_n1 VSS nm1p2_svt_lp L=6e-08 W=3.25e-07
MI1_MXNA2 XI1_n1 SEN VSS VSS nm1p2_svt_lp L=6e-08 W=3.25e-07
MXN1_2 n1__2 m VSS VSS nm1p2_svt_lp L=6e-08 W=2.8e-07
MXN0_2 neck CK n1__2 VSS nm1p2_svt_lp L=6e-08 W=3.3e-07
MXN0_3 neck CK n1__3 VSS nm1p2_svt_lp L=6e-08 W=3.3e-07
MXN1_3 n1__3 m VSS VSS nm1p2_svt_lp L=6e-08 W=3.3e-07
MXN1_4 n1__4 m VSS VSS nm1p2_svt_lp L=6e-08 W=3.3e-07
MXN0_4 neck CK n1__4 VSS nm1p2_svt_lp L=6e-08 W=3.3e-07
MXN0_5 neck CK n1__5 VSS nm1p2_svt_lp L=6e-08 W=3.3e-07
MXN1_5 n1__5 m VSS VSS nm1p2_svt_lp L=6e-08 W=3.3e-07
MXN1 n1 m VSS VSS nm1p2_svt_lp L=6e-08 W=3.3e-07
MXN0 neck CK n1 VSS nm1p2_svt_lp L=6e-08 W=2.8e-07
MI8_MXNA1 ECK neck VSS VSS nm1p2_svt_lp L=6e-08 W=2.35e-07
MI8_MXNA1_2 ECK neck VSS VSS nm1p2_svt_lp L=6e-08 W=2.35e-07
MI8_MXNA1_3 ECK neck VSS VSS nm1p2_svt_lp L=6e-08 W=2.35e-07
MI8_MXNA1_4 ECK neck VSS VSS nm1p2_svt_lp L=6e-08 W=2.35e-07
MI8_MXNA1_5 ECK neck VSS VSS nm1p2_svt_lp L=6e-08 W=2.35e-07
MI8_MXNA1_6 ECK neck VSS VSS nm1p2_svt_lp L=6e-08 W=2.35e-07
MI8_MXNA1_7 ECK neck VSS VSS nm1p2_svt_lp L=6e-08 W=2.35e-07
MI8_MXNA1_8 ECK neck VSS VSS nm1p2_svt_lp L=6e-08 W=2.35e-07
MI8_MXNA1_9 ECK neck VSS VSS nm1p2_svt_lp L=6e-08 W=2.35e-07
MI8_MXNA1_10 ECK neck VSS VSS nm1p2_svt_lp L=6e-08 W=2.35e-07
MI8_MXNA1_11 ECK neck VSS VSS nm1p2_svt_lp L=6e-08 W=2.35e-07
MI8_MXNA1_12 ECK neck VSS VSS nm1p2_svt_lp L=6e-08 W=2.35e-07
MI8_MXNA1_13 ECK neck VSS VSS nm1p2_svt_lp L=6e-08 W=2.35e-07
MI72_MXPA1 nck CK VDD VDD pm1p2_svt_lp L=6e-08 W=2.3e-07
MI74_MXPA1 ne E VDD VDD pm1p2_svt_lp L=6e-08 W=4.6e-07
MI20_MXPOEN nm CK ne VDD pm1p2_svt_lp L=6e-08 W=3.3e-07
MI29_MXPOEN nm nck XI29_p1 VDD pm1p2_svt_lp L=6e-08 W=1.5e-07
MI29_MXPA1 XI29_p1 m VDD VDD pm1p2_svt_lp L=6e-08 W=1.5e-07
MI1_MXPA2 m SEN VDD VDD pm1p2_svt_lp L=6e-08 W=2.9e-07
MI1_MXPA1 m nm VDD VDD pm1p2_svt_lp L=6e-08 W=2.9e-07
MI1_MXPA1_2 m nm VDD VDD pm1p2_svt_lp L=6e-08 W=2.9e-07
MI1_MXPA2_2 m SEN VDD VDD pm1p2_svt_lp L=6e-08 W=2.9e-07
MXP1 neck CK VDD VDD pm1p2_svt_lp L=6e-08 W=5.95e-07
MXP1_2 neck CK VDD VDD pm1p2_svt_lp L=6e-08 W=5.95e-07
MXP1_3 neck CK VDD VDD pm1p2_svt_lp L=6e-08 W=5.95e-07
MXP1_4 neck CK VDD VDD pm1p2_svt_lp L=6e-08 W=5.95e-07
MXP0 neck m VDD VDD pm1p2_svt_lp L=6e-08 W=2.4e-07
MXP1_5 neck CK VDD VDD pm1p2_svt_lp L=6e-08 W=2.95e-07
MI8_MXPA1 ECK neck VDD VDD pm1p2_svt_lp L=6e-08 W=5.85e-07
MI8_MXPA1_2 ECK neck VDD VDD pm1p2_svt_lp L=6e-08 W=5.85e-07
MI8_MXPA1_3 ECK neck VDD VDD pm1p2_svt_lp L=6e-08 W=5.85e-07
MI8_MXPA1_4 ECK neck VDD VDD pm1p2_svt_lp L=6e-08 W=5.85e-07
MI8_MXPA1_5 ECK neck VDD VDD pm1p2_svt_lp L=6e-08 W=5.85e-07
MI8_MXPA1_6 ECK neck VDD VDD pm1p2_svt_lp L=6e-08 W=5.85e-07
MI8_MXPA1_7 ECK neck VDD VDD pm1p2_svt_lp L=6e-08 W=5.85e-07
MI8_MXPA1_8 ECK neck VDD VDD pm1p2_svt_lp L=6e-08 W=5.85e-07
MI8_MXPA1_9 ECK neck VDD VDD pm1p2_svt_lp L=6e-08 W=5.85e-07
MI8_MXPA1_10 ECK neck VDD VDD pm1p2_svt_lp L=6e-08 W=5.85e-07
MI8_MXPA1_11 ECK neck VDD VDD pm1p2_svt_lp L=6e-08 W=5.85e-07
MI8_MXPA1_12 ECK neck VDD VDD pm1p2_svt_lp L=6e-08 W=5.85e-07
MI8_MXPA1_13 ECK neck VDD VDD pm1p2_svt_lp L=6e-08 W=5.85e-07
.ENDS

.SUBCKT POSTICGX16H9R ECK VDD VSS CK E SEN
MI72_MXNA1 nck CK VSS VSS nm1p2_svt_lp L=6e-08 W=1.5e-07
MI74_MXNA1 ne E VSS VSS nm1p2_svt_lp L=6e-08 W=3.5e-07
MI20_MXNOE nm nck ne VSS nm1p2_svt_lp L=6e-08 W=3.5e-07
MI29_MXNOE nm CK XI29_n1 VSS nm1p2_svt_lp L=6e-08 W=1.5e-07
MI29_MXNA1 XI29_n1 m VSS VSS nm1p2_svt_lp L=6e-08 W=1.5e-07
MI1_MXNA2_2 XI1_n1__2 SEN VSS VSS nm1p2_svt_lp L=6e-08 W=3.6e-07
MI1_MXNA1_2 m nm XI1_n1__2 VSS nm1p2_svt_lp L=6e-08 W=3.6e-07
MI1_MXNA1 m nm XI1_n1 VSS nm1p2_svt_lp L=6e-08 W=3.6e-07
MI1_MXNA2 XI1_n1 SEN VSS VSS nm1p2_svt_lp L=6e-08 W=3.6e-07
MXN1_2 n1__2 m VSS VSS nm1p2_svt_lp L=6e-08 W=3.3e-07
MXN0_2 neck CK n1__2 VSS nm1p2_svt_lp L=6e-08 W=3.3e-07
MXN0_3 neck CK n1__3 VSS nm1p2_svt_lp L=6e-08 W=3.3e-07
MXN1_3 n1__3 m VSS VSS nm1p2_svt_lp L=6e-08 W=3.3e-07
MXN1_4 n1__4 m VSS VSS nm1p2_svt_lp L=6e-08 W=3.3e-07
MXN0_4 neck CK n1__4 VSS nm1p2_svt_lp L=6e-08 W=3.3e-07
MXN0_5 neck CK n1__5 VSS nm1p2_svt_lp L=6e-08 W=3.3e-07
MXN1_5 n1__5 m VSS VSS nm1p2_svt_lp L=6e-08 W=3.3e-07
MXN1 n1 m VSS VSS nm1p2_svt_lp L=6e-08 W=3.3e-07
MXN0 neck CK n1 VSS nm1p2_svt_lp L=6e-08 W=3.3e-07
MI8_MXNA1 ECK neck VSS VSS nm1p2_svt_lp L=6e-08 W=2.35e-07
MI8_MXNA1_2 ECK neck VSS VSS nm1p2_svt_lp L=6e-08 W=2.35e-07
MI8_MXNA1_3 ECK neck VSS VSS nm1p2_svt_lp L=6e-08 W=2.35e-07
MI8_MXNA1_4 ECK neck VSS VSS nm1p2_svt_lp L=6e-08 W=2.35e-07
MI8_MXNA1_5 ECK neck VSS VSS nm1p2_svt_lp L=6e-08 W=2.35e-07
MI8_MXNA1_6 ECK neck VSS VSS nm1p2_svt_lp L=6e-08 W=2.35e-07
MI8_MXNA1_7 ECK neck VSS VSS nm1p2_svt_lp L=6e-08 W=2.35e-07
MI8_MXNA1_8 ECK neck VSS VSS nm1p2_svt_lp L=6e-08 W=2.35e-07
MI8_MXNA1_9 ECK neck VSS VSS nm1p2_svt_lp L=6e-08 W=2.35e-07
MI8_MXNA1_10 ECK neck VSS VSS nm1p2_svt_lp L=6e-08 W=2.35e-07
MI8_MXNA1_11 ECK neck VSS VSS nm1p2_svt_lp L=6e-08 W=2.35e-07
MI8_MXNA1_12 ECK neck VSS VSS nm1p2_svt_lp L=6e-08 W=2.35e-07
MI8_MXNA1_13 ECK neck VSS VSS nm1p2_svt_lp L=6e-08 W=2.35e-07
MI8_MXNA1_14 ECK neck VSS VSS nm1p2_svt_lp L=6e-08 W=2.35e-07
MI8_MXNA1_15 ECK neck VSS VSS nm1p2_svt_lp L=6e-08 W=2.35e-07
MI8_MXNA1_16 ECK neck VSS VSS nm1p2_svt_lp L=6e-08 W=2.35e-07
MI72_MXPA1 nck CK VDD VDD pm1p2_svt_lp L=6e-08 W=2.1e-07
MI74_MXPA1 ne E VDD VDD pm1p2_svt_lp L=6e-08 W=4.9e-07
MI20_MXPOEN nm CK ne VDD pm1p2_svt_lp L=6e-08 W=3.5e-07
MI29_MXPOEN nm nck XI29_p1 VDD pm1p2_svt_lp L=6e-08 W=1.5e-07
MI29_MXPA1 XI29_p1 m VDD VDD pm1p2_svt_lp L=6e-08 W=1.5e-07
MI1_MXPA2 m SEN VDD VDD pm1p2_svt_lp L=6e-08 W=2.9e-07
MI1_MXPA1 m nm VDD VDD pm1p2_svt_lp L=6e-08 W=2.9e-07
MI1_MXPA1_2 m nm VDD VDD pm1p2_svt_lp L=6e-08 W=2.9e-07
MI1_MXPA2_2 m SEN VDD VDD pm1p2_svt_lp L=6e-08 W=2.9e-07
MXP1 neck CK VDD VDD pm1p2_svt_lp L=6e-08 W=5.95e-07
MXP1_2 neck CK VDD VDD pm1p2_svt_lp L=6e-08 W=5.95e-07
MXP1_3 neck CK VDD VDD pm1p2_svt_lp L=6e-08 W=5.95e-07
MXP1_4 neck CK VDD VDD pm1p2_svt_lp L=6e-08 W=5.95e-07
MXP0 neck m VDD VDD pm1p2_svt_lp L=6e-08 W=2.8e-07
MXP1_5 neck CK VDD VDD pm1p2_svt_lp L=6e-08 W=5.95e-07
MI8_MXPA1 ECK neck VDD VDD pm1p2_svt_lp L=6e-08 W=5.85e-07
MI8_MXPA1_2 ECK neck VDD VDD pm1p2_svt_lp L=6e-08 W=5.85e-07
MI8_MXPA1_3 ECK neck VDD VDD pm1p2_svt_lp L=6e-08 W=5.85e-07
MI8_MXPA1_4 ECK neck VDD VDD pm1p2_svt_lp L=6e-08 W=5.85e-07
MI8_MXPA1_5 ECK neck VDD VDD pm1p2_svt_lp L=6e-08 W=5.85e-07
MI8_MXPA1_6 ECK neck VDD VDD pm1p2_svt_lp L=6e-08 W=5.85e-07
MI8_MXPA1_7 ECK neck VDD VDD pm1p2_svt_lp L=6e-08 W=5.85e-07
MI8_MXPA1_8 ECK neck VDD VDD pm1p2_svt_lp L=6e-08 W=5.85e-07
MI8_MXPA1_9 ECK neck VDD VDD pm1p2_svt_lp L=6e-08 W=5.85e-07
MI8_MXPA1_10 ECK neck VDD VDD pm1p2_svt_lp L=6e-08 W=5.85e-07
MI8_MXPA1_11 ECK neck VDD VDD pm1p2_svt_lp L=6e-08 W=5.85e-07
MI8_MXPA1_12 ECK neck VDD VDD pm1p2_svt_lp L=6e-08 W=5.85e-07
MI8_MXPA1_13 ECK neck VDD VDD pm1p2_svt_lp L=6e-08 W=5.85e-07
MI8_MXPA1_14 ECK neck VDD VDD pm1p2_svt_lp L=6e-08 W=5.85e-07
MI8_MXPA1_15 ECK neck VDD VDD pm1p2_svt_lp L=6e-08 W=5.85e-07
MI8_MXPA1_16 ECK neck VDD VDD pm1p2_svt_lp L=6e-08 W=5.85e-07
.ENDS

.SUBCKT DFFQX0P5H9R Q VDD VSS CK D
MI68_MXNA1 nd D VSS VSS nm1p2_svt_lp L=6e-08 W=2.3e-07
MI33_MXNOE nm nclk nd VSS nm1p2_svt_lp L=6e-08 W=1.5e-07
MI31_MXNOE nm bclk XI31_n1 VSS nm1p2_svt_lp L=6e-08 W=1.5e-07
MI31_MXNA1 XI31_n1 m VSS VSS nm1p2_svt_lp L=6e-08 W=1.5e-07
MI32_MXNA1 m nm VSS VSS nm1p2_svt_lp L=6e-08 W=1.5e-07
MI20_MXNOE s bclk m VSS nm1p2_svt_lp L=6e-08 W=1.5e-07
MI29_MXNOE s nclk XI29_n1 VSS nm1p2_svt_lp L=6e-08 W=1.5e-07
MI29_MXNA1 XI29_n1 ns VSS VSS nm1p2_svt_lp L=6e-08 W=1.5e-07
MI28_MXNA1 ns s VSS VSS nm1p2_svt_lp L=6e-08 W=1.5e-07
MI8_MXNA1 Q ns VSS VSS nm1p2_svt_lp L=6e-08 W=2.1e-07
MI23_MXNA1 bclk nclk VSS VSS nm1p2_svt_lp L=6e-08 W=1.5e-07
MI22_MXNA1 nclk CK VSS VSS nm1p2_svt_lp L=6e-08 W=1.5e-07
MI68_MXPA1 nd D VDD VDD pm1p2_svt_lp L=6e-08 W=1.6e-07
MI33_MXPOEN nm bclk nd VDD pm1p2_svt_lp L=6e-08 W=1.5e-07
MI31_MXPOEN nm nclk XI31_p1 VDD pm1p2_svt_lp L=6e-08 W=1.5e-07
MI31_MXPA1 XI31_p1 m VDD VDD pm1p2_svt_lp L=6e-08 W=1.5e-07
MI32_MXPA1 m nm VDD VDD pm1p2_svt_lp L=6e-08 W=1.6e-07
MI20_MXPOEN s nclk m VDD pm1p2_svt_lp L=6e-08 W=1.5e-07
MI29_MXPOEN s bclk XI29_p1 VDD pm1p2_svt_lp L=6e-08 W=1.5e-07
MI29_MXPA1 XI29_p1 ns VDD VDD pm1p2_svt_lp L=6e-08 W=1.5e-07
MI28_MXPA1 ns s VDD VDD pm1p2_svt_lp L=6e-08 W=2.1e-07
MI8_MXPA1 Q ns VDD VDD pm1p2_svt_lp L=6e-08 W=2.95e-07
MI23_MXPA1 bclk nclk VDD VDD pm1p2_svt_lp L=6e-08 W=1.9e-07
MI22_MXPA1 nclk CK VDD VDD pm1p2_svt_lp L=6e-08 W=1.7e-07
.ENDS

.SUBCKT DFFQX1H9R Q VDD VSS CK D
MI68_MXNA1 nd D VSS VSS nm1p2_svt_lp L=6e-08 W=3.55e-07
MI33_MXNOE nm nclk nd VSS nm1p2_svt_lp L=6e-08 W=2.6e-07
MI31_MXNOE nm bclk XI31_n1 VSS nm1p2_svt_lp L=6e-08 W=1.5e-07
MI31_MXNA1 XI31_n1 m VSS VSS nm1p2_svt_lp L=6e-08 W=1.5e-07
MI32_MXNA1 m nm VSS VSS nm1p2_svt_lp L=6e-08 W=2.2e-07
MI20_MXNOE s bclk m VSS nm1p2_svt_lp L=6e-08 W=2.6e-07
MI29_MXNOE s nclk XI29_n1 VSS nm1p2_svt_lp L=6e-08 W=1.5e-07
MI29_MXNA1 XI29_n1 ns VSS VSS nm1p2_svt_lp L=6e-08 W=1.5e-07
MI28_MXNA1 ns s VSS VSS nm1p2_svt_lp L=6e-08 W=2.05e-07
MI8_MXNA1 Q ns VSS VSS nm1p2_svt_lp L=6e-08 W=4.2e-07
MI23_MXNA1 bclk nclk VSS VSS nm1p2_svt_lp L=6e-08 W=1.5e-07
MI22_MXNA1 nclk CK VSS VSS nm1p2_svt_lp L=6e-08 W=1.7e-07
MI68_MXPA1 nd D VDD VDD pm1p2_svt_lp L=6e-08 W=2.6e-07
MI33_MXPOEN nm bclk nd VDD pm1p2_svt_lp L=6e-08 W=2.6e-07
MI31_MXPOEN nm nclk XI31_p1 VDD pm1p2_svt_lp L=6e-08 W=1.5e-07
MI31_MXPA1 XI31_p1 m VDD VDD pm1p2_svt_lp L=6e-08 W=1.5e-07
MI32_MXPA1 m nm VDD VDD pm1p2_svt_lp L=6e-08 W=3.4e-07
MI20_MXPOEN s nclk m VDD pm1p2_svt_lp L=6e-08 W=2.6e-07
MI29_MXPOEN s bclk XI29_p1 VDD pm1p2_svt_lp L=6e-08 W=1.5e-07
MI29_MXPA1 XI29_p1 ns VDD VDD pm1p2_svt_lp L=6e-08 W=1.5e-07
MI28_MXPA1 ns s VDD VDD pm1p2_svt_lp L=6e-08 W=3.5e-07
MI8_MXPA1 Q ns VDD VDD pm1p2_svt_lp L=6e-08 W=5.85e-07
MI23_MXPA1 bclk nclk VDD VDD pm1p2_svt_lp L=6e-08 W=3e-07
MI22_MXPA1 nclk CK VDD VDD pm1p2_svt_lp L=6e-08 W=1.9e-07
.ENDS

.SUBCKT DFFQX2H9R Q VDD VSS CK D
MI68_MXNA1 nd D VSS VSS nm1p2_svt_lp L=6e-08 W=4.2e-07
MI33_MXNOE nm nclk nd VSS nm1p2_svt_lp L=6e-08 W=3.2e-07
MI31_MXNOE nm bclk XI31_n1 VSS nm1p2_svt_lp L=6e-08 W=1.5e-07
MI31_MXNA1 XI31_n1 m VSS VSS nm1p2_svt_lp L=6e-08 W=1.5e-07
MI32_MXNA1 m nm VSS VSS nm1p2_svt_lp L=6e-08 W=2.9e-07
MI20_MXNOE s bclk m VSS nm1p2_svt_lp L=6e-08 W=3.2e-07
MI29_MXNOE s nclk XI29_n1 VSS nm1p2_svt_lp L=6e-08 W=1.5e-07
MI29_MXNA1 XI29_n1 ns VSS VSS nm1p2_svt_lp L=6e-08 W=1.5e-07
MI28_MXNA1 ns s VSS VSS nm1p2_svt_lp L=6e-08 W=2.5e-07
MI8_MXNA1 Q ns VSS VSS nm1p2_svt_lp L=6e-08 W=4.2e-07
MI8_MXNA1_2 Q ns VSS VSS nm1p2_svt_lp L=6e-08 W=4.2e-07
MI23_MXNA1 bclk nclk VSS VSS nm1p2_svt_lp L=6e-08 W=1.7e-07
MI22_MXNA1 nclk CK VSS VSS nm1p2_svt_lp L=6e-08 W=2.1e-07
MI68_MXPA1 nd D VDD VDD pm1p2_svt_lp L=6e-08 W=3.2e-07
MI33_MXPOEN nm bclk nd VDD pm1p2_svt_lp L=6e-08 W=3.2e-07
MI31_MXPOEN nm nclk XI31_p1 VDD pm1p2_svt_lp L=6e-08 W=1.5e-07
MI31_MXPA1 XI31_p1 m VDD VDD pm1p2_svt_lp L=6e-08 W=1.5e-07
MI32_MXPA1 m nm VDD VDD pm1p2_svt_lp L=6e-08 W=4.4e-07
MI20_MXPOEN s nclk m VDD pm1p2_svt_lp L=6e-08 W=3.2e-07
MI29_MXPOEN s bclk XI29_p1 VDD pm1p2_svt_lp L=6e-08 W=1.5e-07
MI29_MXPA1 XI29_p1 ns VDD VDD pm1p2_svt_lp L=6e-08 W=1.5e-07
MI28_MXPA1 ns s VDD VDD pm1p2_svt_lp L=6e-08 W=4.7e-07
MI8_MXPA1 Q ns VDD VDD pm1p2_svt_lp L=6e-08 W=5.85e-07
MI8_MXPA1_2 Q ns VDD VDD pm1p2_svt_lp L=6e-08 W=5.85e-07
MI23_MXPA1 bclk nclk VDD VDD pm1p2_svt_lp L=6e-08 W=3.3e-07
MI22_MXPA1 nclk CK VDD VDD pm1p2_svt_lp L=6e-08 W=2.3e-07
.ENDS

.SUBCKT DFFQX3H9R Q VDD VSS CK D
MI22_MXNA1 nclk CK VSS VSS nm1p2_svt_lp L=6e-08 W=2.2e-07
MI23_MXNA1 bclk nclk VSS VSS nm1p2_svt_lp L=6e-08 W=1.8e-07
MI68_MXNA1 nd D VSS VSS nm1p2_svt_lp L=6e-08 W=4.5e-07
MI33_MXNOE nm nclk nd VSS nm1p2_svt_lp L=6e-08 W=3.9e-07
MI31_MXNOE nm bclk XI31_n1 VSS nm1p2_svt_lp L=6e-08 W=1.5e-07
MI31_MXNA1 XI31_n1 m VSS VSS nm1p2_svt_lp L=6e-08 W=1.5e-07
MI32_MXNA1 m nm VSS VSS nm1p2_svt_lp L=6e-08 W=3.9e-07
MI20_MXNOE s bclk m VSS nm1p2_svt_lp L=6e-08 W=3.9e-07
MI29_MXNOE s nclk XI29_n1 VSS nm1p2_svt_lp L=6e-08 W=1.5e-07
MI29_MXNA1 XI29_n1 ns VSS VSS nm1p2_svt_lp L=6e-08 W=1.5e-07
MI28_MXNA1 ns s VSS VSS nm1p2_svt_lp L=6e-08 W=2.9e-07
MI8_MXNA1 Q ns VSS VSS nm1p2_svt_lp L=6e-08 W=4.2e-07
MI8_MXNA1_2 Q ns VSS VSS nm1p2_svt_lp L=6e-08 W=4.2e-07
MI8_MXNA1_3 Q ns VSS VSS nm1p2_svt_lp L=6e-08 W=4.2e-07
MI22_MXPA1 nclk CK VDD VDD pm1p2_svt_lp L=6e-08 W=2.4e-07
MI23_MXPA1 bclk nclk VDD VDD pm1p2_svt_lp L=6e-08 W=3.6e-07
MI68_MXPA1 nd D VDD VDD pm1p2_svt_lp L=6e-08 W=3.2e-07
MI33_MXPOEN nm bclk nd VDD pm1p2_svt_lp L=6e-08 W=3.9e-07
MI31_MXPOEN nm nclk XI31_p1 VDD pm1p2_svt_lp L=6e-08 W=1.5e-07
MI31_MXPA1 XI31_p1 m VDD VDD pm1p2_svt_lp L=6e-08 W=1.5e-07
MI32_MXPA1 m nm VDD VDD pm1p2_svt_lp L=6e-08 W=5.2e-07
MI20_MXPOEN s nclk m VDD pm1p2_svt_lp L=6e-08 W=3.9e-07
MI29_MXPOEN s bclk XI29_p1 VDD pm1p2_svt_lp L=6e-08 W=1.5e-07
MI29_MXPA1 XI29_p1 ns VDD VDD pm1p2_svt_lp L=6e-08 W=1.5e-07
MI28_MXPA1 ns s VDD VDD pm1p2_svt_lp L=6e-08 W=5.4e-07
MI8_MXPA1 Q ns VDD VDD pm1p2_svt_lp L=6e-08 W=5.85e-07
MI8_MXPA1_2 Q ns VDD VDD pm1p2_svt_lp L=6e-08 W=5.85e-07
MI8_MXPA1_3 Q ns VDD VDD pm1p2_svt_lp L=6e-08 W=5.85e-07
.ENDS

.SUBCKT DFFQX4H9R Q VDD VSS CK D
MI22_MXNA1 nclk CK VSS VSS nm1p2_svt_lp L=6e-08 W=2.5e-07
MI23_MXNA1 bclk nclk VSS VSS nm1p2_svt_lp L=6e-08 W=2.1e-07
MI68_MXNA1 nd D VSS VSS nm1p2_svt_lp L=6e-08 W=4.95e-07
MI33_MXNOE nm nclk nd VSS nm1p2_svt_lp L=6e-08 W=4.5e-07
MI31_MXNOE nm bclk XI31_n1 VSS nm1p2_svt_lp L=6e-08 W=1.5e-07
MI31_MXNA1 XI31_n1 m VSS VSS nm1p2_svt_lp L=6e-08 W=1.5e-07
MI32_MXNA1 m nm VSS VSS nm1p2_svt_lp L=6e-08 W=4.2e-07
MI20_MXNOE s bclk m VSS nm1p2_svt_lp L=6e-08 W=4.5e-07
MI29_MXNOE s nclk XI29_n1 VSS nm1p2_svt_lp L=6e-08 W=1.5e-07
MI29_MXNA1 XI29_n1 ns VSS VSS nm1p2_svt_lp L=6e-08 W=1.5e-07
MI28_MXNA1 ns s VSS VSS nm1p2_svt_lp L=6e-08 W=3.2e-07
MI28_MXNA1_2 ns s VSS VSS nm1p2_svt_lp L=6e-08 W=3.2e-07
MI8_MXNA1 Q ns VSS VSS nm1p2_svt_lp L=6e-08 W=4.2e-07
MI8_MXNA1_2 Q ns VSS VSS nm1p2_svt_lp L=6e-08 W=4.2e-07
MI8_MXNA1_3 Q ns VSS VSS nm1p2_svt_lp L=6e-08 W=4.2e-07
MI8_MXNA1_4 Q ns VSS VSS nm1p2_svt_lp L=6e-08 W=4.2e-07
MI22_MXPA1 nclk CK VDD VDD pm1p2_svt_lp L=6e-08 W=2.8e-07
MI23_MXPA1 bclk nclk VDD VDD pm1p2_svt_lp L=6e-08 W=4.2e-07
MI68_MXPA1 nd D VDD VDD pm1p2_svt_lp L=6e-08 W=3.8e-07
MI33_MXPOEN nm bclk nd VDD pm1p2_svt_lp L=6e-08 W=4.5e-07
MI31_MXPOEN nm nclk XI31_p1 VDD pm1p2_svt_lp L=6e-08 W=1.5e-07
MI31_MXPA1 XI31_p1 m VDD VDD pm1p2_svt_lp L=6e-08 W=1.5e-07
MI32_MXPA1 m nm VDD VDD pm1p2_svt_lp L=6e-08 W=5.85e-07
MI20_MXPOEN s nclk m VDD pm1p2_svt_lp L=6e-08 W=4.5e-07
MI29_MXPOEN s bclk XI29_p1 VDD pm1p2_svt_lp L=6e-08 W=1.5e-07
MI29_MXPA1 XI29_p1 ns VDD VDD pm1p2_svt_lp L=6e-08 W=1.5e-07
MI28_MXPA1 ns s VDD VDD pm1p2_svt_lp L=6e-08 W=4.8e-07
MI28_MXPA1_2 ns s VDD VDD pm1p2_svt_lp L=6e-08 W=4.8e-07
MI8_MXPA1 Q ns VDD VDD pm1p2_svt_lp L=6e-08 W=5.85e-07
MI8_MXPA1_2 Q ns VDD VDD pm1p2_svt_lp L=6e-08 W=5.85e-07
MI8_MXPA1_3 Q ns VDD VDD pm1p2_svt_lp L=6e-08 W=5.85e-07
MI8_MXPA1_4 Q ns VDD VDD pm1p2_svt_lp L=6e-08 W=5.85e-07
.ENDS

.SUBCKT DFF2DQX1H9R Q VDD VSS CK D
MI22_MXNA1 nclk CK VSS VSS nm1p2_svt_lp L=6e-08 W=2.85e-07
MI23_MXNA1 bclk nclk VSS VSS nm1p2_svt_lp L=6e-08 W=2.3e-07
MI68_MXNA1 nd D VSS VSS nm1p2_svt_lp L=6e-08 W=3.4e-07
MI33_MXNOE nm nclk nd VSS nm1p2_svt_lp L=6e-08 W=2.6e-07
MI31_MXNOE nm bclk XI31_n1 VSS nm1p2_svt_lp L=6e-08 W=3e-07
MI31_MXNA1 XI31_n1 m VSS VSS nm1p2_svt_lp L=6e-08 W=3e-07
MI32_MXNA1 m nm VSS VSS nm1p2_svt_lp L=6e-08 W=2.2e-07
MI20_MXNOE s bclk m VSS nm1p2_svt_lp L=6e-08 W=2.6e-07
MI29_MXNOE s nclk XI29_n1 VSS nm1p2_svt_lp L=6e-08 W=3e-07
MI29_MXNA1 XI29_n1 ns VSS VSS nm1p2_svt_lp L=6e-08 W=3e-07
MI28_MXNA1 ns s VSS VSS nm1p2_svt_lp L=6e-08 W=2.2e-07
MI8_MXNA1 Q ns VSS VSS nm1p2_svt_lp L=6e-08 W=4.2e-07
MI22_MXPA1 nclk CK VDD VDD pm1p2_svt_lp L=6e-08 W=3.15e-07
MI23_MXPA1 bclk nclk VDD VDD pm1p2_svt_lp L=6e-08 W=4.6e-07
MI68_MXPA1 nd D VDD VDD pm1p2_svt_lp L=6e-08 W=3.4e-07
MI33_MXPOEN nm bclk nd VDD pm1p2_svt_lp L=6e-08 W=2.6e-07
MI31_MXPOEN nm nclk XI31_p1 VDD pm1p2_svt_lp L=6e-08 W=3e-07
MI31_MXPA1 XI31_p1 m VDD VDD pm1p2_svt_lp L=6e-08 W=3e-07
MI32_MXPA1 m nm VDD VDD pm1p2_svt_lp L=6e-08 W=3.8e-07
MI20_MXPOEN s nclk m VDD pm1p2_svt_lp L=6e-08 W=2.6e-07
MI29_MXPOEN s bclk XI29_p1 VDD pm1p2_svt_lp L=6e-08 W=3e-07
MI29_MXPA1 XI29_p1 ns VDD VDD pm1p2_svt_lp L=6e-08 W=3e-07
MI28_MXPA1 ns s VDD VDD pm1p2_svt_lp L=6e-08 W=3.5e-07
MI8_MXPA1 Q ns VDD VDD pm1p2_svt_lp L=6e-08 W=5.85e-07
.ENDS

.SUBCKT DFF2DQX2H9R Q VDD VSS CK D
MI22_MXNA1 nclk CK VSS VSS nm1p2_svt_lp L=6e-08 W=3.1e-07
MI23_MXNA1 bclk nclk VSS VSS nm1p2_svt_lp L=6e-08 W=2.4e-07
MI68_MXNA1 nd D VSS VSS nm1p2_svt_lp L=6e-08 W=4.2e-07
MI33_MXNOE nm nclk nd VSS nm1p2_svt_lp L=6e-08 W=3.2e-07
MI31_MXNOE nm bclk XI31_n1 VSS nm1p2_svt_lp L=6e-08 W=3e-07
MI31_MXNA1 XI31_n1 m VSS VSS nm1p2_svt_lp L=6e-08 W=3e-07
MI32_MXNA1 m nm VSS VSS nm1p2_svt_lp L=6e-08 W=2.9e-07
MI20_MXNOE s bclk m VSS nm1p2_svt_lp L=6e-08 W=3.2e-07
MI29_MXNOE s nclk XI29_n1 VSS nm1p2_svt_lp L=6e-08 W=3e-07
MI29_MXNA1 XI29_n1 ns VSS VSS nm1p2_svt_lp L=6e-08 W=3e-07
MI28_MXNA1 ns s VSS VSS nm1p2_svt_lp L=6e-08 W=3e-07
MI8_MXNA1 Q ns VSS VSS nm1p2_svt_lp L=6e-08 W=4.2e-07
MI8_MXNA1_2 Q ns VSS VSS nm1p2_svt_lp L=6e-08 W=4.2e-07
MI22_MXPA1 nclk CK VDD VDD pm1p2_svt_lp L=6e-08 W=3.4e-07
MI23_MXPA1 bclk nclk VDD VDD pm1p2_svt_lp L=6e-08 W=4.8e-07
MI68_MXPA1 nd D VDD VDD pm1p2_svt_lp L=6e-08 W=3.8e-07
MI33_MXPOEN nm bclk nd VDD pm1p2_svt_lp L=6e-08 W=3.2e-07
MI31_MXPOEN nm nclk XI31_p1 VDD pm1p2_svt_lp L=6e-08 W=3e-07
MI31_MXPA1 XI31_p1 m VDD VDD pm1p2_svt_lp L=6e-08 W=3e-07
MI32_MXPA1 m nm VDD VDD pm1p2_svt_lp L=6e-08 W=4.6e-07
MI20_MXPOEN s nclk m VDD pm1p2_svt_lp L=6e-08 W=3.2e-07
MI29_MXPOEN s bclk XI29_p1 VDD pm1p2_svt_lp L=6e-08 W=3e-07
MI29_MXPA1 XI29_p1 ns VDD VDD pm1p2_svt_lp L=6e-08 W=3e-07
MI28_MXPA1 ns s VDD VDD pm1p2_svt_lp L=6e-08 W=4.7e-07
MI8_MXPA1 Q ns VDD VDD pm1p2_svt_lp L=6e-08 W=5.85e-07
MI8_MXPA1_2 Q ns VDD VDD pm1p2_svt_lp L=6e-08 W=5.85e-07
.ENDS

.SUBCKT DFF2DQX3H9R Q VDD VSS CK D
MI22_MXNA1 nclk CK VSS VSS nm1p2_svt_lp L=6e-08 W=3.5e-07
MI23_MXNA1 bclk nclk VSS VSS nm1p2_svt_lp L=6e-08 W=2.6e-07
MI68_MXNA1 nd D VSS VSS nm1p2_svt_lp L=6e-08 W=4.5e-07
MI33_MXNOE nm nclk nd VSS nm1p2_svt_lp L=6e-08 W=3.9e-07
MI31_MXNOE nm bclk XI31_n1 VSS nm1p2_svt_lp L=6e-08 W=3e-07
MI31_MXNA1 XI31_n1 m VSS VSS nm1p2_svt_lp L=6e-08 W=3e-07
MI32_MXNA1 m nm VSS VSS nm1p2_svt_lp L=6e-08 W=3.9e-07
MI20_MXNOE s bclk m VSS nm1p2_svt_lp L=6e-08 W=3.9e-07
MI29_MXNOE s nclk XI29_n1 VSS nm1p2_svt_lp L=6e-08 W=3e-07
MI29_MXNA1 XI29_n1 ns VSS VSS nm1p2_svt_lp L=6e-08 W=3e-07
MI28_MXNA1 ns s VSS VSS nm1p2_svt_lp L=6e-08 W=3.3e-07
MI8_MXNA1 Q ns VSS VSS nm1p2_svt_lp L=6e-08 W=4.2e-07
MI8_MXNA1_2 Q ns VSS VSS nm1p2_svt_lp L=6e-08 W=4.2e-07
MI8_MXNA1_3 Q ns VSS VSS nm1p2_svt_lp L=6e-08 W=4.2e-07
MI22_MXPA1 nclk CK VDD VDD pm1p2_svt_lp L=6e-08 W=3.85e-07
MI23_MXPA1 bclk nclk VDD VDD pm1p2_svt_lp L=6e-08 W=5.2e-07
MI68_MXPA1 nd D VDD VDD pm1p2_svt_lp L=6e-08 W=3.8e-07
MI33_MXPOEN nm bclk nd VDD pm1p2_svt_lp L=6e-08 W=3.9e-07
MI31_MXPOEN nm nclk XI31_p1 VDD pm1p2_svt_lp L=6e-08 W=3e-07
MI31_MXPA1 XI31_p1 m VDD VDD pm1p2_svt_lp L=6e-08 W=3e-07
MI32_MXPA1 m nm VDD VDD pm1p2_svt_lp L=6e-08 W=5.4e-07
MI20_MXPOEN s nclk m VDD pm1p2_svt_lp L=6e-08 W=3.9e-07
MI29_MXPOEN s bclk XI29_p1 VDD pm1p2_svt_lp L=6e-08 W=3e-07
MI29_MXPA1 XI29_p1 ns VDD VDD pm1p2_svt_lp L=6e-08 W=3e-07
MI28_MXPA1 ns s VDD VDD pm1p2_svt_lp L=6e-08 W=5.4e-07
MI8_MXPA1 Q ns VDD VDD pm1p2_svt_lp L=6e-08 W=5.85e-07
MI8_MXPA1_2 Q ns VDD VDD pm1p2_svt_lp L=6e-08 W=5.85e-07
MI8_MXPA1_3 Q ns VDD VDD pm1p2_svt_lp L=6e-08 W=5.85e-07
.ENDS

.SUBCKT DFF2DQX4H9R Q VDD VSS CK D
MI22_MXNA1 nclk CK VSS VSS nm1p2_svt_lp L=6e-08 W=4e-07
MI23_MXNA1 bclk nclk VSS VSS nm1p2_svt_lp L=6e-08 W=3e-07
MI68_MXNA1 nd D VSS VSS nm1p2_svt_lp L=6e-08 W=4.95e-07
MI33_MXNOE nm nclk nd VSS nm1p2_svt_lp L=6e-08 W=4.5e-07
MI31_MXNOE nm bclk XI31_n1 VSS nm1p2_svt_lp L=6e-08 W=3e-07
MI31_MXNA1 XI31_n1 m VSS VSS nm1p2_svt_lp L=6e-08 W=3e-07
MI32_MXNA1 m nm VSS VSS nm1p2_svt_lp L=6e-08 W=4.2e-07
MI20_MXNOE s bclk m VSS nm1p2_svt_lp L=6e-08 W=4.5e-07
MI29_MXNOE s nclk XI29_n1 VSS nm1p2_svt_lp L=6e-08 W=3e-07
MI29_MXNA1 XI29_n1 ns VSS VSS nm1p2_svt_lp L=6e-08 W=3e-07
MI28_MXNA1 ns s VSS VSS nm1p2_svt_lp L=6e-08 W=3.8e-07
MI28_MXNA1_2 ns s VSS VSS nm1p2_svt_lp L=6e-08 W=3.8e-07
MI8_MXNA1 Q ns VSS VSS nm1p2_svt_lp L=6e-08 W=4.2e-07
MI8_MXNA1_2 Q ns VSS VSS nm1p2_svt_lp L=6e-08 W=4.2e-07
MI8_MXNA1_3 Q ns VSS VSS nm1p2_svt_lp L=6e-08 W=4.2e-07
MI8_MXNA1_4 Q ns VSS VSS nm1p2_svt_lp L=6e-08 W=4.2e-07
MI22_MXPA1 nclk CK VDD VDD pm1p2_svt_lp L=6e-08 W=4.4e-07
MI23_MXPA1 bclk nclk VDD VDD pm1p2_svt_lp L=6e-08 W=5.85e-07
MI68_MXPA1 nd D VDD VDD pm1p2_svt_lp L=6e-08 W=4.1e-07
MI33_MXPOEN nm bclk nd VDD pm1p2_svt_lp L=6e-08 W=4.5e-07
MI31_MXPOEN nm nclk XI31_p1 VDD pm1p2_svt_lp L=6e-08 W=3e-07
MI31_MXPA1 XI31_p1 m VDD VDD pm1p2_svt_lp L=6e-08 W=3e-07
MI32_MXPA1 m nm VDD VDD pm1p2_svt_lp L=6e-08 W=5.85e-07
MI20_MXPOEN s nclk m VDD pm1p2_svt_lp L=6e-08 W=4.5e-07
MI29_MXPOEN s bclk XI29_p1 VDD pm1p2_svt_lp L=6e-08 W=3e-07
MI29_MXPA1 XI29_p1 ns VDD VDD pm1p2_svt_lp L=6e-08 W=3e-07
MI28_MXPA1 ns s VDD VDD pm1p2_svt_lp L=6e-08 W=4.9e-07
MI28_MXPA1_2 ns s VDD VDD pm1p2_svt_lp L=6e-08 W=4.9e-07
MI8_MXPA1 Q ns VDD VDD pm1p2_svt_lp L=6e-08 W=5.85e-07
MI8_MXPA1_2 Q ns VDD VDD pm1p2_svt_lp L=6e-08 W=5.85e-07
MI8_MXPA1_3 Q ns VDD VDD pm1p2_svt_lp L=6e-08 W=5.85e-07
MI8_MXPA1_4 Q ns VDD VDD pm1p2_svt_lp L=6e-08 W=5.85e-07
.ENDS

.SUBCKT DFFQNX0P5H9R QN VDD VSS CK D
MI69_MXNA1 nd D VSS VSS nm1p2_svt_lp L=6e-08 W=2e-07
MI33_MXNOE nm nclk nd VSS nm1p2_svt_lp L=6e-08 W=1.5e-07
MI31_MXNOE nm bclk XI31_n1 VSS nm1p2_svt_lp L=6e-08 W=1.5e-07
MI31_MXNA1 XI31_n1 m VSS VSS nm1p2_svt_lp L=6e-08 W=1.5e-07
MI32_MXNA1 m nm VSS VSS nm1p2_svt_lp L=6e-08 W=1.5e-07
MI20_MXNOE s bclk m VSS nm1p2_svt_lp L=6e-08 W=1.5e-07
MI68_MXNOE s nclk XI68_n1 VSS nm1p2_svt_lp L=6e-08 W=1.5e-07
MI68_MXNA1 XI68_n1 ns VSS VSS nm1p2_svt_lp L=6e-08 W=1.5e-07
MI28_MXNA1 ns s VSS VSS nm1p2_svt_lp L=6e-08 W=1.2e-07
MI75_MXNA1 QN s VSS VSS nm1p2_svt_lp L=6e-08 W=2.1e-07
MI23_MXNA1 bclk nclk VSS VSS nm1p2_svt_lp L=6e-08 W=1.5e-07
MI22_MXNA1 nclk CK VSS VSS nm1p2_svt_lp L=6e-08 W=1.5e-07
MI69_MXPA1 nd D VDD VDD pm1p2_svt_lp L=6e-08 W=1.55e-07
MI33_MXPOEN nm bclk nd VDD pm1p2_svt_lp L=6e-08 W=1.5e-07
MI31_MXPOEN nm nclk XI31_p1 VDD pm1p2_svt_lp L=6e-08 W=1.5e-07
MI31_MXPA1 XI31_p1 m VDD VDD pm1p2_svt_lp L=6e-08 W=1.5e-07
MI32_MXPA1 m nm VDD VDD pm1p2_svt_lp L=6e-08 W=2e-07
MI20_MXPOEN s nclk m VDD pm1p2_svt_lp L=6e-08 W=1.5e-07
MI68_MXPOEN s bclk XI68_p1 VDD pm1p2_svt_lp L=6e-08 W=1.5e-07
MI68_MXPA1 XI68_p1 ns VDD VDD pm1p2_svt_lp L=6e-08 W=1.5e-07
MI28_MXPA1 ns s VDD VDD pm1p2_svt_lp L=6e-08 W=1.2e-07
MI75_MXPA1 QN s VDD VDD pm1p2_svt_lp L=6e-08 W=2.95e-07
MI23_MXPA1 bclk nclk VDD VDD pm1p2_svt_lp L=6e-08 W=1.9e-07
MI22_MXPA1 nclk CK VDD VDD pm1p2_svt_lp L=6e-08 W=1.7e-07
.ENDS

.SUBCKT DFFQNX1H9R QN VDD VSS CK D
MI69_MXNA1 nd D VSS VSS nm1p2_svt_lp L=6e-08 W=3.2e-07
MI33_MXNOE nm nclk nd VSS nm1p2_svt_lp L=6e-08 W=2.6e-07
MI31_MXNOE nm bclk XI31_n1 VSS nm1p2_svt_lp L=6e-08 W=1.5e-07
MI31_MXNA1 XI31_n1 m VSS VSS nm1p2_svt_lp L=6e-08 W=1.5e-07
MI32_MXNA1 m nm VSS VSS nm1p2_svt_lp L=6e-08 W=1.6e-07
MI20_MXNOE s bclk m VSS nm1p2_svt_lp L=6e-08 W=2.6e-07
MI68_MXNOE s nclk XI68_n1 VSS nm1p2_svt_lp L=6e-08 W=1.5e-07
MI68_MXNA1 XI68_n1 ns VSS VSS nm1p2_svt_lp L=6e-08 W=1.5e-07
MI28_MXNA1 ns s VSS VSS nm1p2_svt_lp L=6e-08 W=1.2e-07
MI75_MXNA1 QN s VSS VSS nm1p2_svt_lp L=6e-08 W=4.2e-07
MI23_MXNA1 bclk nclk VSS VSS nm1p2_svt_lp L=6e-08 W=1.5e-07
MI22_MXNA1 nclk CK VSS VSS nm1p2_svt_lp L=6e-08 W=1.7e-07
MI69_MXPA1 nd D VDD VDD pm1p2_svt_lp L=6e-08 W=2.5e-07
MI33_MXPOEN nm bclk nd VDD pm1p2_svt_lp L=6e-08 W=2.6e-07
MI31_MXPOEN nm nclk XI31_p1 VDD pm1p2_svt_lp L=6e-08 W=1.5e-07
MI31_MXPA1 XI31_p1 m VDD VDD pm1p2_svt_lp L=6e-08 W=1.5e-07
MI32_MXPA1 m nm VDD VDD pm1p2_svt_lp L=6e-08 W=2.4e-07
MI20_MXPOEN s nclk m VDD pm1p2_svt_lp L=6e-08 W=2.6e-07
MI68_MXPOEN s bclk XI68_p1 VDD pm1p2_svt_lp L=6e-08 W=1.5e-07
MI68_MXPA1 XI68_p1 ns VDD VDD pm1p2_svt_lp L=6e-08 W=1.5e-07
MI28_MXPA1 ns s VDD VDD pm1p2_svt_lp L=6e-08 W=1.2e-07
MI75_MXPA1 QN s VDD VDD pm1p2_svt_lp L=6e-08 W=5.85e-07
MI23_MXPA1 bclk nclk VDD VDD pm1p2_svt_lp L=6e-08 W=3e-07
MI22_MXPA1 nclk CK VDD VDD pm1p2_svt_lp L=6e-08 W=1.9e-07
.ENDS

.SUBCKT DFFQNX2H9R QN VDD VSS CK D
MI69_MXNA1 nd D VSS VSS nm1p2_svt_lp L=6e-08 W=4.2e-07
MI33_MXNOE nm nclk nd VSS nm1p2_svt_lp L=6e-08 W=3.2e-07
MI31_MXNOE nm bclk XI31_n1 VSS nm1p2_svt_lp L=6e-08 W=1.5e-07
MI31_MXNA1 XI31_n1 m VSS VSS nm1p2_svt_lp L=6e-08 W=1.5e-07
MI32_MXNA1 m nm VSS VSS nm1p2_svt_lp L=6e-08 W=2.3e-07
MI20_MXNOE s bclk m VSS nm1p2_svt_lp L=6e-08 W=3.2e-07
MI68_MXNOE s nclk XI68_n1 VSS nm1p2_svt_lp L=6e-08 W=1.5e-07
MI68_MXNA1 XI68_n1 ns VSS VSS nm1p2_svt_lp L=6e-08 W=1.5e-07
MI28_MXNA1 ns s VSS VSS nm1p2_svt_lp L=6e-08 W=1.2e-07
MI75_MXNA1 QN s VSS VSS nm1p2_svt_lp L=6e-08 W=4.2e-07
MI75_MXNA1_2 QN s VSS VSS nm1p2_svt_lp L=6e-08 W=4.2e-07
MI23_MXNA1 bclk nclk VSS VSS nm1p2_svt_lp L=6e-08 W=1.7e-07
MI22_MXNA1 nclk CK VSS VSS nm1p2_svt_lp L=6e-08 W=2.1e-07
MI69_MXPA1 nd D VDD VDD pm1p2_svt_lp L=6e-08 W=3.3e-07
MI33_MXPOEN nm bclk nd VDD pm1p2_svt_lp L=6e-08 W=3.2e-07
MI31_MXPOEN nm nclk XI31_p1 VDD pm1p2_svt_lp L=6e-08 W=1.5e-07
MI31_MXPA1 XI31_p1 m VDD VDD pm1p2_svt_lp L=6e-08 W=1.5e-07
MI32_MXPA1 m nm VDD VDD pm1p2_svt_lp L=6e-08 W=3.9e-07
MI20_MXPOEN s nclk m VDD pm1p2_svt_lp L=6e-08 W=3.2e-07
MI68_MXPOEN s bclk XI68_p1 VDD pm1p2_svt_lp L=6e-08 W=1.5e-07
MI68_MXPA1 XI68_p1 ns VDD VDD pm1p2_svt_lp L=6e-08 W=1.5e-07
MI28_MXPA1 ns s VDD VDD pm1p2_svt_lp L=6e-08 W=1.2e-07
MI75_MXPA1 QN s VDD VDD pm1p2_svt_lp L=6e-08 W=5.85e-07
MI75_MXPA1_2 QN s VDD VDD pm1p2_svt_lp L=6e-08 W=5.85e-07
MI23_MXPA1 bclk nclk VDD VDD pm1p2_svt_lp L=6e-08 W=3.3e-07
MI22_MXPA1 nclk CK VDD VDD pm1p2_svt_lp L=6e-08 W=2.3e-07
.ENDS

.SUBCKT DFFQNX3H9R QN VDD VSS CK D
MI69_MXNA1 nd D VSS VSS nm1p2_svt_lp L=6e-08 W=3.9e-07
MI33_MXNOE nm nclk nd VSS nm1p2_svt_lp L=6e-08 W=3.9e-07
MI31_MXNOE nm bclk XI31_n1 VSS nm1p2_svt_lp L=6e-08 W=1.5e-07
MI31_MXNA1 XI31_n1 m VSS VSS nm1p2_svt_lp L=6e-08 W=1.5e-07
MI32_MXNA1 m nm VSS VSS nm1p2_svt_lp L=6e-08 W=2.8e-07
MI20_MXNOE s bclk m VSS nm1p2_svt_lp L=6e-08 W=3.9e-07
MI68_MXNOE s nclk XI68_n1 VSS nm1p2_svt_lp L=6e-08 W=1.5e-07
MI68_MXNA1 XI68_n1 ns VSS VSS nm1p2_svt_lp L=6e-08 W=1.5e-07
MI28_MXNA1 ns s VSS VSS nm1p2_svt_lp L=6e-08 W=1.2e-07
MI75_MXNA1 QN s VSS VSS nm1p2_svt_lp L=6e-08 W=4.2e-07
MI75_MXNA1_2 QN s VSS VSS nm1p2_svt_lp L=6e-08 W=4.2e-07
MI75_MXNA1_3 QN s VSS VSS nm1p2_svt_lp L=6e-08 W=4.2e-07
MI23_MXNA1 bclk nclk VSS VSS nm1p2_svt_lp L=6e-08 W=1.8e-07
MI22_MXNA1 nclk CK VSS VSS nm1p2_svt_lp L=6e-08 W=2.2e-07
MI69_MXPA1 nd D VDD VDD pm1p2_svt_lp L=6e-08 W=3.3e-07
MI33_MXPOEN nm bclk nd VDD pm1p2_svt_lp L=6e-08 W=3.9e-07
MI31_MXPOEN nm nclk XI31_p1 VDD pm1p2_svt_lp L=6e-08 W=1.5e-07
MI31_MXPA1 XI31_p1 m VDD VDD pm1p2_svt_lp L=6e-08 W=1.5e-07
MI32_MXPA1 m nm VDD VDD pm1p2_svt_lp L=6e-08 W=5.1e-07
MI20_MXPOEN s nclk m VDD pm1p2_svt_lp L=6e-08 W=3.9e-07
MI68_MXPOEN s bclk XI68_p1 VDD pm1p2_svt_lp L=6e-08 W=1.5e-07
MI68_MXPA1 XI68_p1 ns VDD VDD pm1p2_svt_lp L=6e-08 W=1.5e-07
MI28_MXPA1 ns s VDD VDD pm1p2_svt_lp L=6e-08 W=1.2e-07
MI75_MXPA1 QN s VDD VDD pm1p2_svt_lp L=6e-08 W=5.85e-07
MI75_MXPA1_2 QN s VDD VDD pm1p2_svt_lp L=6e-08 W=5.85e-07
MI75_MXPA1_3 QN s VDD VDD pm1p2_svt_lp L=6e-08 W=5.85e-07
MI23_MXPA1 bclk nclk VDD VDD pm1p2_svt_lp L=6e-08 W=3.6e-07
MI22_MXPA1 nclk CK VDD VDD pm1p2_svt_lp L=6e-08 W=2.4e-07
.ENDS

.SUBCKT DFFNQX1H9R Q VDD VSS CKN D
MI23_MXNA1 bclk_ nclk_ VSS VSS nm1p2_svt_lp L=6e-08 W=1.7e-07
MI68_MXNA1 nd D VSS VSS nm1p2_svt_lp L=6e-08 W=1.5e-07
MI33_MXNOE nm bclk_ nd VSS nm1p2_svt_lp L=6e-08 W=1.5e-07
MI31_MXNOE nm nclk_ XI31_n1 VSS nm1p2_svt_lp L=6e-08 W=1.5e-07
MI31_MXNA1 XI31_n1 m VSS VSS nm1p2_svt_lp L=6e-08 W=1.5e-07
MI32_MXNA1 m nm VSS VSS nm1p2_svt_lp L=6e-08 W=2.5e-07
MI20_MXNOE s nclk_ m VSS nm1p2_svt_lp L=6e-08 W=1.5e-07
MI29_MXNOE s bclk_ XI29_n1 VSS nm1p2_svt_lp L=6e-08 W=1.5e-07
MI29_MXNA1 XI29_n1 ns VSS VSS nm1p2_svt_lp L=6e-08 W=1.5e-07
MI8_MXNA1 Q ns VSS VSS nm1p2_svt_lp L=6e-08 W=4.2e-07
MI28_MXNA1 ns s VSS VSS nm1p2_svt_lp L=6e-08 W=3.4e-07
MI22_MXNA1 nclk_ CKN VSS VSS nm1p2_svt_lp L=6e-08 W=1.5e-07
MI23_MXPA1 bclk_ nclk_ VDD VDD pm1p2_svt_lp L=6e-08 W=1.9e-07
MI68_MXPA1 nd D VDD VDD pm1p2_svt_lp L=6e-08 W=3.4e-07
MI33_MXPOEN nm nclk_ nd VDD pm1p2_svt_lp L=6e-08 W=3.6e-07
MI31_MXPOEN nm bclk_ XI31_p1 VDD pm1p2_svt_lp L=6e-08 W=1.5e-07
MI31_MXPA1 XI31_p1 m VDD VDD pm1p2_svt_lp L=6e-08 W=1.5e-07
MI32_MXPA1 m nm VDD VDD pm1p2_svt_lp L=6e-08 W=1.7e-07
MI20_MXPOEN s bclk_ m VDD pm1p2_svt_lp L=6e-08 W=3.6e-07
MI29_MXPOEN s nclk_ XI29_p1 VDD pm1p2_svt_lp L=6e-08 W=1.5e-07
MI29_MXPA1 XI29_p1 ns VDD VDD pm1p2_svt_lp L=6e-08 W=1.5e-07
MI8_MXPA1 Q ns VDD VDD pm1p2_svt_lp L=6e-08 W=5.85e-07
MI28_MXPA1 ns s VDD VDD pm1p2_svt_lp L=6e-08 W=1.5e-07
MI22_MXPA1 nclk_ CKN VDD VDD pm1p2_svt_lp L=6e-08 W=3e-07
.ENDS

.SUBCKT DFFNQX2H9R Q VDD VSS CKN D
MI22_MXNA1 nclk_ CKN VSS VSS nm1p2_svt_lp L=6e-08 W=1.7e-07
MI23_MXNA1 bclk_ nclk_ VSS VSS nm1p2_svt_lp L=6e-08 W=2.1e-07
MI68_MXNA1 nd D VSS VSS nm1p2_svt_lp L=6e-08 W=1.5e-07
MI33_MXNOE nm bclk_ nd VSS nm1p2_svt_lp L=6e-08 W=1.8e-07
MI31_MXNOE nm nclk_ XI31_n1 VSS nm1p2_svt_lp L=6e-08 W=1.5e-07
MI31_MXNA1 XI31_n1 m VSS VSS nm1p2_svt_lp L=6e-08 W=1.5e-07
MI32_MXNA1 m nm VSS VSS nm1p2_svt_lp L=6e-08 W=4.2e-07
MI20_MXNOE s nclk_ m VSS nm1p2_svt_lp L=6e-08 W=1.8e-07
MI29_MXNOE s bclk_ XI29_n1 VSS nm1p2_svt_lp L=6e-08 W=1.5e-07
MI29_MXNA1 XI29_n1 ns VSS VSS nm1p2_svt_lp L=6e-08 W=1.5e-07
MI8_MXNA1 Q ns VSS VSS nm1p2_svt_lp L=6e-08 W=4.2e-07
MI8_MXNA1_2 Q ns VSS VSS nm1p2_svt_lp L=6e-08 W=4.2e-07
MI28_MXNA1 ns s VSS VSS nm1p2_svt_lp L=6e-08 W=3.7e-07
MI22_MXPA1 nclk_ CKN VDD VDD pm1p2_svt_lp L=6e-08 W=3.3e-07
MI23_MXPA1 bclk_ nclk_ VDD VDD pm1p2_svt_lp L=6e-08 W=2.3e-07
MI68_MXPA1 nd D VDD VDD pm1p2_svt_lp L=6e-08 W=3e-07
MI33_MXPOEN nm nclk_ nd VDD pm1p2_svt_lp L=6e-08 W=4.5e-07
MI31_MXPOEN nm bclk_ XI31_p1 VDD pm1p2_svt_lp L=6e-08 W=1.5e-07
MI31_MXPA1 XI31_p1 m VDD VDD pm1p2_svt_lp L=6e-08 W=1.5e-07
MI32_MXPA1 m nm VDD VDD pm1p2_svt_lp L=6e-08 W=2e-07
MI20_MXPOEN s bclk_ m VDD pm1p2_svt_lp L=6e-08 W=4.5e-07
MI29_MXPOEN s nclk_ XI29_p1 VDD pm1p2_svt_lp L=6e-08 W=1.5e-07
MI29_MXPA1 XI29_p1 ns VDD VDD pm1p2_svt_lp L=6e-08 W=1.5e-07
MI8_MXPA1 Q ns VDD VDD pm1p2_svt_lp L=6e-08 W=5.85e-07
MI8_MXPA1_2 Q ns VDD VDD pm1p2_svt_lp L=6e-08 W=5.85e-07
MI28_MXPA1 ns s VDD VDD pm1p2_svt_lp L=6e-08 W=2e-07
.ENDS

.SUBCKT DFFNQX3H9R Q VDD VSS CKN D
MI23_MXNA1 bclk_ nclk_ VSS VSS nm1p2_svt_lp L=6e-08 W=2.2e-07
MI68_MXNA1 nd D VSS VSS nm1p2_svt_lp L=6e-08 W=1.65e-07
MI33_MXNOE nm bclk_ nd VSS nm1p2_svt_lp L=6e-08 W=1.8e-07
MI31_MXNOE nm nclk_ XI31_n1 VSS nm1p2_svt_lp L=6e-08 W=1.5e-07
MI31_MXNA1 XI31_n1 m VSS VSS nm1p2_svt_lp L=6e-08 W=1.5e-07
MI32_MXNA1 m nm VSS VSS nm1p2_svt_lp L=6e-08 W=3.9e-07
MI20_MXNOE s nclk_ m VSS nm1p2_svt_lp L=6e-08 W=1.8e-07
MI29_MXNOE s bclk_ XI29_n1 VSS nm1p2_svt_lp L=6e-08 W=1.5e-07
MI29_MXNA1 XI29_n1 ns VSS VSS nm1p2_svt_lp L=6e-08 W=1.5e-07
MI8_MXNA1 Q ns VSS VSS nm1p2_svt_lp L=6e-08 W=4.2e-07
MI8_MXNA1_2 Q ns VSS VSS nm1p2_svt_lp L=6e-08 W=4.2e-07
MI8_MXNA1_3 Q ns VSS VSS nm1p2_svt_lp L=6e-08 W=4.2e-07
MI28_MXNA1 ns s VSS VSS nm1p2_svt_lp L=6e-08 W=2.2e-07
MI22_MXNA1 nclk_ CKN VSS VSS nm1p2_svt_lp L=6e-08 W=1.8e-07
MI23_MXPA1 bclk_ nclk_ VDD VDD pm1p2_svt_lp L=6e-08 W=2.4e-07
MI68_MXPA1 nd D VDD VDD pm1p2_svt_lp L=6e-08 W=4.7e-07
MI33_MXPOEN nm nclk_ nd VDD pm1p2_svt_lp L=6e-08 W=5.85e-07
MI31_MXPOEN nm bclk_ XI31_p1 VDD pm1p2_svt_lp L=6e-08 W=1.5e-07
MI31_MXPA1 XI31_p1 m VDD VDD pm1p2_svt_lp L=6e-08 W=1.5e-07
MI32_MXPA1 m nm VDD VDD pm1p2_svt_lp L=6e-08 W=4.5e-07
MI20_MXPOEN s bclk_ m VDD pm1p2_svt_lp L=6e-08 W=5.85e-07
MI29_MXPOEN s nclk_ XI29_p1 VDD pm1p2_svt_lp L=6e-08 W=1.5e-07
MI29_MXPA1 XI29_p1 ns VDD VDD pm1p2_svt_lp L=6e-08 W=1.5e-07
MI8_MXPA1 Q ns VDD VDD pm1p2_svt_lp L=6e-08 W=5.85e-07
MI8_MXPA1_2 Q ns VDD VDD pm1p2_svt_lp L=6e-08 W=5.85e-07
MI8_MXPA1_3 Q ns VDD VDD pm1p2_svt_lp L=6e-08 W=5.85e-07
MI28_MXPA1 ns s VDD VDD pm1p2_svt_lp L=6e-08 W=2.2e-07
MI22_MXPA1 nclk_ CKN VDD VDD pm1p2_svt_lp L=6e-08 W=3.6e-07
.ENDS

.SUBCKT DFFRPQX0P5H9R Q VDD VSS CK D R
MI22_MXNA1 nclk CK VSS VSS nm1p2_svt_lp L=6e-08 W=1.5e-07
MI23_MXNA1 bclk nclk VSS VSS nm1p2_svt_lp L=6e-08 W=1.5e-07
MI78_MXNA1 nd D VSS VSS nm1p2_svt_lp L=6e-08 W=2.4e-07
MI33_MXNOE nm nclk nd VSS nm1p2_svt_lp L=6e-08 W=1.5e-07
MI31_MXNOE nm bclk XI31_n1 VSS nm1p2_svt_lp L=6e-08 W=1.5e-07
MI31_MXNA1 XI31_n1 m VSS VSS nm1p2_svt_lp L=6e-08 W=1.5e-07
MI0_MXNA2 m nm VSS VSS nm1p2_svt_lp L=6e-08 W=1.5e-07
MI0_MXNA1 m R VSS VSS nm1p2_svt_lp L=6e-08 W=1.5e-07
MI20_MXNOE s bclk m VSS nm1p2_svt_lp L=6e-08 W=1.5e-07
MXN4 s nclk net45 VSS nm1p2_svt_lp L=6e-08 W=1.5e-07
MXN0 net45 ns VSS VSS nm1p2_svt_lp L=6e-08 W=1.5e-07
MXN1 s R VSS VSS nm1p2_svt_lp L=6e-08 W=1.5e-07
MI28_MXNA1 ns s VSS VSS nm1p2_svt_lp L=6e-08 W=1.5e-07
MI8_MXNA1 Q ns VSS VSS nm1p2_svt_lp L=6e-08 W=2.1e-07
MI22_MXPA1 nclk CK VDD VDD pm1p2_svt_lp L=6e-08 W=1.7e-07
MI23_MXPA1 bclk nclk VDD VDD pm1p2_svt_lp L=6e-08 W=1.9e-07
MI78_MXPA1 nd D VDD VDD pm1p2_svt_lp L=6e-08 W=1.7e-07
MI33_MXPOEN nm bclk nd VDD pm1p2_svt_lp L=6e-08 W=1.5e-07
MI31_MXPOEN nm nclk XI31_p1 VDD pm1p2_svt_lp L=6e-08 W=1.5e-07
MI31_MXPA1 XI31_p1 m VDD VDD pm1p2_svt_lp L=6e-08 W=1.5e-07
MI0_MXPA2 XI0_p1 nm VDD VDD pm1p2_svt_lp L=6e-08 W=3e-07
MI0_MXPA1 m R XI0_p1 VDD pm1p2_svt_lp L=6e-08 W=3e-07
MI20_MXPOEN s nclk m VDD pm1p2_svt_lp L=6e-08 W=1.5e-07
MXP1 s bclk net80 VDD pm1p2_svt_lp L=6e-08 W=2e-07
MXP0 net80 ns net72 VDD pm1p2_svt_lp L=6e-08 W=2e-07
MXP5 net72 R VDD VDD pm1p2_svt_lp L=6e-08 W=2e-07
MI28_MXPA1 ns s VDD VDD pm1p2_svt_lp L=6e-08 W=2.1e-07
MI8_MXPA1 Q ns VDD VDD pm1p2_svt_lp L=6e-08 W=2.95e-07
.ENDS

.SUBCKT DFFRPQX1H9R Q VDD VSS CK D R
MI22_MXNA1 nclk CK VSS VSS nm1p2_svt_lp L=6e-08 W=1.7e-07
MI23_MXNA1 bclk nclk VSS VSS nm1p2_svt_lp L=6e-08 W=1.5e-07
MI78_MXNA1 nd D VSS VSS nm1p2_svt_lp L=6e-08 W=3.2e-07
MI33_MXNOE nm nclk nd VSS nm1p2_svt_lp L=6e-08 W=2.6e-07
MI31_MXNOE nm bclk XI31_n1 VSS nm1p2_svt_lp L=6e-08 W=1.5e-07
MI31_MXNA1 XI31_n1 m VSS VSS nm1p2_svt_lp L=6e-08 W=1.5e-07
MI0_MXNA2 m nm VSS VSS nm1p2_svt_lp L=6e-08 W=2e-07
MI0_MXNA1 m R VSS VSS nm1p2_svt_lp L=6e-08 W=2e-07
MI20_MXNOE s bclk m VSS nm1p2_svt_lp L=6e-08 W=2.6e-07
MXN4 s nclk net45 VSS nm1p2_svt_lp L=6e-08 W=1.5e-07
MXN0 net45 ns VSS VSS nm1p2_svt_lp L=6e-08 W=1.5e-07
MXN1 s R VSS VSS nm1p2_svt_lp L=6e-08 W=1.5e-07
MI28_MXNA1 ns s VSS VSS nm1p2_svt_lp L=6e-08 W=2.6e-07
MI8_MXNA1 Q ns VSS VSS nm1p2_svt_lp L=6e-08 W=4.2e-07
MI22_MXPA1 nclk CK VDD VDD pm1p2_svt_lp L=6e-08 W=1.9e-07
MI23_MXPA1 bclk nclk VDD VDD pm1p2_svt_lp L=6e-08 W=3e-07
MI78_MXPA1 nd D VDD VDD pm1p2_svt_lp L=6e-08 W=2.5e-07
MI33_MXPOEN nm bclk nd VDD pm1p2_svt_lp L=6e-08 W=2.6e-07
MI31_MXPOEN nm nclk XI31_p1 VDD pm1p2_svt_lp L=6e-08 W=1.5e-07
MI31_MXPA1 XI31_p1 m VDD VDD pm1p2_svt_lp L=6e-08 W=1.5e-07
MI0_MXPA2 XI0_p1 nm VDD VDD pm1p2_svt_lp L=6e-08 W=4.5e-07
MI0_MXPA1 m R XI0_p1 VDD pm1p2_svt_lp L=6e-08 W=4.5e-07
MI20_MXPOEN s nclk m VDD pm1p2_svt_lp L=6e-08 W=2.6e-07
MXP1 s bclk net80 VDD pm1p2_svt_lp L=6e-08 W=2e-07
MXP0 net80 ns net72 VDD pm1p2_svt_lp L=6e-08 W=2e-07
MXP5 net72 R VDD VDD pm1p2_svt_lp L=6e-08 W=2e-07
MI28_MXPA1 ns s VDD VDD pm1p2_svt_lp L=6e-08 W=3.4e-07
MI8_MXPA1 Q ns VDD VDD pm1p2_svt_lp L=6e-08 W=5.85e-07
.ENDS

.SUBCKT DFFRPQX2H9R Q VDD VSS CK D R
MI22_MXNA1 nclk CK VSS VSS nm1p2_svt_lp L=6e-08 W=2.1e-07
MI23_MXNA1 bclk nclk VSS VSS nm1p2_svt_lp L=6e-08 W=1.7e-07
MI78_MXNA1 nd D VSS VSS nm1p2_svt_lp L=6e-08 W=4.2e-07
MI33_MXNOE nm nclk nd VSS nm1p2_svt_lp L=6e-08 W=3.2e-07
MI31_MXNOE nm bclk XI31_n1 VSS nm1p2_svt_lp L=6e-08 W=1.5e-07
MI31_MXNA1 XI31_n1 m VSS VSS nm1p2_svt_lp L=6e-08 W=1.5e-07
MI0_MXNA2 m nm VSS VSS nm1p2_svt_lp L=6e-08 W=2.2e-07
MI0_MXNA1 m R VSS VSS nm1p2_svt_lp L=6e-08 W=2.2e-07
MI20_MXNOE s bclk m VSS nm1p2_svt_lp L=6e-08 W=3.2e-07
MXN4 s nclk net45 VSS nm1p2_svt_lp L=6e-08 W=1.5e-07
MXN0 net45 ns VSS VSS nm1p2_svt_lp L=6e-08 W=1.5e-07
MXN1 s R VSS VSS nm1p2_svt_lp L=6e-08 W=1.5e-07
MI28_MXNA1 ns s VSS VSS nm1p2_svt_lp L=6e-08 W=3.8e-07
MI8_MXNA1 Q ns VSS VSS nm1p2_svt_lp L=6e-08 W=4.2e-07
MI8_MXNA1_2 Q ns VSS VSS nm1p2_svt_lp L=6e-08 W=4.2e-07
MI22_MXPA1 nclk CK VDD VDD pm1p2_svt_lp L=6e-08 W=2.3e-07
MI23_MXPA1 bclk nclk VDD VDD pm1p2_svt_lp L=6e-08 W=3.3e-07
MI78_MXPA1 nd D VDD VDD pm1p2_svt_lp L=6e-08 W=3.1e-07
MI33_MXPOEN nm bclk nd VDD pm1p2_svt_lp L=6e-08 W=3.2e-07
MI31_MXPOEN nm nclk XI31_p1 VDD pm1p2_svt_lp L=6e-08 W=1.5e-07
MI31_MXPA1 XI31_p1 m VDD VDD pm1p2_svt_lp L=6e-08 W=1.5e-07
MI0_MXPA2 XI0_p1 nm VDD VDD pm1p2_svt_lp L=6e-08 W=4.8e-07
MI0_MXPA1 m R XI0_p1 VDD pm1p2_svt_lp L=6e-08 W=4.8e-07
MI20_MXPOEN s nclk m VDD pm1p2_svt_lp L=6e-08 W=3.2e-07
MXP1 s bclk net80 VDD pm1p2_svt_lp L=6e-08 W=2e-07
MXP0 net80 ns net72 VDD pm1p2_svt_lp L=6e-08 W=2e-07
MXP5 net72 R VDD VDD pm1p2_svt_lp L=6e-08 W=2e-07
MI28_MXPA1 ns s VDD VDD pm1p2_svt_lp L=6e-08 W=4.8e-07
MI8_MXPA1 Q ns VDD VDD pm1p2_svt_lp L=6e-08 W=5.85e-07
MI8_MXPA1_2 Q ns VDD VDD pm1p2_svt_lp L=6e-08 W=5.85e-07
.ENDS

.SUBCKT DFFRPQX3H9R Q VDD VSS CK D R
MI22_MXNA1 nclk CK VSS VSS nm1p2_svt_lp L=6e-08 W=2.2e-07
MI23_MXNA1 bclk nclk VSS VSS nm1p2_svt_lp L=6e-08 W=1.8e-07
MI78_MXNA1 nd D VSS VSS nm1p2_svt_lp L=6e-08 W=4.5e-07
MI33_MXNOE nm nclk nd VSS nm1p2_svt_lp L=6e-08 W=3.9e-07
MI31_MXNOE nm bclk XI31_n1 VSS nm1p2_svt_lp L=6e-08 W=1.5e-07
MI31_MXNA1 XI31_n1 m VSS VSS nm1p2_svt_lp L=6e-08 W=1.5e-07
MI0_MXNA2 m nm VSS VSS nm1p2_svt_lp L=6e-08 W=2.2e-07
MI0_MXNA1 m R VSS VSS nm1p2_svt_lp L=6e-08 W=2.2e-07
MI20_MXNOE s bclk m VSS nm1p2_svt_lp L=6e-08 W=3.9e-07
MXN4 s nclk net45 VSS nm1p2_svt_lp L=6e-08 W=1.5e-07
MXN0 net45 ns VSS VSS nm1p2_svt_lp L=6e-08 W=1.5e-07
MXN1 s R VSS VSS nm1p2_svt_lp L=6e-08 W=1.5e-07
MI28_MXNA1 ns s VSS VSS nm1p2_svt_lp L=6e-08 W=4.2e-07
MI8_MXNA1 Q ns VSS VSS nm1p2_svt_lp L=6e-08 W=4.2e-07
MI8_MXNA1_2 Q ns VSS VSS nm1p2_svt_lp L=6e-08 W=4.2e-07
MI8_MXNA1_3 Q ns VSS VSS nm1p2_svt_lp L=6e-08 W=4.2e-07
MI22_MXPA1 nclk CK VDD VDD pm1p2_svt_lp L=6e-08 W=2.4e-07
MI23_MXPA1 bclk nclk VDD VDD pm1p2_svt_lp L=6e-08 W=3.6e-07
MI78_MXPA1 nd D VDD VDD pm1p2_svt_lp L=6e-08 W=3.4e-07
MI33_MXPOEN nm bclk nd VDD pm1p2_svt_lp L=6e-08 W=3.9e-07
MI31_MXPOEN nm nclk XI31_p1 VDD pm1p2_svt_lp L=6e-08 W=1.5e-07
MI31_MXPA1 XI31_p1 m VDD VDD pm1p2_svt_lp L=6e-08 W=1.5e-07
MI0_MXPA2 XI0_p1 nm VDD VDD pm1p2_svt_lp L=6e-08 W=4.9e-07
MI0_MXPA1 m R XI0_p1 VDD pm1p2_svt_lp L=6e-08 W=4.9e-07
MI20_MXPOEN s nclk m VDD pm1p2_svt_lp L=6e-08 W=3.9e-07
MXP1 s bclk net80 VDD pm1p2_svt_lp L=6e-08 W=2e-07
MXP0 net80 ns net72 VDD pm1p2_svt_lp L=6e-08 W=2e-07
MXP5 net72 R VDD VDD pm1p2_svt_lp L=6e-08 W=2e-07
MI28_MXPA1 ns s VDD VDD pm1p2_svt_lp L=6e-08 W=5.5e-07
MI8_MXPA1 Q ns VDD VDD pm1p2_svt_lp L=6e-08 W=5.85e-07
MI8_MXPA1_2 Q ns VDD VDD pm1p2_svt_lp L=6e-08 W=5.85e-07
MI8_MXPA1_3 Q ns VDD VDD pm1p2_svt_lp L=6e-08 W=5.85e-07
.ENDS

.SUBCKT DFFRPQX4H9R Q VDD VSS CK D R
MI23_MXNA1 bclk nclk VSS VSS nm1p2_svt_lp L=6e-08 W=2.1e-07
MI78_MXNA1 nd D VSS VSS nm1p2_svt_lp L=6e-08 W=4.8e-07
MI33_MXNOE nm nclk nd VSS nm1p2_svt_lp L=6e-08 W=4.5e-07
MI31_MXNOE nm bclk XI31_n1 VSS nm1p2_svt_lp L=6e-08 W=1.5e-07
MI31_MXNA1 XI31_n1 m VSS VSS nm1p2_svt_lp L=6e-08 W=1.5e-07
MI0_MXNA2 m nm VSS VSS nm1p2_svt_lp L=6e-08 W=2.6e-07
MI0_MXNA1 m R VSS VSS nm1p2_svt_lp L=6e-08 W=2.6e-07
MI20_MXNOE s bclk m VSS nm1p2_svt_lp L=6e-08 W=4.5e-07
MXN4 s nclk net45 VSS nm1p2_svt_lp L=6e-08 W=1.5e-07
MXN0 net45 ns VSS VSS nm1p2_svt_lp L=6e-08 W=1.5e-07
MXN1 s R VSS VSS nm1p2_svt_lp L=6e-08 W=1.5e-07
MI22_MXNA1 nclk CK VSS VSS nm1p2_svt_lp L=6e-08 W=2.5e-07
MI28_MXNA1 ns s VSS VSS nm1p2_svt_lp L=6e-08 W=4.5e-07
MI28_MXNA1_2 ns s VSS VSS nm1p2_svt_lp L=6e-08 W=4.5e-07
MI8_MXNA1 Q ns VSS VSS nm1p2_svt_lp L=6e-08 W=4.2e-07
MI8_MXNA1_2 Q ns VSS VSS nm1p2_svt_lp L=6e-08 W=4.2e-07
MI8_MXNA1_3 Q ns VSS VSS nm1p2_svt_lp L=6e-08 W=4.2e-07
MI8_MXNA1_4 Q ns VSS VSS nm1p2_svt_lp L=6e-08 W=4.2e-07
MI23_MXPA1 bclk nclk VDD VDD pm1p2_svt_lp L=6e-08 W=4.2e-07
MI78_MXPA1 nd D VDD VDD pm1p2_svt_lp L=6e-08 W=3.7e-07
MI33_MXPOEN nm bclk nd VDD pm1p2_svt_lp L=6e-08 W=4.5e-07
MI31_MXPOEN nm nclk XI31_p1 VDD pm1p2_svt_lp L=6e-08 W=1.5e-07
MI31_MXPA1 XI31_p1 m VDD VDD pm1p2_svt_lp L=6e-08 W=1.5e-07
MI0_MXPA2 XI0_p1 nm VDD VDD pm1p2_svt_lp L=6e-08 W=5.85e-07
MI0_MXPA1 m R XI0_p1 VDD pm1p2_svt_lp L=6e-08 W=5.85e-07
MI20_MXPOEN s nclk m VDD pm1p2_svt_lp L=6e-08 W=4.5e-07
MXP1 s bclk net80 VDD pm1p2_svt_lp L=6e-08 W=2e-07
MXP0 net80 ns net72 VDD pm1p2_svt_lp L=6e-08 W=2e-07
MXP5 net72 R VDD VDD pm1p2_svt_lp L=6e-08 W=2e-07
MI22_MXPA1 nclk CK VDD VDD pm1p2_svt_lp L=6e-08 W=2.8e-07
MI28_MXPA1 ns s VDD VDD pm1p2_svt_lp L=6e-08 W=4.3e-07
MI28_MXPA1_2 ns s VDD VDD pm1p2_svt_lp L=6e-08 W=4.3e-07
MI8_MXPA1 Q ns VDD VDD pm1p2_svt_lp L=6e-08 W=5.85e-07
MI8_MXPA1_2 Q ns VDD VDD pm1p2_svt_lp L=6e-08 W=5.85e-07
MI8_MXPA1_3 Q ns VDD VDD pm1p2_svt_lp L=6e-08 W=5.85e-07
MI8_MXPA1_4 Q ns VDD VDD pm1p2_svt_lp L=6e-08 W=5.85e-07
.ENDS

.SUBCKT DFFRPQNX0P5H9R QN VDD VSS CK D R
MI83_MXNA1 nd D VSS VSS nm1p2_svt_lp L=6e-08 W=2e-07
MI33_MXNOE nm nclk nd VSS nm1p2_svt_lp L=6e-08 W=1.5e-07
MI31_MXNOE nm bclk XI31_n1 VSS nm1p2_svt_lp L=6e-08 W=1.5e-07
MI31_MXNA1 XI31_n1 m VSS VSS nm1p2_svt_lp L=6e-08 W=1.5e-07
MI0_MXNA2 m nm VSS VSS nm1p2_svt_lp L=6e-08 W=1.5e-07
MI0_MXNA1 m R VSS VSS nm1p2_svt_lp L=6e-08 W=1.5e-07
MI20_MXNOE s bclk m VSS nm1p2_svt_lp L=6e-08 W=1.5e-07
MXN6 s nclk net53 VSS nm1p2_svt_lp L=6e-08 W=1.5e-07
MXN5 net53 ns VSS VSS nm1p2_svt_lp L=6e-08 W=1.5e-07
MXN7 s R VSS VSS nm1p2_svt_lp L=6e-08 W=1.5e-07
MI78_MXNA1 ns s VSS VSS nm1p2_svt_lp L=6e-08 W=1.2e-07
MI8_MXNA1 QN s VSS VSS nm1p2_svt_lp L=6e-08 W=2.1e-07
MI23_MXNA1 bclk nclk VSS VSS nm1p2_svt_lp L=6e-08 W=1.5e-07
MI22_MXNA1 nclk CK VSS VSS nm1p2_svt_lp L=6e-08 W=1.5e-07
MI83_MXPA1 nd D VDD VDD pm1p2_svt_lp L=6e-08 W=1.5e-07
MI33_MXPOEN nm bclk nd VDD pm1p2_svt_lp L=6e-08 W=1.5e-07
MI31_MXPOEN nm nclk XI31_p1 VDD pm1p2_svt_lp L=6e-08 W=1.5e-07
MI31_MXPA1 XI31_p1 m VDD VDD pm1p2_svt_lp L=6e-08 W=1.5e-07
MI0_MXPA2 XI0_p1 nm VDD VDD pm1p2_svt_lp L=6e-08 W=3.2e-07
MI0_MXPA1 m R XI0_p1 VDD pm1p2_svt_lp L=6e-08 W=3.2e-07
MI20_MXPOEN s nclk m VDD pm1p2_svt_lp L=6e-08 W=1.5e-07
MXP7 s bclk net74 VDD pm1p2_svt_lp L=6e-08 W=2e-07
MXP4 net74 ns net78 VDD pm1p2_svt_lp L=6e-08 W=2e-07
MXP6 net78 R VDD VDD pm1p2_svt_lp L=6e-08 W=2e-07
MI78_MXPA1 ns s VDD VDD pm1p2_svt_lp L=6e-08 W=1.2e-07
MI8_MXPA1 QN s VDD VDD pm1p2_svt_lp L=6e-08 W=2.95e-07
MI23_MXPA1 bclk nclk VDD VDD pm1p2_svt_lp L=6e-08 W=1.9e-07
MI22_MXPA1 nclk CK VDD VDD pm1p2_svt_lp L=6e-08 W=1.7e-07
.ENDS

.SUBCKT DFFRPQNX1H9R QN VDD VSS CK D R
MI83_MXNA1 nd D VSS VSS nm1p2_svt_lp L=6e-08 W=3.4e-07
MI33_MXNOE nm nclk nd VSS nm1p2_svt_lp L=6e-08 W=2.6e-07
MI31_MXNOE nm bclk XI31_n1 VSS nm1p2_svt_lp L=6e-08 W=1.5e-07
MI31_MXNA1 XI31_n1 m VSS VSS nm1p2_svt_lp L=6e-08 W=1.5e-07
MI0_MXNA2 m nm VSS VSS nm1p2_svt_lp L=6e-08 W=2e-07
MI0_MXNA1 m R VSS VSS nm1p2_svt_lp L=6e-08 W=2e-07
MI20_MXNOE s bclk m VSS nm1p2_svt_lp L=6e-08 W=2.6e-07
MXN6 s nclk net53 VSS nm1p2_svt_lp L=6e-08 W=1.5e-07
MXN5 net53 ns VSS VSS nm1p2_svt_lp L=6e-08 W=1.5e-07
MXN7 s R VSS VSS nm1p2_svt_lp L=6e-08 W=1.5e-07
MI78_MXNA1 ns s VSS VSS nm1p2_svt_lp L=6e-08 W=1.2e-07
MI8_MXNA1 QN s VSS VSS nm1p2_svt_lp L=6e-08 W=4.2e-07
MI23_MXNA1 bclk nclk VSS VSS nm1p2_svt_lp L=6e-08 W=1.5e-07
MI22_MXNA1 nclk CK VSS VSS nm1p2_svt_lp L=6e-08 W=1.7e-07
MI83_MXPA1 nd D VDD VDD pm1p2_svt_lp L=6e-08 W=2.7e-07
MI33_MXPOEN nm bclk nd VDD pm1p2_svt_lp L=6e-08 W=2.6e-07
MI31_MXPOEN nm nclk XI31_p1 VDD pm1p2_svt_lp L=6e-08 W=1.5e-07
MI31_MXPA1 XI31_p1 m VDD VDD pm1p2_svt_lp L=6e-08 W=1.5e-07
MI0_MXPA2 XI0_p1 nm VDD VDD pm1p2_svt_lp L=6e-08 W=4.9e-07
MI0_MXPA1 m R XI0_p1 VDD pm1p2_svt_lp L=6e-08 W=4.9e-07
MI20_MXPOEN s nclk m VDD pm1p2_svt_lp L=6e-08 W=2.6e-07
MXP7 s bclk net74 VDD pm1p2_svt_lp L=6e-08 W=2e-07
MXP4 net74 ns net78 VDD pm1p2_svt_lp L=6e-08 W=2e-07
MXP6 net78 R VDD VDD pm1p2_svt_lp L=6e-08 W=2e-07
MI78_MXPA1 ns s VDD VDD pm1p2_svt_lp L=6e-08 W=1.2e-07
MI8_MXPA1 QN s VDD VDD pm1p2_svt_lp L=6e-08 W=5.85e-07
MI23_MXPA1 bclk nclk VDD VDD pm1p2_svt_lp L=6e-08 W=3e-07
MI22_MXPA1 nclk CK VDD VDD pm1p2_svt_lp L=6e-08 W=1.9e-07
.ENDS

.SUBCKT DFFRPQNX2H9R QN VDD VSS CK D R
MI83_MXNA1 nd D VSS VSS nm1p2_svt_lp L=6e-08 W=3.5e-07
MI33_MXNOE nm nclk nd VSS nm1p2_svt_lp L=6e-08 W=3.2e-07
MI31_MXNOE nm bclk XI31_n1 VSS nm1p2_svt_lp L=6e-08 W=1.5e-07
MI31_MXNA1 XI31_n1 m VSS VSS nm1p2_svt_lp L=6e-08 W=1.5e-07
MI0_MXNA2 m nm VSS VSS nm1p2_svt_lp L=6e-08 W=1.5e-07
MI0_MXNA1 m R VSS VSS nm1p2_svt_lp L=6e-08 W=1.5e-07
MI20_MXNOE s bclk m VSS nm1p2_svt_lp L=6e-08 W=3.2e-07
MXN6 s nclk net53 VSS nm1p2_svt_lp L=6e-08 W=1.5e-07
MXN5 net53 ns VSS VSS nm1p2_svt_lp L=6e-08 W=1.5e-07
MXN7 s R VSS VSS nm1p2_svt_lp L=6e-08 W=1.5e-07
MI78_MXNA1 ns s VSS VSS nm1p2_svt_lp L=6e-08 W=1.2e-07
MI8_MXNA1 QN s VSS VSS nm1p2_svt_lp L=6e-08 W=4.2e-07
MI8_MXNA1_2 QN s VSS VSS nm1p2_svt_lp L=6e-08 W=4.2e-07
MI23_MXNA1 bclk nclk VSS VSS nm1p2_svt_lp L=6e-08 W=1.7e-07
MI22_MXNA1 nclk CK VSS VSS nm1p2_svt_lp L=6e-08 W=2.1e-07
MI83_MXPA1 nd D VDD VDD pm1p2_svt_lp L=6e-08 W=4.4e-07
MI33_MXPOEN nm bclk nd VDD pm1p2_svt_lp L=6e-08 W=3.2e-07
MI31_MXPOEN nm nclk XI31_p1 VDD pm1p2_svt_lp L=6e-08 W=1.5e-07
MI31_MXPA1 XI31_p1 m VDD VDD pm1p2_svt_lp L=6e-08 W=1.5e-07
MI0_MXPA2 XI0_p1 nm VDD VDD pm1p2_svt_lp L=6e-08 W=5.2e-07
MI0_MXPA1 m R XI0_p1 VDD pm1p2_svt_lp L=6e-08 W=5.2e-07
MI20_MXPOEN s nclk m VDD pm1p2_svt_lp L=6e-08 W=3.2e-07
MXP7 s bclk net74 VDD pm1p2_svt_lp L=6e-08 W=2e-07
MXP4 net74 ns net78 VDD pm1p2_svt_lp L=6e-08 W=2e-07
MXP6 net78 R VDD VDD pm1p2_svt_lp L=6e-08 W=2e-07
MI78_MXPA1 ns s VDD VDD pm1p2_svt_lp L=6e-08 W=1.2e-07
MI8_MXPA1 QN s VDD VDD pm1p2_svt_lp L=6e-08 W=5.85e-07
MI8_MXPA1_2 QN s VDD VDD pm1p2_svt_lp L=6e-08 W=5.85e-07
MI23_MXPA1 bclk nclk VDD VDD pm1p2_svt_lp L=6e-08 W=3.3e-07
MI22_MXPA1 nclk CK VDD VDD pm1p2_svt_lp L=6e-08 W=2.3e-07
.ENDS

.SUBCKT DFFRPQNX3H9R QN VDD VSS CK D R
MI83_MXNA1 nd D VSS VSS nm1p2_svt_lp L=6e-08 W=4e-07
MI33_MXNOE nm nclk nd VSS nm1p2_svt_lp L=6e-08 W=3.9e-07
MI31_MXNOE nm bclk XI31_n1 VSS nm1p2_svt_lp L=6e-08 W=1.5e-07
MI31_MXNA1 XI31_n1 m VSS VSS nm1p2_svt_lp L=6e-08 W=1.5e-07
MI0_MXNA2 m nm VSS VSS nm1p2_svt_lp L=6e-08 W=1.5e-07
MI0_MXNA1 m R VSS VSS nm1p2_svt_lp L=6e-08 W=1.5e-07
MI20_MXNOE s bclk m VSS nm1p2_svt_lp L=6e-08 W=3.9e-07
MXN6 s nclk net53 VSS nm1p2_svt_lp L=6e-08 W=1.5e-07
MXN5 net53 ns VSS VSS nm1p2_svt_lp L=6e-08 W=1.5e-07
MXN7 s R VSS VSS nm1p2_svt_lp L=6e-08 W=1.5e-07
MI78_MXNA1 ns s VSS VSS nm1p2_svt_lp L=6e-08 W=1.2e-07
MI8_MXNA1 QN s VSS VSS nm1p2_svt_lp L=6e-08 W=4.2e-07
MI8_MXNA1_2 QN s VSS VSS nm1p2_svt_lp L=6e-08 W=4.2e-07
MI8_MXNA1_3 QN s VSS VSS nm1p2_svt_lp L=6e-08 W=4.2e-07
MI23_MXNA1 bclk nclk VSS VSS nm1p2_svt_lp L=6e-08 W=1.8e-07
MI22_MXNA1 nclk CK VSS VSS nm1p2_svt_lp L=6e-08 W=2.2e-07
MI83_MXPA1 nd D VDD VDD pm1p2_svt_lp L=6e-08 W=5.5e-07
MI33_MXPOEN nm bclk nd VDD pm1p2_svt_lp L=6e-08 W=3.9e-07
MI31_MXPOEN nm nclk XI31_p1 VDD pm1p2_svt_lp L=6e-08 W=1.5e-07
MI31_MXPA1 XI31_p1 m VDD VDD pm1p2_svt_lp L=6e-08 W=1.5e-07
MI0_MXPA2 XI0_p1 nm VDD VDD pm1p2_svt_lp L=6e-08 W=5.85e-07
MI0_MXPA1 m R XI0_p1 VDD pm1p2_svt_lp L=6e-08 W=5.85e-07
MI20_MXPOEN s nclk m VDD pm1p2_svt_lp L=6e-08 W=3.9e-07
MXP7 s bclk net74 VDD pm1p2_svt_lp L=6e-08 W=2e-07
MXP4 net74 ns net78 VDD pm1p2_svt_lp L=6e-08 W=2e-07
MXP6 net78 R VDD VDD pm1p2_svt_lp L=6e-08 W=2e-07
MI78_MXPA1 ns s VDD VDD pm1p2_svt_lp L=6e-08 W=1.2e-07
MI8_MXPA1 QN s VDD VDD pm1p2_svt_lp L=6e-08 W=5.85e-07
MI8_MXPA1_2 QN s VDD VDD pm1p2_svt_lp L=6e-08 W=5.85e-07
MI8_MXPA1_3 QN s VDD VDD pm1p2_svt_lp L=6e-08 W=5.85e-07
MI23_MXPA1 bclk nclk VDD VDD pm1p2_svt_lp L=6e-08 W=3.6e-07
MI22_MXPA1 nclk CK VDD VDD pm1p2_svt_lp L=6e-08 W=2.4e-07
.ENDS

.SUBCKT DFFNRPQX1H9R Q VDD VSS CKN D R
MI22_MXNA1 nclk_ CKN VSS VSS nm1p2_svt_lp L=6e-08 W=1.5e-07
MI23_MXNA1 bclk_ nclk_ VSS VSS nm1p2_svt_lp L=6e-08 W=1.7e-07
MI78_MXNA1 nd D VSS VSS nm1p2_svt_lp L=6e-08 W=1.5e-07
MI33_MXNOE nm bclk_ nd VSS nm1p2_svt_lp L=6e-08 W=1.5e-07
MI31_MXNOE nm nclk_ XI31_n1 VSS nm1p2_svt_lp L=6e-08 W=1.5e-07
MI31_MXNA1 XI31_n1 m VSS VSS nm1p2_svt_lp L=6e-08 W=1.5e-07
MI0_MXNA2 m nm VSS VSS nm1p2_svt_lp L=6e-08 W=1.6e-07
MI0_MXNA1 m R VSS VSS nm1p2_svt_lp L=6e-08 W=1.6e-07
MI20_MXNOE s nclk_ m VSS nm1p2_svt_lp L=6e-08 W=1.5e-07
MXN4 s bclk_ net45 VSS nm1p2_svt_lp L=6e-08 W=1.5e-07
MXN0 net45 ns VSS VSS nm1p2_svt_lp L=6e-08 W=1.5e-07
MXN1 s R VSS VSS nm1p2_svt_lp L=6e-08 W=1.5e-07
MI28_MXNA1 ns s VSS VSS nm1p2_svt_lp L=6e-08 W=3.4e-07
MI8_MXNA1 Q ns VSS VSS nm1p2_svt_lp L=6e-08 W=4.2e-07
MI22_MXPA1 nclk_ CKN VDD VDD pm1p2_svt_lp L=6e-08 W=3e-07
MI23_MXPA1 bclk_ nclk_ VDD VDD pm1p2_svt_lp L=6e-08 W=1.9e-07
MI78_MXPA1 nd D VDD VDD pm1p2_svt_lp L=6e-08 W=5.5e-07
MI33_MXPOEN nm nclk_ nd VDD pm1p2_svt_lp L=6e-08 W=3.6e-07
MI31_MXPOEN nm bclk_ XI31_p1 VDD pm1p2_svt_lp L=6e-08 W=1.5e-07
MI31_MXPA1 XI31_p1 m VDD VDD pm1p2_svt_lp L=6e-08 W=1.5e-07
MI0_MXPA2 XI0_p1 nm VDD VDD pm1p2_svt_lp L=6e-08 W=5e-07
MI0_MXPA1 m R XI0_p1 VDD pm1p2_svt_lp L=6e-08 W=5e-07
MI20_MXPOEN s bclk_ m VDD pm1p2_svt_lp L=6e-08 W=3.6e-07
MXP1 s nclk_ net80 VDD pm1p2_svt_lp L=6e-08 W=2e-07
MXP0 net80 ns net72 VDD pm1p2_svt_lp L=6e-08 W=2e-07
MXP5 net72 R VDD VDD pm1p2_svt_lp L=6e-08 W=2e-07
MI28_MXPA1 ns s VDD VDD pm1p2_svt_lp L=6e-08 W=2.3e-07
MI8_MXPA1 Q ns VDD VDD pm1p2_svt_lp L=6e-08 W=5.85e-07
.ENDS

.SUBCKT DFFNRPQX2H9R Q VDD VSS CKN D R
MI22_MXNA1 nclk_ CKN VSS VSS nm1p2_svt_lp L=6e-08 W=1.7e-07
MI23_MXNA1 bclk_ nclk_ VSS VSS nm1p2_svt_lp L=6e-08 W=2.1e-07
MI78_MXNA1 nd D VSS VSS nm1p2_svt_lp L=6e-08 W=1.7e-07
MI33_MXNOE nm bclk_ nd VSS nm1p2_svt_lp L=6e-08 W=1.8e-07
MI31_MXNOE nm nclk_ XI31_n1 VSS nm1p2_svt_lp L=6e-08 W=1.5e-07
MI31_MXNA1 XI31_n1 m VSS VSS nm1p2_svt_lp L=6e-08 W=1.5e-07
MI0_MXNA2 m nm VSS VSS nm1p2_svt_lp L=6e-08 W=2e-07
MI0_MXNA1 m R VSS VSS nm1p2_svt_lp L=6e-08 W=2e-07
MI20_MXNOE s nclk_ m VSS nm1p2_svt_lp L=6e-08 W=1.8e-07
MXN4 s bclk_ net45 VSS nm1p2_svt_lp L=6e-08 W=1.5e-07
MXN0 net45 ns VSS VSS nm1p2_svt_lp L=6e-08 W=1.5e-07
MXN1 s R VSS VSS nm1p2_svt_lp L=6e-08 W=1.5e-07
MI28_MXNA1 ns s VSS VSS nm1p2_svt_lp L=6e-08 W=3.8e-07
MI8_MXNA1 Q ns VSS VSS nm1p2_svt_lp L=6e-08 W=4.2e-07
MI8_MXNA1_2 Q ns VSS VSS nm1p2_svt_lp L=6e-08 W=4.2e-07
MI22_MXPA1 nclk_ CKN VDD VDD pm1p2_svt_lp L=6e-08 W=3.3e-07
MI23_MXPA1 bclk_ nclk_ VDD VDD pm1p2_svt_lp L=6e-08 W=2.3e-07
MI78_MXPA1 nd D VDD VDD pm1p2_svt_lp L=6e-08 W=5e-07
MI33_MXPOEN nm nclk_ nd VDD pm1p2_svt_lp L=6e-08 W=4.5e-07
MI31_MXPOEN nm bclk_ XI31_p1 VDD pm1p2_svt_lp L=6e-08 W=1.5e-07
MI31_MXPA1 XI31_p1 m VDD VDD pm1p2_svt_lp L=6e-08 W=1.5e-07
MI0_MXPA2 XI0_p1 nm VDD VDD pm1p2_svt_lp L=6e-08 W=5e-07
MI0_MXPA1 m R XI0_p1 VDD pm1p2_svt_lp L=6e-08 W=5e-07
MI20_MXPOEN s bclk_ m VDD pm1p2_svt_lp L=6e-08 W=4.5e-07
MXP1 s nclk_ net80 VDD pm1p2_svt_lp L=6e-08 W=2e-07
MXP0 net80 ns net72 VDD pm1p2_svt_lp L=6e-08 W=2e-07
MXP5 net72 R VDD VDD pm1p2_svt_lp L=6e-08 W=2e-07
MI28_MXPA1 ns s VDD VDD pm1p2_svt_lp L=6e-08 W=2.9e-07
MI8_MXPA1 Q ns VDD VDD pm1p2_svt_lp L=6e-08 W=5.85e-07
MI8_MXPA1_2 Q ns VDD VDD pm1p2_svt_lp L=6e-08 W=5.85e-07
.ENDS

.SUBCKT DFFNRPQX3H9R Q VDD VSS CKN D R
MI22_MXNA1 nclk_ CKN VSS VSS nm1p2_svt_lp L=6e-08 W=1.8e-07
MI23_MXNA1 bclk_ nclk_ VSS VSS nm1p2_svt_lp L=6e-08 W=2.2e-07
MI78_MXNA1 nd D VSS VSS nm1p2_svt_lp L=6e-08 W=1.7e-07
MI33_MXNOE nm bclk_ nd VSS nm1p2_svt_lp L=6e-08 W=1.8e-07
MI31_MXNOE nm nclk_ XI31_n1 VSS nm1p2_svt_lp L=6e-08 W=1.5e-07
MI31_MXNA1 XI31_n1 m VSS VSS nm1p2_svt_lp L=6e-08 W=1.5e-07
MI0_MXNA2 m nm VSS VSS nm1p2_svt_lp L=6e-08 W=1.7e-07
MI0_MXNA1 m R VSS VSS nm1p2_svt_lp L=6e-08 W=1.7e-07
MI20_MXNOE s nclk_ m VSS nm1p2_svt_lp L=6e-08 W=1.8e-07
MXN4 s bclk_ net45 VSS nm1p2_svt_lp L=6e-08 W=1.5e-07
MXN0 net45 ns VSS VSS nm1p2_svt_lp L=6e-08 W=1.5e-07
MXN1 s R VSS VSS nm1p2_svt_lp L=6e-08 W=1.5e-07
MI28_MXNA1 ns s VSS VSS nm1p2_svt_lp L=6e-08 W=2.5e-07
MI8_MXNA1 Q ns VSS VSS nm1p2_svt_lp L=6e-08 W=4.2e-07
MI8_MXNA1_2 Q ns VSS VSS nm1p2_svt_lp L=6e-08 W=4.2e-07
MI8_MXNA1_3 Q ns VSS VSS nm1p2_svt_lp L=6e-08 W=4.2e-07
MI22_MXPA1 nclk_ CKN VDD VDD pm1p2_svt_lp L=6e-08 W=3.6e-07
MI23_MXPA1 bclk_ nclk_ VDD VDD pm1p2_svt_lp L=6e-08 W=2.4e-07
MI78_MXPA1 nd D VDD VDD pm1p2_svt_lp L=6e-08 W=5e-07
MI33_MXPOEN nm nclk_ nd VDD pm1p2_svt_lp L=6e-08 W=5.85e-07
MI31_MXPOEN nm bclk_ XI31_p1 VDD pm1p2_svt_lp L=6e-08 W=1.5e-07
MI31_MXPA1 XI31_p1 m VDD VDD pm1p2_svt_lp L=6e-08 W=1.5e-07
MI0_MXPA2 XI0_p1 nm VDD VDD pm1p2_svt_lp L=6e-08 W=5.5e-07
MI0_MXPA1 m R XI0_p1 VDD pm1p2_svt_lp L=6e-08 W=5.5e-07
MI20_MXPOEN s bclk_ m VDD pm1p2_svt_lp L=6e-08 W=5.85e-07
MXP1 s nclk_ net80 VDD pm1p2_svt_lp L=6e-08 W=2e-07
MXP0 net80 ns net72 VDD pm1p2_svt_lp L=6e-08 W=2e-07
MXP5 net72 R VDD VDD pm1p2_svt_lp L=6e-08 W=2e-07
MI28_MXPA1 ns s VDD VDD pm1p2_svt_lp L=6e-08 W=2.5e-07
MI8_MXPA1 Q ns VDD VDD pm1p2_svt_lp L=6e-08 W=5.85e-07
MI8_MXPA1_2 Q ns VDD VDD pm1p2_svt_lp L=6e-08 W=5.85e-07
MI8_MXPA1_3 Q ns VDD VDD pm1p2_svt_lp L=6e-08 W=5.85e-07
.ENDS

.SUBCKT DFFSQX0P5H9R Q VDD VSS CK D SN
MI22_MXNA1 nclk CK VSS VSS nm1p2_svt_lp L=6e-08 W=1.5e-07
MI23_MXNA1 bclk nclk VSS VSS nm1p2_svt_lp L=6e-08 W=1.5e-07
MI79_MXNA1 nd D VSS VSS nm1p2_svt_lp L=6e-08 W=2e-07
MI33_MXNOE nm nclk nd VSS nm1p2_svt_lp L=6e-08 W=1.5e-07
MI31_MXNOE nm bclk XI31_n1 VSS nm1p2_svt_lp L=6e-08 W=1.5e-07
MI31_MXNA1 XI31_n1 m VSS VSS nm1p2_svt_lp L=6e-08 W=1.5e-07
MI0_MXNA2 XI0_n1 nm VSS VSS nm1p2_svt_lp L=6e-08 W=1.7e-07
MI0_MXNA1 m SN XI0_n1 VSS nm1p2_svt_lp L=6e-08 W=1.7e-07
MI20_MXNOE s bclk m VSS nm1p2_svt_lp L=6e-08 W=1.5e-07
MXN4 s nclk net54 VSS nm1p2_svt_lp L=6e-08 W=2e-07
MXN0 net54 ns net50 VSS nm1p2_svt_lp L=6e-08 W=2e-07
MXN1 net50 SN VSS VSS nm1p2_svt_lp L=6e-08 W=2e-07
MI28_MXNA1 ns s VSS VSS nm1p2_svt_lp L=6e-08 W=1.5e-07
MI8_MXNA1 Q ns VSS VSS nm1p2_svt_lp L=6e-08 W=2.1e-07
MI22_MXPA1 nclk CK VDD VDD pm1p2_svt_lp L=6e-08 W=1.7e-07
MI23_MXPA1 bclk nclk VDD VDD pm1p2_svt_lp L=6e-08 W=1.9e-07
MI79_MXPA1 nd D VDD VDD pm1p2_svt_lp L=6e-08 W=1.75e-07
MI33_MXPOEN nm bclk nd VDD pm1p2_svt_lp L=6e-08 W=1.5e-07
MI31_MXPOEN nm nclk XI31_p1 VDD pm1p2_svt_lp L=6e-08 W=1.5e-07
MI31_MXPA1 XI31_p1 m VDD VDD pm1p2_svt_lp L=6e-08 W=1.5e-07
MI0_MXPA2 m nm VDD VDD pm1p2_svt_lp L=6e-08 W=1.8e-07
MI0_MXPA1 m SN VDD VDD pm1p2_svt_lp L=6e-08 W=1.8e-07
MI20_MXPOEN s nclk m VDD pm1p2_svt_lp L=6e-08 W=1.5e-07
MXP0 s bclk net73 VDD pm1p2_svt_lp L=6e-08 W=1.5e-07
MXP1 net73 ns VDD VDD pm1p2_svt_lp L=6e-08 W=1.5e-07
MXP4 s SN VDD VDD pm1p2_svt_lp L=6e-08 W=1.5e-07
MI28_MXPA1 ns s VDD VDD pm1p2_svt_lp L=6e-08 W=2.7e-07
MI8_MXPA1 Q ns VDD VDD pm1p2_svt_lp L=6e-08 W=2.95e-07
.ENDS

.SUBCKT DFFSQX1H9R Q VDD VSS CK D SN
MI22_MXNA1 nclk CK VSS VSS nm1p2_svt_lp L=6e-08 W=1.7e-07
MI23_MXNA1 bclk nclk VSS VSS nm1p2_svt_lp L=6e-08 W=1.5e-07
MI79_MXNA1 nd D VSS VSS nm1p2_svt_lp L=6e-08 W=3.4e-07
MI33_MXNOE nm nclk nd VSS nm1p2_svt_lp L=6e-08 W=2.6e-07
MI31_MXNOE nm bclk XI31_n1 VSS nm1p2_svt_lp L=6e-08 W=1.5e-07
MI31_MXNA1 XI31_n1 m VSS VSS nm1p2_svt_lp L=6e-08 W=1.5e-07
MI0_MXNA2 XI0_n1 nm VSS VSS nm1p2_svt_lp L=6e-08 W=2.6e-07
MI0_MXNA1 m SN XI0_n1 VSS nm1p2_svt_lp L=6e-08 W=2.6e-07
MI20_MXNOE s bclk m VSS nm1p2_svt_lp L=6e-08 W=2.6e-07
MXN4 s nclk net54 VSS nm1p2_svt_lp L=6e-08 W=2e-07
MXN0 net54 ns net50 VSS nm1p2_svt_lp L=6e-08 W=2e-07
MXN1 net50 SN VSS VSS nm1p2_svt_lp L=6e-08 W=2e-07
MI28_MXNA1 ns s VSS VSS nm1p2_svt_lp L=6e-08 W=2.1e-07
MI8_MXNA1 Q ns VSS VSS nm1p2_svt_lp L=6e-08 W=4.2e-07
MI22_MXPA1 nclk CK VDD VDD pm1p2_svt_lp L=6e-08 W=1.9e-07
MI23_MXPA1 bclk nclk VDD VDD pm1p2_svt_lp L=6e-08 W=3e-07
MI79_MXPA1 nd D VDD VDD pm1p2_svt_lp L=6e-08 W=2.6e-07
MI33_MXPOEN nm bclk nd VDD pm1p2_svt_lp L=6e-08 W=2.6e-07
MI31_MXPOEN nm nclk XI31_p1 VDD pm1p2_svt_lp L=6e-08 W=1.5e-07
MI31_MXPA1 XI31_p1 m VDD VDD pm1p2_svt_lp L=6e-08 W=1.5e-07
MI0_MXPA2 m nm VDD VDD pm1p2_svt_lp L=6e-08 W=2.5e-07
MI0_MXPA1 m SN VDD VDD pm1p2_svt_lp L=6e-08 W=2.5e-07
MI20_MXPOEN s nclk m VDD pm1p2_svt_lp L=6e-08 W=2.6e-07
MXP0 s bclk net73 VDD pm1p2_svt_lp L=6e-08 W=1.5e-07
MXP1 net73 ns VDD VDD pm1p2_svt_lp L=6e-08 W=1.5e-07
MXP4 s SN VDD VDD pm1p2_svt_lp L=6e-08 W=1.5e-07
MI28_MXPA1 ns s VDD VDD pm1p2_svt_lp L=6e-08 W=3.85e-07
MI8_MXPA1 Q ns VDD VDD pm1p2_svt_lp L=6e-08 W=5.85e-07
.ENDS

.SUBCKT DFFSQX2H9R Q VDD VSS CK D SN
MI22_MXNA1 nclk CK VSS VSS nm1p2_svt_lp L=6e-08 W=2.1e-07
MI23_MXNA1 bclk nclk VSS VSS nm1p2_svt_lp L=6e-08 W=1.7e-07
MI79_MXNA1 nd D VSS VSS nm1p2_svt_lp L=6e-08 W=4.2e-07
MI33_MXNOE nm nclk nd VSS nm1p2_svt_lp L=6e-08 W=3.2e-07
MI31_MXNOE nm bclk XI31_n1 VSS nm1p2_svt_lp L=6e-08 W=1.5e-07
MI31_MXNA1 XI31_n1 m VSS VSS nm1p2_svt_lp L=6e-08 W=1.5e-07
MI0_MXNA2 XI0_n1 nm VSS VSS nm1p2_svt_lp L=6e-08 W=3.5e-07
MI0_MXNA1 m SN XI0_n1 VSS nm1p2_svt_lp L=6e-08 W=3.5e-07
MI20_MXNOE s bclk m VSS nm1p2_svt_lp L=6e-08 W=3.2e-07
MXN4 s nclk net54 VSS nm1p2_svt_lp L=6e-08 W=2e-07
MXN0 net54 ns net50 VSS nm1p2_svt_lp L=6e-08 W=2e-07
MXN1 net50 SN VSS VSS nm1p2_svt_lp L=6e-08 W=2e-07
MI28_MXNA1 ns s VSS VSS nm1p2_svt_lp L=6e-08 W=3e-07
MI8_MXNA1 Q ns VSS VSS nm1p2_svt_lp L=6e-08 W=4.2e-07
MI8_MXNA1_2 Q ns VSS VSS nm1p2_svt_lp L=6e-08 W=4.2e-07
MI22_MXPA1 nclk CK VDD VDD pm1p2_svt_lp L=6e-08 W=2.3e-07
MI23_MXPA1 bclk nclk VDD VDD pm1p2_svt_lp L=6e-08 W=3.3e-07
MI79_MXPA1 nd D VDD VDD pm1p2_svt_lp L=6e-08 W=3.1e-07
MI33_MXPOEN nm bclk nd VDD pm1p2_svt_lp L=6e-08 W=3.2e-07
MI31_MXPOEN nm nclk XI31_p1 VDD pm1p2_svt_lp L=6e-08 W=1.5e-07
MI31_MXPA1 XI31_p1 m VDD VDD pm1p2_svt_lp L=6e-08 W=1.5e-07
MI0_MXPA2 m nm VDD VDD pm1p2_svt_lp L=6e-08 W=3e-07
MI0_MXPA1 m SN VDD VDD pm1p2_svt_lp L=6e-08 W=3e-07
MI20_MXPOEN s nclk m VDD pm1p2_svt_lp L=6e-08 W=3.2e-07
MXP0 s bclk net73 VDD pm1p2_svt_lp L=6e-08 W=1.5e-07
MXP1 net73 ns VDD VDD pm1p2_svt_lp L=6e-08 W=1.5e-07
MXP4 s SN VDD VDD pm1p2_svt_lp L=6e-08 W=1.5e-07
MI28_MXPA1 ns s VDD VDD pm1p2_svt_lp L=6e-08 W=4.9e-07
MI8_MXPA1 Q ns VDD VDD pm1p2_svt_lp L=6e-08 W=5.85e-07
MI8_MXPA1_2 Q ns VDD VDD pm1p2_svt_lp L=6e-08 W=5.85e-07
.ENDS

.SUBCKT DFFSQX3H9R Q VDD VSS CK D SN
MI22_MXNA1 nclk CK VSS VSS nm1p2_svt_lp L=6e-08 W=2.2e-07
MI23_MXNA1 bclk nclk VSS VSS nm1p2_svt_lp L=6e-08 W=1.8e-07
MI79_MXNA1 nd D VSS VSS nm1p2_svt_lp L=6e-08 W=4.5e-07
MI33_MXNOE nm nclk nd VSS nm1p2_svt_lp L=6e-08 W=3.9e-07
MI31_MXNOE nm bclk XI31_n1 VSS nm1p2_svt_lp L=6e-08 W=1.5e-07
MI31_MXNA1 XI31_n1 m VSS VSS nm1p2_svt_lp L=6e-08 W=1.5e-07
MI0_MXNA2 XI0_n1 nm VSS VSS nm1p2_svt_lp L=6e-08 W=4.95e-07
MI0_MXNA1 m SN XI0_n1 VSS nm1p2_svt_lp L=6e-08 W=4.95e-07
MI20_MXNOE s bclk m VSS nm1p2_svt_lp L=6e-08 W=3.9e-07
MXN4 s nclk net54 VSS nm1p2_svt_lp L=6e-08 W=2e-07
MXN0 net54 ns net50 VSS nm1p2_svt_lp L=6e-08 W=2e-07
MXN1 net50 SN VSS VSS nm1p2_svt_lp L=6e-08 W=2e-07
MI28_MXNA1 ns s VSS VSS nm1p2_svt_lp L=6e-08 W=3.1e-07
MI8_MXNA1 Q ns VSS VSS nm1p2_svt_lp L=6e-08 W=4.2e-07
MI8_MXNA1_2 Q ns VSS VSS nm1p2_svt_lp L=6e-08 W=4.2e-07
MI8_MXNA1_3 Q ns VSS VSS nm1p2_svt_lp L=6e-08 W=4.2e-07
MI22_MXPA1 nclk CK VDD VDD pm1p2_svt_lp L=6e-08 W=2.4e-07
MI23_MXPA1 bclk nclk VDD VDD pm1p2_svt_lp L=6e-08 W=3.6e-07
MI79_MXPA1 nd D VDD VDD pm1p2_svt_lp L=6e-08 W=3.3e-07
MI33_MXPOEN nm bclk nd VDD pm1p2_svt_lp L=6e-08 W=3.9e-07
MI31_MXPOEN nm nclk XI31_p1 VDD pm1p2_svt_lp L=6e-08 W=1.5e-07
MI31_MXPA1 XI31_p1 m VDD VDD pm1p2_svt_lp L=6e-08 W=1.5e-07
MI0_MXPA2 m nm VDD VDD pm1p2_svt_lp L=6e-08 W=4.55e-07
MI0_MXPA1 m SN VDD VDD pm1p2_svt_lp L=6e-08 W=4.55e-07
MI20_MXPOEN s nclk m VDD pm1p2_svt_lp L=6e-08 W=3.9e-07
MXP0 s bclk net73 VDD pm1p2_svt_lp L=6e-08 W=1.5e-07
MXP1 net73 ns VDD VDD pm1p2_svt_lp L=6e-08 W=1.5e-07
MXP4 s SN VDD VDD pm1p2_svt_lp L=6e-08 W=1.5e-07
MI28_MXPA1 ns s VDD VDD pm1p2_svt_lp L=6e-08 W=5.8e-07
MI8_MXPA1 Q ns VDD VDD pm1p2_svt_lp L=6e-08 W=5.85e-07
MI8_MXPA1_2 Q ns VDD VDD pm1p2_svt_lp L=6e-08 W=5.85e-07
MI8_MXPA1_3 Q ns VDD VDD pm1p2_svt_lp L=6e-08 W=5.85e-07
.ENDS

.SUBCKT DFFSQX4H9R Q VDD VSS CK D SN
MI22_MXNA1 nclk CK VSS VSS nm1p2_svt_lp L=6e-08 W=2.5e-07
MI23_MXNA1 bclk nclk VSS VSS nm1p2_svt_lp L=6e-08 W=2.1e-07
MI79_MXNA1 nd D VSS VSS nm1p2_svt_lp L=6e-08 W=4.95e-07
MI33_MXNOE nm nclk nd VSS nm1p2_svt_lp L=6e-08 W=4.5e-07
MI31_MXNOE nm bclk XI31_n1 VSS nm1p2_svt_lp L=6e-08 W=1.5e-07
MI31_MXNA1 XI31_n1 m VSS VSS nm1p2_svt_lp L=6e-08 W=1.5e-07
MI0_MXNA2 XI0_n1 nm VSS VSS nm1p2_svt_lp L=6e-08 W=4.95e-07
MI0_MXNA1 m SN XI0_n1 VSS nm1p2_svt_lp L=6e-08 W=4.95e-07
MI20_MXNOE s bclk m VSS nm1p2_svt_lp L=6e-08 W=4.5e-07
MXN4 s nclk net54 VSS nm1p2_svt_lp L=6e-08 W=2e-07
MXN0 net54 ns net50 VSS nm1p2_svt_lp L=6e-08 W=2e-07
MXN1 net50 SN VSS VSS nm1p2_svt_lp L=6e-08 W=2e-07
MI28_MXNA1 ns s VSS VSS nm1p2_svt_lp L=6e-08 W=3.4e-07
MI28_MXNA1_2 ns s VSS VSS nm1p2_svt_lp L=6e-08 W=3.4e-07
MI8_MXNA1 Q ns VSS VSS nm1p2_svt_lp L=6e-08 W=4.2e-07
MI8_MXNA1_2 Q ns VSS VSS nm1p2_svt_lp L=6e-08 W=4.2e-07
MI8_MXNA1_3 Q ns VSS VSS nm1p2_svt_lp L=6e-08 W=4.2e-07
MI8_MXNA1_4 Q ns VSS VSS nm1p2_svt_lp L=6e-08 W=4.2e-07
MI22_MXPA1 nclk CK VDD VDD pm1p2_svt_lp L=6e-08 W=2.8e-07
MI23_MXPA1 bclk nclk VDD VDD pm1p2_svt_lp L=6e-08 W=4.2e-07
MI79_MXPA1 nd D VDD VDD pm1p2_svt_lp L=6e-08 W=3.8e-07
MI33_MXPOEN nm bclk nd VDD pm1p2_svt_lp L=6e-08 W=4.5e-07
MI31_MXPOEN nm nclk XI31_p1 VDD pm1p2_svt_lp L=6e-08 W=1.5e-07
MI31_MXPA1 XI31_p1 m VDD VDD pm1p2_svt_lp L=6e-08 W=1.5e-07
MI0_MXPA2 m nm VDD VDD pm1p2_svt_lp L=6e-08 W=4.55e-07
MI0_MXPA1 m SN VDD VDD pm1p2_svt_lp L=6e-08 W=4.55e-07
MI20_MXPOEN s nclk m VDD pm1p2_svt_lp L=6e-08 W=4.5e-07
MXP0 s bclk net73 VDD pm1p2_svt_lp L=6e-08 W=1.5e-07
MXP1 net73 ns VDD VDD pm1p2_svt_lp L=6e-08 W=1.5e-07
MXP4 s SN VDD VDD pm1p2_svt_lp L=6e-08 W=1.5e-07
MI28_MXPA1 ns s VDD VDD pm1p2_svt_lp L=6e-08 W=5e-07
MI28_MXPA1_2 ns s VDD VDD pm1p2_svt_lp L=6e-08 W=5e-07
MI8_MXPA1 Q ns VDD VDD pm1p2_svt_lp L=6e-08 W=5.85e-07
MI8_MXPA1_2 Q ns VDD VDD pm1p2_svt_lp L=6e-08 W=5.85e-07
MI8_MXPA1_3 Q ns VDD VDD pm1p2_svt_lp L=6e-08 W=5.85e-07
MI8_MXPA1_4 Q ns VDD VDD pm1p2_svt_lp L=6e-08 W=5.85e-07
.ENDS

.SUBCKT DFFSQNX0P5H9R QN VDD VSS CK D SN
MI83_MXNA1 nd D VSS VSS nm1p2_svt_lp L=6e-08 W=2.6e-07
MI33_MXNOE nm nclk nd VSS nm1p2_svt_lp L=6e-08 W=1.5e-07
MI31_MXNOE nm bclk XI31_n1 VSS nm1p2_svt_lp L=6e-08 W=1.5e-07
MI31_MXNA1 XI31_n1 m VSS VSS nm1p2_svt_lp L=6e-08 W=1.5e-07
MI0_MXNA2 XI0_n1 nm VSS VSS nm1p2_svt_lp L=6e-08 W=2.5e-07
MI0_MXNA1 m SN XI0_n1 VSS nm1p2_svt_lp L=6e-08 W=2.5e-07
MI20_MXNOE s bclk m VSS nm1p2_svt_lp L=6e-08 W=1.5e-07
MXN4 s nclk net58 VSS nm1p2_svt_lp L=6e-08 W=2e-07
MXN0 net58 ns net54 VSS nm1p2_svt_lp L=6e-08 W=2e-07
MXN1 net54 SN VSS VSS nm1p2_svt_lp L=6e-08 W=2e-07
MI28_MXNA1 ns s VSS VSS nm1p2_svt_lp L=6e-08 W=1.2e-07
MI8_MXNA1 QN s VSS VSS nm1p2_svt_lp L=6e-08 W=2.1e-07
MI23_MXNA1 bclk nclk VSS VSS nm1p2_svt_lp L=6e-08 W=1.5e-07
MI22_MXNA1 nclk CK VSS VSS nm1p2_svt_lp L=6e-08 W=1.5e-07
MI83_MXPA1 nd D VDD VDD pm1p2_svt_lp L=6e-08 W=1.55e-07
MI33_MXPOEN nm bclk nd VDD pm1p2_svt_lp L=6e-08 W=1.5e-07
MI31_MXPOEN nm nclk XI31_p1 VDD pm1p2_svt_lp L=6e-08 W=1.5e-07
MI31_MXPA1 XI31_p1 m VDD VDD pm1p2_svt_lp L=6e-08 W=1.5e-07
MI0_MXPA2 m nm VDD VDD pm1p2_svt_lp L=6e-08 W=1.5e-07
MI0_MXPA1 m SN VDD VDD pm1p2_svt_lp L=6e-08 W=1.5e-07
MI20_MXPOEN s nclk m VDD pm1p2_svt_lp L=6e-08 W=1.5e-07
MXP1 s bclk net79 VDD pm1p2_svt_lp L=6e-08 W=1.5e-07
MXP0 net79 ns VDD VDD pm1p2_svt_lp L=6e-08 W=1.5e-07
MXP4 s SN VDD VDD pm1p2_svt_lp L=6e-08 W=1.5e-07
MI28_MXPA1 ns s VDD VDD pm1p2_svt_lp L=6e-08 W=1.2e-07
MI8_MXPA1 QN s VDD VDD pm1p2_svt_lp L=6e-08 W=2.95e-07
MI23_MXPA1 bclk nclk VDD VDD pm1p2_svt_lp L=6e-08 W=1.9e-07
MI22_MXPA1 nclk CK VDD VDD pm1p2_svt_lp L=6e-08 W=1.7e-07
.ENDS

.SUBCKT DFFSQNX1H9R QN VDD VSS CK D SN
MI83_MXNA1 nd D VSS VSS nm1p2_svt_lp L=6e-08 W=4.1e-07
MI33_MXNOE nm nclk nd VSS nm1p2_svt_lp L=6e-08 W=2.6e-07
MI31_MXNOE nm bclk XI31_n1 VSS nm1p2_svt_lp L=6e-08 W=1.5e-07
MI31_MXNA1 XI31_n1 m VSS VSS nm1p2_svt_lp L=6e-08 W=1.5e-07
MI0_MXNA2 XI0_n1 nm VSS VSS nm1p2_svt_lp L=6e-08 W=3.2e-07
MI0_MXNA1 m SN XI0_n1 VSS nm1p2_svt_lp L=6e-08 W=3.2e-07
MI20_MXNOE s bclk m VSS nm1p2_svt_lp L=6e-08 W=2.6e-07
MXN4 s nclk net58 VSS nm1p2_svt_lp L=6e-08 W=2e-07
MXN0 net58 ns net54 VSS nm1p2_svt_lp L=6e-08 W=2e-07
MXN1 net54 SN VSS VSS nm1p2_svt_lp L=6e-08 W=2e-07
MI28_MXNA1 ns s VSS VSS nm1p2_svt_lp L=6e-08 W=1.2e-07
MI8_MXNA1 QN s VSS VSS nm1p2_svt_lp L=6e-08 W=4.2e-07
MI23_MXNA1 bclk nclk VSS VSS nm1p2_svt_lp L=6e-08 W=1.5e-07
MI22_MXNA1 nclk CK VSS VSS nm1p2_svt_lp L=6e-08 W=1.7e-07
MI83_MXPA1 nd D VDD VDD pm1p2_svt_lp L=6e-08 W=2.7e-07
MI33_MXPOEN nm bclk nd VDD pm1p2_svt_lp L=6e-08 W=2.6e-07
MI31_MXPOEN nm nclk XI31_p1 VDD pm1p2_svt_lp L=6e-08 W=1.5e-07
MI31_MXPA1 XI31_p1 m VDD VDD pm1p2_svt_lp L=6e-08 W=1.5e-07
MI0_MXPA2 m nm VDD VDD pm1p2_svt_lp L=6e-08 W=2.4e-07
MI0_MXPA1 m SN VDD VDD pm1p2_svt_lp L=6e-08 W=2.4e-07
MI20_MXPOEN s nclk m VDD pm1p2_svt_lp L=6e-08 W=2.6e-07
MXP1 s bclk net79 VDD pm1p2_svt_lp L=6e-08 W=1.5e-07
MXP0 net79 ns VDD VDD pm1p2_svt_lp L=6e-08 W=1.5e-07
MXP4 s SN VDD VDD pm1p2_svt_lp L=6e-08 W=1.5e-07
MI28_MXPA1 ns s VDD VDD pm1p2_svt_lp L=6e-08 W=1.2e-07
MI8_MXPA1 QN s VDD VDD pm1p2_svt_lp L=6e-08 W=5.85e-07
MI23_MXPA1 bclk nclk VDD VDD pm1p2_svt_lp L=6e-08 W=3e-07
MI22_MXPA1 nclk CK VDD VDD pm1p2_svt_lp L=6e-08 W=1.9e-07
.ENDS

.SUBCKT DFFSQNX2H9R QN VDD VSS CK D SN
MI83_MXNA1 nd D VSS VSS nm1p2_svt_lp L=6e-08 W=4.2e-07
MI33_MXNOE nm nclk nd VSS nm1p2_svt_lp L=6e-08 W=3.2e-07
MI31_MXNOE nm bclk XI31_n1 VSS nm1p2_svt_lp L=6e-08 W=1.5e-07
MI31_MXNA1 XI31_n1 m VSS VSS nm1p2_svt_lp L=6e-08 W=1.5e-07
MI0_MXNA2 XI0_n1 nm VSS VSS nm1p2_svt_lp L=6e-08 W=4.95e-07
MI0_MXNA1 m SN XI0_n1 VSS nm1p2_svt_lp L=6e-08 W=4.95e-07
MI20_MXNOE s bclk m VSS nm1p2_svt_lp L=6e-08 W=3.2e-07
MXN4 s nclk net58 VSS nm1p2_svt_lp L=6e-08 W=2e-07
MXN0 net58 ns net54 VSS nm1p2_svt_lp L=6e-08 W=2e-07
MXN1 net54 SN VSS VSS nm1p2_svt_lp L=6e-08 W=2e-07
MI28_MXNA1 ns s VSS VSS nm1p2_svt_lp L=6e-08 W=1.2e-07
MI8_MXNA1 QN s VSS VSS nm1p2_svt_lp L=6e-08 W=4.2e-07
MI8_MXNA1_2 QN s VSS VSS nm1p2_svt_lp L=6e-08 W=4.2e-07
MI23_MXNA1 bclk nclk VSS VSS nm1p2_svt_lp L=6e-08 W=1.7e-07
MI22_MXNA1 nclk CK VSS VSS nm1p2_svt_lp L=6e-08 W=2.1e-07
MI83_MXPA1 nd D VDD VDD pm1p2_svt_lp L=6e-08 W=3.1e-07
MI33_MXPOEN nm bclk nd VDD pm1p2_svt_lp L=6e-08 W=3.2e-07
MI31_MXPOEN nm nclk XI31_p1 VDD pm1p2_svt_lp L=6e-08 W=1.5e-07
MI31_MXPA1 XI31_p1 m VDD VDD pm1p2_svt_lp L=6e-08 W=1.5e-07
MI0_MXPA2 m nm VDD VDD pm1p2_svt_lp L=6e-08 W=4.1e-07
MI0_MXPA1 m SN VDD VDD pm1p2_svt_lp L=6e-08 W=4.1e-07
MI20_MXPOEN s nclk m VDD pm1p2_svt_lp L=6e-08 W=3.2e-07
MXP1 s bclk net79 VDD pm1p2_svt_lp L=6e-08 W=1.5e-07
MXP0 net79 ns VDD VDD pm1p2_svt_lp L=6e-08 W=1.5e-07
MXP4 s SN VDD VDD pm1p2_svt_lp L=6e-08 W=1.5e-07
MI28_MXPA1 ns s VDD VDD pm1p2_svt_lp L=6e-08 W=1.2e-07
MI8_MXPA1 QN s VDD VDD pm1p2_svt_lp L=6e-08 W=5.85e-07
MI8_MXPA1_2 QN s VDD VDD pm1p2_svt_lp L=6e-08 W=5.85e-07
MI23_MXPA1 bclk nclk VDD VDD pm1p2_svt_lp L=6e-08 W=3.3e-07
MI22_MXPA1 nclk CK VDD VDD pm1p2_svt_lp L=6e-08 W=2.3e-07
.ENDS

.SUBCKT DFFSQNX3H9R QN VDD VSS CK D SN
MI83_MXNA1 nd D VSS VSS nm1p2_svt_lp L=6e-08 W=4.2e-07
MI33_MXNOE nm nclk nd VSS nm1p2_svt_lp L=6e-08 W=3.9e-07
MI31_MXNOE nm bclk XI31_n1 VSS nm1p2_svt_lp L=6e-08 W=1.5e-07
MI31_MXNA1 XI31_n1 m VSS VSS nm1p2_svt_lp L=6e-08 W=1.5e-07
MI0_MXNA2 XI0_n1 nm VSS VSS nm1p2_svt_lp L=6e-08 W=4e-07
MI0_MXNA1 m SN XI0_n1 VSS nm1p2_svt_lp L=6e-08 W=4e-07
MI20_MXNOE s bclk m VSS nm1p2_svt_lp L=6e-08 W=3.9e-07
MXN4 s nclk net58 VSS nm1p2_svt_lp L=6e-08 W=2e-07
MXN0 net58 ns net54 VSS nm1p2_svt_lp L=6e-08 W=2e-07
MXN1 net54 SN VSS VSS nm1p2_svt_lp L=6e-08 W=2e-07
MI28_MXNA1 ns s VSS VSS nm1p2_svt_lp L=6e-08 W=1.2e-07
MI8_MXNA1 QN s VSS VSS nm1p2_svt_lp L=6e-08 W=4.2e-07
MI8_MXNA1_2 QN s VSS VSS nm1p2_svt_lp L=6e-08 W=4.2e-07
MI8_MXNA1_3 QN s VSS VSS nm1p2_svt_lp L=6e-08 W=4.2e-07
MI23_MXNA1 bclk nclk VSS VSS nm1p2_svt_lp L=6e-08 W=1.8e-07
MI22_MXNA1 nclk CK VSS VSS nm1p2_svt_lp L=6e-08 W=2.2e-07
MI83_MXPA1 nd D VDD VDD pm1p2_svt_lp L=6e-08 W=3.3e-07
MI33_MXPOEN nm bclk nd VDD pm1p2_svt_lp L=6e-08 W=3.9e-07
MI31_MXPOEN nm nclk XI31_p1 VDD pm1p2_svt_lp L=6e-08 W=1.5e-07
MI31_MXPA1 XI31_p1 m VDD VDD pm1p2_svt_lp L=6e-08 W=1.5e-07
MI0_MXPA2 m nm VDD VDD pm1p2_svt_lp L=6e-08 W=4.1e-07
MI0_MXPA1 m SN VDD VDD pm1p2_svt_lp L=6e-08 W=4.1e-07
MI20_MXPOEN s nclk m VDD pm1p2_svt_lp L=6e-08 W=3.9e-07
MXP1 s bclk net79 VDD pm1p2_svt_lp L=6e-08 W=1.5e-07
MXP0 net79 ns VDD VDD pm1p2_svt_lp L=6e-08 W=1.5e-07
MXP4 s SN VDD VDD pm1p2_svt_lp L=6e-08 W=1.5e-07
MI28_MXPA1 ns s VDD VDD pm1p2_svt_lp L=6e-08 W=1.2e-07
MI8_MXPA1 QN s VDD VDD pm1p2_svt_lp L=6e-08 W=5.85e-07
MI8_MXPA1_2 QN s VDD VDD pm1p2_svt_lp L=6e-08 W=5.85e-07
MI8_MXPA1_3 QN s VDD VDD pm1p2_svt_lp L=6e-08 W=5.85e-07
MI23_MXPA1 bclk nclk VDD VDD pm1p2_svt_lp L=6e-08 W=3.6e-07
MI22_MXPA1 nclk CK VDD VDD pm1p2_svt_lp L=6e-08 W=2.4e-07
.ENDS

.SUBCKT DFFNSQX1H9R Q VDD VSS CKN D SN
MI22_MXNA1 nclk_ CKN VSS VSS nm1p2_svt_lp L=6e-08 W=1.5e-07
MI23_MXNA1 bclk_ nclk_ VSS VSS nm1p2_svt_lp L=6e-08 W=1.7e-07
MI79_MXNA1 nd D VSS VSS nm1p2_svt_lp L=6e-08 W=1.5e-07
MI33_MXNOE nm bclk_ nd VSS nm1p2_svt_lp L=6e-08 W=1.5e-07
MI31_MXNOE nm nclk_ XI31_n1 VSS nm1p2_svt_lp L=6e-08 W=1.5e-07
MI31_MXNA1 XI31_n1 m VSS VSS nm1p2_svt_lp L=6e-08 W=1.5e-07
MI0_MXNA2 XI0_n1 nm VSS VSS nm1p2_svt_lp L=6e-08 W=2.5e-07
MI0_MXNA1 m SN XI0_n1 VSS nm1p2_svt_lp L=6e-08 W=2.5e-07
MI20_MXNOE s nclk_ m VSS nm1p2_svt_lp L=6e-08 W=1.5e-07
MXN4 s bclk_ net54 VSS nm1p2_svt_lp L=6e-08 W=2e-07
MXN0 net54 ns net50 VSS nm1p2_svt_lp L=6e-08 W=2e-07
MXN1 net50 SN VSS VSS nm1p2_svt_lp L=6e-08 W=2e-07
MI28_MXNA1 ns s VSS VSS nm1p2_svt_lp L=6e-08 W=3.3e-07
MI8_MXNA1 Q ns VSS VSS nm1p2_svt_lp L=6e-08 W=4.2e-07
MI22_MXPA1 nclk_ CKN VDD VDD pm1p2_svt_lp L=6e-08 W=3e-07
MI23_MXPA1 bclk_ nclk_ VDD VDD pm1p2_svt_lp L=6e-08 W=1.9e-07
MI79_MXPA1 nd D VDD VDD pm1p2_svt_lp L=6e-08 W=5.2e-07
MI33_MXPOEN nm nclk_ nd VDD pm1p2_svt_lp L=6e-08 W=3.6e-07
MI31_MXPOEN nm bclk_ XI31_p1 VDD pm1p2_svt_lp L=6e-08 W=1.5e-07
MI31_MXPA1 XI31_p1 m VDD VDD pm1p2_svt_lp L=6e-08 W=1.5e-07
MI0_MXPA2 m nm VDD VDD pm1p2_svt_lp L=6e-08 W=3e-07
MI0_MXPA1 m SN VDD VDD pm1p2_svt_lp L=6e-08 W=3e-07
MI20_MXPOEN s bclk_ m VDD pm1p2_svt_lp L=6e-08 W=3.6e-07
MXP0 s nclk_ net73 VDD pm1p2_svt_lp L=6e-08 W=1.5e-07
MXP1 net73 ns VDD VDD pm1p2_svt_lp L=6e-08 W=1.5e-07
MXP4 s SN VDD VDD pm1p2_svt_lp L=6e-08 W=1.5e-07
MI28_MXPA1 ns s VDD VDD pm1p2_svt_lp L=6e-08 W=2.5e-07
MI8_MXPA1 Q ns VDD VDD pm1p2_svt_lp L=6e-08 W=5.85e-07
.ENDS

.SUBCKT DFFNSQX2H9R Q VDD VSS CKN D SN
MI22_MXNA1 nclk_ CKN VSS VSS nm1p2_svt_lp L=6e-08 W=1.7e-07
MI23_MXNA1 bclk_ nclk_ VSS VSS nm1p2_svt_lp L=6e-08 W=2.1e-07
MI79_MXNA1 nd D VSS VSS nm1p2_svt_lp L=6e-08 W=1.5e-07
MI33_MXNOE nm bclk_ nd VSS nm1p2_svt_lp L=6e-08 W=1.8e-07
MI31_MXNOE nm nclk_ XI31_n1 VSS nm1p2_svt_lp L=6e-08 W=1.5e-07
MI31_MXNA1 XI31_n1 m VSS VSS nm1p2_svt_lp L=6e-08 W=1.5e-07
MI0_MXNA2 XI0_n1 nm VSS VSS nm1p2_svt_lp L=6e-08 W=2.5e-07
MI0_MXNA1 m SN XI0_n1 VSS nm1p2_svt_lp L=6e-08 W=2.5e-07
MI20_MXNOE s nclk_ m VSS nm1p2_svt_lp L=6e-08 W=1.8e-07
MXN4 s bclk_ net54 VSS nm1p2_svt_lp L=6e-08 W=2e-07
MXN0 net54 ns net50 VSS nm1p2_svt_lp L=6e-08 W=2e-07
MXN1 net50 SN VSS VSS nm1p2_svt_lp L=6e-08 W=2e-07
MI28_MXNA1 ns s VSS VSS nm1p2_svt_lp L=6e-08 W=3.2e-07
MI8_MXNA1 Q ns VSS VSS nm1p2_svt_lp L=6e-08 W=4.2e-07
MI8_MXNA1_2 Q ns VSS VSS nm1p2_svt_lp L=6e-08 W=4.2e-07
MI22_MXPA1 nclk_ CKN VDD VDD pm1p2_svt_lp L=6e-08 W=3.3e-07
MI23_MXPA1 bclk_ nclk_ VDD VDD pm1p2_svt_lp L=6e-08 W=2.3e-07
MI79_MXPA1 nd D VDD VDD pm1p2_svt_lp L=6e-08 W=5.1e-07
MI33_MXPOEN nm nclk_ nd VDD pm1p2_svt_lp L=6e-08 W=4.5e-07
MI31_MXPOEN nm bclk_ XI31_p1 VDD pm1p2_svt_lp L=6e-08 W=1.5e-07
MI31_MXPA1 XI31_p1 m VDD VDD pm1p2_svt_lp L=6e-08 W=1.5e-07
MI0_MXPA2 m nm VDD VDD pm1p2_svt_lp L=6e-08 W=3.3e-07
MI0_MXPA1 m SN VDD VDD pm1p2_svt_lp L=6e-08 W=3.3e-07
MI20_MXPOEN s bclk_ m VDD pm1p2_svt_lp L=6e-08 W=4.5e-07
MXP0 s nclk_ net73 VDD pm1p2_svt_lp L=6e-08 W=1.5e-07
MXP1 net73 ns VDD VDD pm1p2_svt_lp L=6e-08 W=1.5e-07
MXP4 s SN VDD VDD pm1p2_svt_lp L=6e-08 W=1.5e-07
MI28_MXPA1 ns s VDD VDD pm1p2_svt_lp L=6e-08 W=3.4e-07
MI8_MXPA1 Q ns VDD VDD pm1p2_svt_lp L=6e-08 W=5.85e-07
MI8_MXPA1_2 Q ns VDD VDD pm1p2_svt_lp L=6e-08 W=5.85e-07
.ENDS

.SUBCKT DFFNSQX3H9R Q VDD VSS CKN D SN
MI22_MXNA1 nclk_ CKN VSS VSS nm1p2_svt_lp L=6e-08 W=1.8e-07
MI23_MXNA1 bclk_ nclk_ VSS VSS nm1p2_svt_lp L=6e-08 W=2.2e-07
MI79_MXNA1 nd D VSS VSS nm1p2_svt_lp L=6e-08 W=1.7e-07
MI33_MXNOE nm bclk_ nd VSS nm1p2_svt_lp L=6e-08 W=1.8e-07
MI31_MXNOE nm nclk_ XI31_n1 VSS nm1p2_svt_lp L=6e-08 W=1.5e-07
MI31_MXNA1 XI31_n1 m VSS VSS nm1p2_svt_lp L=6e-08 W=1.5e-07
MI0_MXNA2 XI0_n1 nm VSS VSS nm1p2_svt_lp L=6e-08 W=3.9e-07
MI0_MXNA1 m SN XI0_n1 VSS nm1p2_svt_lp L=6e-08 W=3.9e-07
MI20_MXNOE s nclk_ m VSS nm1p2_svt_lp L=6e-08 W=1.8e-07
MXN4 s bclk_ net54 VSS nm1p2_svt_lp L=6e-08 W=2e-07
MXN0 net54 ns net50 VSS nm1p2_svt_lp L=6e-08 W=2e-07
MXN1 net50 SN VSS VSS nm1p2_svt_lp L=6e-08 W=2e-07
MI28_MXNA1 ns s VSS VSS nm1p2_svt_lp L=6e-08 W=2.3e-07
MI8_MXNA1 Q ns VSS VSS nm1p2_svt_lp L=6e-08 W=4.2e-07
MI8_MXNA1_2 Q ns VSS VSS nm1p2_svt_lp L=6e-08 W=4.2e-07
MI8_MXNA1_3 Q ns VSS VSS nm1p2_svt_lp L=6e-08 W=4.2e-07
MI22_MXPA1 nclk_ CKN VDD VDD pm1p2_svt_lp L=6e-08 W=3.6e-07
MI23_MXPA1 bclk_ nclk_ VDD VDD pm1p2_svt_lp L=6e-08 W=2.4e-07
MI79_MXPA1 nd D VDD VDD pm1p2_svt_lp L=6e-08 W=5e-07
MI33_MXPOEN nm nclk_ nd VDD pm1p2_svt_lp L=6e-08 W=5.85e-07
MI31_MXPOEN nm bclk_ XI31_p1 VDD pm1p2_svt_lp L=6e-08 W=1.5e-07
MI31_MXPA1 XI31_p1 m VDD VDD pm1p2_svt_lp L=6e-08 W=1.5e-07
MI0_MXPA2 m nm VDD VDD pm1p2_svt_lp L=6e-08 W=5.05e-07
MI0_MXPA1 m SN VDD VDD pm1p2_svt_lp L=6e-08 W=5.05e-07
MI20_MXPOEN s bclk_ m VDD pm1p2_svt_lp L=6e-08 W=5.85e-07
MXP0 s nclk_ net73 VDD pm1p2_svt_lp L=6e-08 W=1.5e-07
MXP1 net73 ns VDD VDD pm1p2_svt_lp L=6e-08 W=1.5e-07
MXP4 s SN VDD VDD pm1p2_svt_lp L=6e-08 W=1.5e-07
MI28_MXPA1 ns s VDD VDD pm1p2_svt_lp L=6e-08 W=2.8e-07
MI8_MXPA1 Q ns VDD VDD pm1p2_svt_lp L=6e-08 W=5.85e-07
MI8_MXPA1_2 Q ns VDD VDD pm1p2_svt_lp L=6e-08 W=5.85e-07
MI8_MXPA1_3 Q ns VDD VDD pm1p2_svt_lp L=6e-08 W=5.85e-07
.ENDS

.SUBCKT DFFSRPQX0P5H9R Q VDD VSS CK D R SN
MI80_MXNA1 nd D VSS VSS nm1p2_svt_lp L=6e-08 W=2e-07
MI33_MXNOE nm nclk nd VSS nm1p2_svt_lp L=6e-08 W=1.5e-07
MI31_MXNOE nm bclk XI31_n1 VSS nm1p2_svt_lp L=6e-08 W=1.5e-07
MI31_MXNA1 XI31_n1 m VSS VSS nm1p2_svt_lp L=6e-08 W=1.5e-07
MXN8 net64 SN VSS VSS nm1p2_svt_lp L=6e-08 W=1.5e-07
MXN7 m nm net64 VSS nm1p2_svt_lp L=6e-08 W=1.5e-07
MXN9 m R net64 VSS nm1p2_svt_lp L=6e-08 W=1.5e-07
MI20_MXNOE s bclk m VSS nm1p2_svt_lp L=6e-08 W=1.5e-07
MXN6 net56 R VSS VSS nm1p2_svt_lp L=6e-08 W=2e-07
MXN0 s SN net56 VSS nm1p2_svt_lp L=6e-08 W=2e-07
MXN4 s nclk net48 VSS nm1p2_svt_lp L=6e-08 W=2e-07
MXN1 net48 ns net44 VSS nm1p2_svt_lp L=6e-08 W=2e-07
MXN5 net44 SN VSS VSS nm1p2_svt_lp L=6e-08 W=2e-07
MI28_MXNA1 ns s VSS VSS nm1p2_svt_lp L=6e-08 W=1.6e-07
MI8_MXNA1 Q ns VSS VSS nm1p2_svt_lp L=6e-08 W=2.1e-07
MI23_MXNA1 bclk nclk VSS VSS nm1p2_svt_lp L=6e-08 W=1.5e-07
MI22_MXNA1 nclk CK VSS VSS nm1p2_svt_lp L=6e-08 W=1.5e-07
MI80_MXPA1 nd D VDD VDD pm1p2_svt_lp L=6e-08 W=2e-07
MI33_MXPOEN nm bclk nd VDD pm1p2_svt_lp L=6e-08 W=1.5e-07
MI31_MXPOEN nm nclk XI31_p1 VDD pm1p2_svt_lp L=6e-08 W=1.5e-07
MI31_MXPA1 XI31_p1 m VDD VDD pm1p2_svt_lp L=6e-08 W=1.5e-07
MXP9 m SN VDD VDD pm1p2_svt_lp L=6e-08 W=2.4e-07
MXP8 net103 nm VDD VDD pm1p2_svt_lp L=6e-08 W=2.4e-07
MXP7 m R net103 VDD pm1p2_svt_lp L=6e-08 W=2.4e-07
MI20_MXPOEN s nclk m VDD pm1p2_svt_lp L=6e-08 W=1.5e-07
MXP5 net91 R VDD VDD pm1p2_svt_lp L=6e-08 W=2e-07
MXP1 net87 ns net91 VDD pm1p2_svt_lp L=6e-08 W=2e-07
MXP0 s bclk net87 VDD pm1p2_svt_lp L=6e-08 W=2e-07
MXP6 s SN VDD VDD pm1p2_svt_lp L=6e-08 W=2e-07
MI28_MXPA1 ns s VDD VDD pm1p2_svt_lp L=6e-08 W=1.9e-07
MI8_MXPA1 Q ns VDD VDD pm1p2_svt_lp L=6e-08 W=2.95e-07
MI23_MXPA1 bclk nclk VDD VDD pm1p2_svt_lp L=6e-08 W=1.9e-07
MI22_MXPA1 nclk CK VDD VDD pm1p2_svt_lp L=6e-08 W=1.7e-07
.ENDS

.SUBCKT DFFSRPQX1H9R Q VDD VSS CK D R SN
MI80_MXNA1 nd D VSS VSS nm1p2_svt_lp L=6e-08 W=3.4e-07
MI33_MXNOE nm nclk nd VSS nm1p2_svt_lp L=6e-08 W=2.6e-07
MI31_MXNOE nm bclk XI31_n1 VSS nm1p2_svt_lp L=6e-08 W=1.5e-07
MI31_MXNA1 XI31_n1 m VSS VSS nm1p2_svt_lp L=6e-08 W=1.5e-07
MXN8 net64 SN VSS VSS nm1p2_svt_lp L=6e-08 W=2e-07
MXN7 m nm net64 VSS nm1p2_svt_lp L=6e-08 W=2e-07
MXN9 m R net64 VSS nm1p2_svt_lp L=6e-08 W=2e-07
MI20_MXNOE s bclk m VSS nm1p2_svt_lp L=6e-08 W=2.6e-07
MXN6 net56 R VSS VSS nm1p2_svt_lp L=6e-08 W=2e-07
MXN0 s SN net56 VSS nm1p2_svt_lp L=6e-08 W=2e-07
MXN4 s nclk net48 VSS nm1p2_svt_lp L=6e-08 W=2e-07
MXN1 net48 ns net44 VSS nm1p2_svt_lp L=6e-08 W=2e-07
MXN5 net44 SN VSS VSS nm1p2_svt_lp L=6e-08 W=2e-07
MI28_MXNA1 ns s VSS VSS nm1p2_svt_lp L=6e-08 W=2.5e-07
MI8_MXNA1 Q ns VSS VSS nm1p2_svt_lp L=6e-08 W=4.2e-07
MI23_MXNA1 bclk nclk VSS VSS nm1p2_svt_lp L=6e-08 W=1.5e-07
MI22_MXNA1 nclk CK VSS VSS nm1p2_svt_lp L=6e-08 W=1.7e-07
MI80_MXPA1 nd D VDD VDD pm1p2_svt_lp L=6e-08 W=2.9e-07
MI33_MXPOEN nm bclk nd VDD pm1p2_svt_lp L=6e-08 W=2.6e-07
MI31_MXPOEN nm nclk XI31_p1 VDD pm1p2_svt_lp L=6e-08 W=1.5e-07
MI31_MXPA1 XI31_p1 m VDD VDD pm1p2_svt_lp L=6e-08 W=1.5e-07
MXP9 m SN VDD VDD pm1p2_svt_lp L=6e-08 W=3.3e-07
MXP8 net103 nm VDD VDD pm1p2_svt_lp L=6e-08 W=3.3e-07
MXP7 m R net103 VDD pm1p2_svt_lp L=6e-08 W=3.3e-07
MI20_MXPOEN s nclk m VDD pm1p2_svt_lp L=6e-08 W=2.6e-07
MXP5 net91 R VDD VDD pm1p2_svt_lp L=6e-08 W=2e-07
MXP1 net87 ns net91 VDD pm1p2_svt_lp L=6e-08 W=2e-07
MXP0 s bclk net87 VDD pm1p2_svt_lp L=6e-08 W=2e-07
MXP6 s SN VDD VDD pm1p2_svt_lp L=6e-08 W=2e-07
MI28_MXPA1 ns s VDD VDD pm1p2_svt_lp L=6e-08 W=3.1e-07
MI8_MXPA1 Q ns VDD VDD pm1p2_svt_lp L=6e-08 W=5.85e-07
MI23_MXPA1 bclk nclk VDD VDD pm1p2_svt_lp L=6e-08 W=3e-07
MI22_MXPA1 nclk CK VDD VDD pm1p2_svt_lp L=6e-08 W=1.9e-07
.ENDS

.SUBCKT DFFSRPQX2H9R Q VDD VSS CK D R SN
MI80_MXNA1 nd D VSS VSS nm1p2_svt_lp L=6e-08 W=4.2e-07
MI33_MXNOE nm nclk nd VSS nm1p2_svt_lp L=6e-08 W=3.2e-07
MI31_MXNOE nm bclk XI31_n1 VSS nm1p2_svt_lp L=6e-08 W=1.5e-07
MI31_MXNA1 XI31_n1 m VSS VSS nm1p2_svt_lp L=6e-08 W=1.5e-07
MXN8 net64 SN VSS VSS nm1p2_svt_lp L=6e-08 W=2.9e-07
MXN7 m nm net64 VSS nm1p2_svt_lp L=6e-08 W=2.9e-07
MXN9 m R net64 VSS nm1p2_svt_lp L=6e-08 W=2.9e-07
MI20_MXNOE s bclk m VSS nm1p2_svt_lp L=6e-08 W=3.2e-07
MXN6 net56 R VSS VSS nm1p2_svt_lp L=6e-08 W=2e-07
MXN0 s SN net56 VSS nm1p2_svt_lp L=6e-08 W=2e-07
MXN4 s nclk net48 VSS nm1p2_svt_lp L=6e-08 W=2e-07
MXN1 net48 ns net44 VSS nm1p2_svt_lp L=6e-08 W=2e-07
MXN5 net44 SN VSS VSS nm1p2_svt_lp L=6e-08 W=2e-07
MI28_MXNA1 ns s VSS VSS nm1p2_svt_lp L=6e-08 W=3.5e-07
MI8_MXNA1 Q ns VSS VSS nm1p2_svt_lp L=6e-08 W=4.2e-07
MI8_MXNA1_2 Q ns VSS VSS nm1p2_svt_lp L=6e-08 W=4.2e-07
MI23_MXNA1 bclk nclk VSS VSS nm1p2_svt_lp L=6e-08 W=1.7e-07
MI22_MXNA1 nclk CK VSS VSS nm1p2_svt_lp L=6e-08 W=2.1e-07
MI80_MXPA1 nd D VDD VDD pm1p2_svt_lp L=6e-08 W=3.3e-07
MI33_MXPOEN nm bclk nd VDD pm1p2_svt_lp L=6e-08 W=3.2e-07
MI31_MXPOEN nm nclk XI31_p1 VDD pm1p2_svt_lp L=6e-08 W=1.5e-07
MI31_MXPA1 XI31_p1 m VDD VDD pm1p2_svt_lp L=6e-08 W=1.5e-07
MXP9 m SN VDD VDD pm1p2_svt_lp L=6e-08 W=4.4e-07
MXP8 net103 nm VDD VDD pm1p2_svt_lp L=6e-08 W=4.4e-07
MXP7 m R net103 VDD pm1p2_svt_lp L=6e-08 W=4.4e-07
MI20_MXPOEN s nclk m VDD pm1p2_svt_lp L=6e-08 W=3.2e-07
MXP5 net91 R VDD VDD pm1p2_svt_lp L=6e-08 W=2e-07
MXP1 net87 ns net91 VDD pm1p2_svt_lp L=6e-08 W=2e-07
MXP0 s bclk net87 VDD pm1p2_svt_lp L=6e-08 W=2e-07
MXP6 s SN VDD VDD pm1p2_svt_lp L=6e-08 W=2e-07
MI28_MXPA1 ns s VDD VDD pm1p2_svt_lp L=6e-08 W=4.7e-07
MI8_MXPA1 Q ns VDD VDD pm1p2_svt_lp L=6e-08 W=5.85e-07
MI8_MXPA1_2 Q ns VDD VDD pm1p2_svt_lp L=6e-08 W=5.85e-07
MI23_MXPA1 bclk nclk VDD VDD pm1p2_svt_lp L=6e-08 W=3.3e-07
MI22_MXPA1 nclk CK VDD VDD pm1p2_svt_lp L=6e-08 W=2.3e-07
.ENDS

.SUBCKT DFFSRPQX3H9R Q VDD VSS CK D R SN
MI80_MXNA1 nd D VSS VSS nm1p2_svt_lp L=6e-08 W=4.5e-07
MI33_MXNOE nm nclk nd VSS nm1p2_svt_lp L=6e-08 W=3.9e-07
MI31_MXNOE nm bclk XI31_n1 VSS nm1p2_svt_lp L=6e-08 W=1.5e-07
MI31_MXNA1 XI31_n1 m VSS VSS nm1p2_svt_lp L=6e-08 W=1.5e-07
MXN7 m nm net64 VSS nm1p2_svt_lp L=6e-08 W=3.5e-07
MXN9 m R net64 VSS nm1p2_svt_lp L=6e-08 W=3.5e-07
MXN8 net64 SN VSS VSS nm1p2_svt_lp L=6e-08 W=3.5e-07
MI20_MXNOE s bclk m VSS nm1p2_svt_lp L=6e-08 W=3.9e-07
MXN6 net56 R VSS VSS nm1p2_svt_lp L=6e-08 W=2e-07
MXN0 s SN net56 VSS nm1p2_svt_lp L=6e-08 W=2e-07
MXN4 s nclk net48 VSS nm1p2_svt_lp L=6e-08 W=2e-07
MXN1 net48 ns net44 VSS nm1p2_svt_lp L=6e-08 W=2e-07
MXN5 net44 SN VSS VSS nm1p2_svt_lp L=6e-08 W=2e-07
MI28_MXNA1 ns s VSS VSS nm1p2_svt_lp L=6e-08 W=3.6e-07
MI8_MXNA1 Q ns VSS VSS nm1p2_svt_lp L=6e-08 W=4.2e-07
MI8_MXNA1_2 Q ns VSS VSS nm1p2_svt_lp L=6e-08 W=4.2e-07
MI8_MXNA1_3 Q ns VSS VSS nm1p2_svt_lp L=6e-08 W=4.2e-07
MI23_MXNA1 bclk nclk VSS VSS nm1p2_svt_lp L=6e-08 W=1.8e-07
MI22_MXNA1 nclk CK VSS VSS nm1p2_svt_lp L=6e-08 W=2.2e-07
MI80_MXPA1 nd D VDD VDD pm1p2_svt_lp L=6e-08 W=3.3e-07
MI33_MXPOEN nm bclk nd VDD pm1p2_svt_lp L=6e-08 W=3.9e-07
MI31_MXPOEN nm nclk XI31_p1 VDD pm1p2_svt_lp L=6e-08 W=1.5e-07
MI31_MXPA1 XI31_p1 m VDD VDD pm1p2_svt_lp L=6e-08 W=1.5e-07
MXP8 net103 nm VDD VDD pm1p2_svt_lp L=6e-08 W=5e-07
MXP7 m R net103 VDD pm1p2_svt_lp L=6e-08 W=5e-07
MXP9 m SN VDD VDD pm1p2_svt_lp L=6e-08 W=5e-07
MI20_MXPOEN s nclk m VDD pm1p2_svt_lp L=6e-08 W=3.9e-07
MXP5 net91 R VDD VDD pm1p2_svt_lp L=6e-08 W=2e-07
MXP1 net87 ns net91 VDD pm1p2_svt_lp L=6e-08 W=2e-07
MXP0 s bclk net87 VDD pm1p2_svt_lp L=6e-08 W=2e-07
MXP6 s SN VDD VDD pm1p2_svt_lp L=6e-08 W=2e-07
MI28_MXPA1 ns s VDD VDD pm1p2_svt_lp L=6e-08 W=5.1e-07
MI8_MXPA1 Q ns VDD VDD pm1p2_svt_lp L=6e-08 W=5.85e-07
MI8_MXPA1_2 Q ns VDD VDD pm1p2_svt_lp L=6e-08 W=5.85e-07
MI8_MXPA1_3 Q ns VDD VDD pm1p2_svt_lp L=6e-08 W=5.85e-07
MI23_MXPA1 bclk nclk VDD VDD pm1p2_svt_lp L=6e-08 W=3.6e-07
MI22_MXPA1 nclk CK VDD VDD pm1p2_svt_lp L=6e-08 W=2.4e-07
.ENDS

.SUBCKT DFFSRPQX4H9R Q VDD VSS CK D R SN
MI80_MXNA1 nd D VSS VSS nm1p2_svt_lp L=6e-08 W=4.95e-07
MI33_MXNOE nm nclk nd VSS nm1p2_svt_lp L=6e-08 W=4.5e-07
MI31_MXNOE nm bclk XI31_n1 VSS nm1p2_svt_lp L=6e-08 W=1.5e-07
MI31_MXNA1 XI31_n1 m VSS VSS nm1p2_svt_lp L=6e-08 W=1.5e-07
MXN7 m nm net64 VSS nm1p2_svt_lp L=6e-08 W=3.6e-07
MXN9 m R net64 VSS nm1p2_svt_lp L=6e-08 W=3.6e-07
MXN8 net64 SN VSS VSS nm1p2_svt_lp L=6e-08 W=3.6e-07
MI20_MXNOE s bclk m VSS nm1p2_svt_lp L=6e-08 W=4.5e-07
MXN6 net56 R VSS VSS nm1p2_svt_lp L=6e-08 W=2e-07
MXN0 s SN net56 VSS nm1p2_svt_lp L=6e-08 W=2e-07
MXN4 s nclk net48 VSS nm1p2_svt_lp L=6e-08 W=2e-07
MXN1 net48 ns net44 VSS nm1p2_svt_lp L=6e-08 W=2e-07
MXN5 net44 SN VSS VSS nm1p2_svt_lp L=6e-08 W=2e-07
MI28_MXNA1 ns s VSS VSS nm1p2_svt_lp L=6e-08 W=4.2e-07
MI28_MXNA1_2 ns s VSS VSS nm1p2_svt_lp L=6e-08 W=4.2e-07
MI8_MXNA1 Q ns VSS VSS nm1p2_svt_lp L=6e-08 W=4.2e-07
MI8_MXNA1_2 Q ns VSS VSS nm1p2_svt_lp L=6e-08 W=4.2e-07
MI8_MXNA1_3 Q ns VSS VSS nm1p2_svt_lp L=6e-08 W=4.2e-07
MI8_MXNA1_4 Q ns VSS VSS nm1p2_svt_lp L=6e-08 W=4.2e-07
MI23_MXNA1 bclk nclk VSS VSS nm1p2_svt_lp L=6e-08 W=2.1e-07
MI22_MXNA1 nclk CK VSS VSS nm1p2_svt_lp L=6e-08 W=2.5e-07
MI80_MXPA1 nd D VDD VDD pm1p2_svt_lp L=6e-08 W=4.05e-07
MI33_MXPOEN nm bclk nd VDD pm1p2_svt_lp L=6e-08 W=4.5e-07
MI31_MXPOEN nm nclk XI31_p1 VDD pm1p2_svt_lp L=6e-08 W=1.5e-07
MI31_MXPA1 XI31_p1 m VDD VDD pm1p2_svt_lp L=6e-08 W=1.5e-07
MXP8 net103 nm VDD VDD pm1p2_svt_lp L=6e-08 W=5.5e-07
MXP7 m R net103 VDD pm1p2_svt_lp L=6e-08 W=5.5e-07
MXP9 m SN VDD VDD pm1p2_svt_lp L=6e-08 W=5.5e-07
MI20_MXPOEN s nclk m VDD pm1p2_svt_lp L=6e-08 W=4.5e-07
MXP5 net91 R VDD VDD pm1p2_svt_lp L=6e-08 W=2e-07
MXP1 net87 ns net91 VDD pm1p2_svt_lp L=6e-08 W=2e-07
MXP0 s bclk net87 VDD pm1p2_svt_lp L=6e-08 W=2e-07
MXP6 s SN VDD VDD pm1p2_svt_lp L=6e-08 W=2e-07
MI28_MXPA1 ns s VDD VDD pm1p2_svt_lp L=6e-08 W=4.5e-07
MI28_MXPA1_2 ns s VDD VDD pm1p2_svt_lp L=6e-08 W=4.5e-07
MI8_MXPA1 Q ns VDD VDD pm1p2_svt_lp L=6e-08 W=5.85e-07
MI8_MXPA1_2 Q ns VDD VDD pm1p2_svt_lp L=6e-08 W=5.85e-07
MI8_MXPA1_3 Q ns VDD VDD pm1p2_svt_lp L=6e-08 W=5.85e-07
MI8_MXPA1_4 Q ns VDD VDD pm1p2_svt_lp L=6e-08 W=5.85e-07
MI23_MXPA1 bclk nclk VDD VDD pm1p2_svt_lp L=6e-08 W=4.2e-07
MI22_MXPA1 nclk CK VDD VDD pm1p2_svt_lp L=6e-08 W=2.8e-07
.ENDS

.SUBCKT DFFNSRPQX1H9R Q VDD VSS CKN D R SN
MI22_MXNA1 nclk_ CKN VSS VSS nm1p2_svt_lp L=6e-08 W=1.5e-07
MI23_MXNA1 bclk_ nclk_ VSS VSS nm1p2_svt_lp L=6e-08 W=1.7e-07
MI80_MXNA1 net0167 D VSS VSS nm1p2_svt_lp L=6e-08 W=1.7e-07
MI33_MXNOE nm bclk_ net0167 VSS nm1p2_svt_lp L=6e-08 W=1.5e-07
MI31_MXNOE nm nclk_ XI31_n1 VSS nm1p2_svt_lp L=6e-08 W=1.5e-07
MI31_MXNA1 XI31_n1 m VSS VSS nm1p2_svt_lp L=6e-08 W=1.5e-07
MXN8 net64 SN VSS VSS nm1p2_svt_lp L=6e-08 W=1.5e-07
MXN7 m nm net64 VSS nm1p2_svt_lp L=6e-08 W=1.5e-07
MXN9 m R net64 VSS nm1p2_svt_lp L=6e-08 W=1.5e-07
MI20_MXNOE s nclk_ m VSS nm1p2_svt_lp L=6e-08 W=1.5e-07
MXN6 net56 R VSS VSS nm1p2_svt_lp L=6e-08 W=2e-07
MXN0 s SN net56 VSS nm1p2_svt_lp L=6e-08 W=2e-07
MXN4 s bclk_ net48 VSS nm1p2_svt_lp L=6e-08 W=2e-07
MXN1 net48 ns net44 VSS nm1p2_svt_lp L=6e-08 W=2e-07
MXN5 net44 SN VSS VSS nm1p2_svt_lp L=6e-08 W=2e-07
MI28_MXNA1 ns s VSS VSS nm1p2_svt_lp L=6e-08 W=2.3e-07
MI8_MXNA1 Q ns VSS VSS nm1p2_svt_lp L=6e-08 W=4.2e-07
MI22_MXPA1 nclk_ CKN VDD VDD pm1p2_svt_lp L=6e-08 W=3e-07
MI23_MXPA1 bclk_ nclk_ VDD VDD pm1p2_svt_lp L=6e-08 W=1.9e-07
MI80_MXPA1 net0167 D VDD VDD pm1p2_svt_lp L=6e-08 W=5e-07
MI33_MXPOEN nm nclk_ net0167 VDD pm1p2_svt_lp L=6e-08 W=3.6e-07
MI31_MXPOEN nm bclk_ XI31_p1 VDD pm1p2_svt_lp L=6e-08 W=1.5e-07
MI31_MXPA1 XI31_p1 m VDD VDD pm1p2_svt_lp L=6e-08 W=1.5e-07
MXP9 m SN VDD VDD pm1p2_svt_lp L=6e-08 W=3.1e-07
MXP8 net103 nm VDD VDD pm1p2_svt_lp L=6e-08 W=3.1e-07
MXP7 m R net103 VDD pm1p2_svt_lp L=6e-08 W=3.1e-07
MI20_MXPOEN s bclk_ m VDD pm1p2_svt_lp L=6e-08 W=3.6e-07
MXP5 net91 R VDD VDD pm1p2_svt_lp L=6e-08 W=2e-07
MXP1 net87 ns net91 VDD pm1p2_svt_lp L=6e-08 W=2e-07
MXP0 s nclk_ net87 VDD pm1p2_svt_lp L=6e-08 W=2e-07
MXP6 s SN VDD VDD pm1p2_svt_lp L=6e-08 W=2e-07
MI28_MXPA1 ns s VDD VDD pm1p2_svt_lp L=6e-08 W=2e-07
MI8_MXPA1 Q ns VDD VDD pm1p2_svt_lp L=6e-08 W=5.85e-07
.ENDS

.SUBCKT DFFNSRPQX2H9R Q VDD VSS CKN D R SN
MI22_MXNA1 nclk_ CKN VSS VSS nm1p2_svt_lp L=6e-08 W=1.7e-07
MI23_MXNA1 bclk_ nclk_ VSS VSS nm1p2_svt_lp L=6e-08 W=2.1e-07
MI80_MXNA1 net0167 D VSS VSS nm1p2_svt_lp L=6e-08 W=1.7e-07
MI33_MXNOE nm bclk_ net0167 VSS nm1p2_svt_lp L=6e-08 W=1.8e-07
MI31_MXNOE nm nclk_ XI31_n1 VSS nm1p2_svt_lp L=6e-08 W=1.5e-07
MI31_MXNA1 XI31_n1 m VSS VSS nm1p2_svt_lp L=6e-08 W=1.5e-07
MXN7 m nm net64 VSS nm1p2_svt_lp L=6e-08 W=2.4e-07
MXN9 m R net64 VSS nm1p2_svt_lp L=6e-08 W=2.4e-07
MXN8 net64 SN VSS VSS nm1p2_svt_lp L=6e-08 W=2.4e-07
MI20_MXNOE s nclk_ m VSS nm1p2_svt_lp L=6e-08 W=1.8e-07
MXN6 net56 R VSS VSS nm1p2_svt_lp L=6e-08 W=2e-07
MXN0 s SN net56 VSS nm1p2_svt_lp L=6e-08 W=2e-07
MXN4 s bclk_ net48 VSS nm1p2_svt_lp L=6e-08 W=2e-07
MXN1 net48 ns net44 VSS nm1p2_svt_lp L=6e-08 W=2e-07
MXN5 net44 SN VSS VSS nm1p2_svt_lp L=6e-08 W=2e-07
MI28_MXNA1 ns s VSS VSS nm1p2_svt_lp L=6e-08 W=3.1e-07
MI8_MXNA1 Q ns VSS VSS nm1p2_svt_lp L=6e-08 W=4.2e-07
MI8_MXNA1_2 Q ns VSS VSS nm1p2_svt_lp L=6e-08 W=4.2e-07
MI22_MXPA1 nclk_ CKN VDD VDD pm1p2_svt_lp L=6e-08 W=3.3e-07
MI23_MXPA1 bclk_ nclk_ VDD VDD pm1p2_svt_lp L=6e-08 W=2.3e-07
MI80_MXPA1 net0167 D VDD VDD pm1p2_svt_lp L=6e-08 W=4.1e-07
MI33_MXPOEN nm nclk_ net0167 VDD pm1p2_svt_lp L=6e-08 W=4.5e-07
MI31_MXPOEN nm bclk_ XI31_p1 VDD pm1p2_svt_lp L=6e-08 W=1.5e-07
MI31_MXPA1 XI31_p1 m VDD VDD pm1p2_svt_lp L=6e-08 W=1.5e-07
MXP8 net103 nm VDD VDD pm1p2_svt_lp L=6e-08 W=4.05e-07
MXP7 m R net103 VDD pm1p2_svt_lp L=6e-08 W=4.05e-07
MXP9 m SN VDD VDD pm1p2_svt_lp L=6e-08 W=4.05e-07
MI20_MXPOEN s bclk_ m VDD pm1p2_svt_lp L=6e-08 W=4.5e-07
MXP5 net91 R VDD VDD pm1p2_svt_lp L=6e-08 W=2e-07
MXP1 net87 ns net91 VDD pm1p2_svt_lp L=6e-08 W=2e-07
MXP0 s nclk_ net87 VDD pm1p2_svt_lp L=6e-08 W=2e-07
MXP6 s SN VDD VDD pm1p2_svt_lp L=6e-08 W=2e-07
MI28_MXPA1 ns s VDD VDD pm1p2_svt_lp L=6e-08 W=2.6e-07
MI8_MXPA1 Q ns VDD VDD pm1p2_svt_lp L=6e-08 W=5.85e-07
MI8_MXPA1_2 Q ns VDD VDD pm1p2_svt_lp L=6e-08 W=5.85e-07
.ENDS

.SUBCKT DFFNSRPQX3H9R Q VDD VSS CKN D R SN
MI22_MXNA1 nclk_ CKN VSS VSS nm1p2_svt_lp L=6e-08 W=1.8e-07
MI23_MXNA1 bclk_ nclk_ VSS VSS nm1p2_svt_lp L=6e-08 W=2.2e-07
MI80_MXNA1 net0167 D VSS VSS nm1p2_svt_lp L=6e-08 W=2.2e-07
MI33_MXNOE nm bclk_ net0167 VSS nm1p2_svt_lp L=6e-08 W=1.8e-07
MI31_MXNOE nm nclk_ XI31_n1 VSS nm1p2_svt_lp L=6e-08 W=1.5e-07
MI31_MXNA1 XI31_n1 m VSS VSS nm1p2_svt_lp L=6e-08 W=1.5e-07
MXN7 m nm net64 VSS nm1p2_svt_lp L=6e-08 W=3.5e-07
MXN9 m R net64 VSS nm1p2_svt_lp L=6e-08 W=3.5e-07
MXN8 net64 SN VSS VSS nm1p2_svt_lp L=6e-08 W=3.5e-07
MI20_MXNOE s nclk_ m VSS nm1p2_svt_lp L=6e-08 W=1.8e-07
MXN6 net56 R VSS VSS nm1p2_svt_lp L=6e-08 W=2e-07
MXN0 s SN net56 VSS nm1p2_svt_lp L=6e-08 W=2e-07
MXN4 s bclk_ net48 VSS nm1p2_svt_lp L=6e-08 W=2e-07
MXN1 net48 ns net44 VSS nm1p2_svt_lp L=6e-08 W=2e-07
MXN5 net44 SN VSS VSS nm1p2_svt_lp L=6e-08 W=2e-07
MI28_MXNA1 ns s VSS VSS nm1p2_svt_lp L=6e-08 W=3e-07
MI8_MXNA1 Q ns VSS VSS nm1p2_svt_lp L=6e-08 W=4.2e-07
MI8_MXNA1_2 Q ns VSS VSS nm1p2_svt_lp L=6e-08 W=4.2e-07
MI8_MXNA1_3 Q ns VSS VSS nm1p2_svt_lp L=6e-08 W=4.2e-07
MI22_MXPA1 nclk_ CKN VDD VDD pm1p2_svt_lp L=6e-08 W=3.6e-07
MI23_MXPA1 bclk_ nclk_ VDD VDD pm1p2_svt_lp L=6e-08 W=2.4e-07
MI80_MXPA1 net0167 D VDD VDD pm1p2_svt_lp L=6e-08 W=4.7e-07
MI33_MXPOEN nm nclk_ net0167 VDD pm1p2_svt_lp L=6e-08 W=5.85e-07
MI31_MXPOEN nm bclk_ XI31_p1 VDD pm1p2_svt_lp L=6e-08 W=1.5e-07
MI31_MXPA1 XI31_p1 m VDD VDD pm1p2_svt_lp L=6e-08 W=1.5e-07
MXP8 net103 nm VDD VDD pm1p2_svt_lp L=6e-08 W=5e-07
MXP7 m R net103 VDD pm1p2_svt_lp L=6e-08 W=5e-07
MXP9 m SN VDD VDD pm1p2_svt_lp L=6e-08 W=5e-07
MI20_MXPOEN s bclk_ m VDD pm1p2_svt_lp L=6e-08 W=5.85e-07
MXP5 net91 R VDD VDD pm1p2_svt_lp L=6e-08 W=2e-07
MXP1 net87 ns net91 VDD pm1p2_svt_lp L=6e-08 W=2e-07
MXP0 s nclk_ net87 VDD pm1p2_svt_lp L=6e-08 W=2e-07
MXP6 s SN VDD VDD pm1p2_svt_lp L=6e-08 W=2e-07
MI28_MXPA1 ns s VDD VDD pm1p2_svt_lp L=6e-08 W=2.6e-07
MI8_MXPA1 Q ns VDD VDD pm1p2_svt_lp L=6e-08 W=5.85e-07
MI8_MXPA1_2 Q ns VDD VDD pm1p2_svt_lp L=6e-08 W=5.85e-07
MI8_MXPA1_3 Q ns VDD VDD pm1p2_svt_lp L=6e-08 W=5.85e-07
.ENDS

.SUBCKT MDFFQX0P5H9R Q VDD VSS CK D0 D1 S0
MI70_MXNA1 ns0 S0 VSS VSS nm1p2_svt_lp L=6e-08 W=2.3e-07
MI112_MXNA1 nd1 D1 VSS VSS nm1p2_svt_lp L=6e-08 W=2e-07
MI110_MXNOE nenmux S0 nd1 VSS nm1p2_svt_lp L=6e-08 W=2e-07
MI111_MXNOE nenmux ns0 nd0 VSS nm1p2_svt_lp L=6e-08 W=2e-07
MI113_MXNA1 nd0 D0 VSS VSS nm1p2_svt_lp L=6e-08 W=2e-07
MI93_MXNA1 semux nenmux VSS VSS nm1p2_svt_lp L=6e-08 W=2e-07
MI33_MXNOE m nclk semux VSS nm1p2_svt_lp L=6e-08 W=1.5e-07
MI31_MXNOE m bclk XI31_n1 VSS nm1p2_svt_lp L=6e-08 W=1.5e-07
MI31_MXNA1 XI31_n1 nm VSS VSS nm1p2_svt_lp L=6e-08 W=1.5e-07
MI32_MXNA1 nm m VSS VSS nm1p2_svt_lp L=6e-08 W=2.25e-07
MI20_MXNOE ns bclk nm VSS nm1p2_svt_lp L=6e-08 W=1.5e-07
MI68_MXNOE ns nclk XI68_n1 VSS nm1p2_svt_lp L=6e-08 W=1.5e-07
MI68_MXNA1 XI68_n1 s VSS VSS nm1p2_svt_lp L=6e-08 W=1.5e-07
MI28_MXNA1 s ns VSS VSS nm1p2_svt_lp L=6e-08 W=1.2e-07
MI75_MXNA1 Q ns VSS VSS nm1p2_svt_lp L=6e-08 W=2.1e-07
MI23_MXNA1 bclk nclk VSS VSS nm1p2_svt_lp L=6e-08 W=1.5e-07
MI22_MXNA1 nclk CK VSS VSS nm1p2_svt_lp L=6e-08 W=1.5e-07
MI70_MXPA1 ns0 S0 VDD VDD pm1p2_svt_lp L=6e-08 W=3.25e-07
MI112_MXPA1 nd1 D1 VDD VDD pm1p2_svt_lp L=6e-08 W=4.2e-07
MI110_MXPOEN nenmux ns0 nd1 VDD pm1p2_svt_lp L=6e-08 W=2e-07
MI111_MXPOEN nenmux S0 nd0 VDD pm1p2_svt_lp L=6e-08 W=2e-07
MI113_MXPA1 nd0 D0 VDD VDD pm1p2_svt_lp L=6e-08 W=4.2e-07
MI93_MXPA1 semux nenmux VDD VDD pm1p2_svt_lp L=6e-08 W=1.75e-07
MI33_MXPOEN m bclk semux VDD pm1p2_svt_lp L=6e-08 W=1.5e-07
MI31_MXPOEN m nclk XI31_p1 VDD pm1p2_svt_lp L=6e-08 W=1.5e-07
MI31_MXPA1 XI31_p1 nm VDD VDD pm1p2_svt_lp L=6e-08 W=1.5e-07
MI32_MXPA1 nm m VDD VDD pm1p2_svt_lp L=6e-08 W=2.1e-07
MI20_MXPOEN ns nclk nm VDD pm1p2_svt_lp L=6e-08 W=1.5e-07
MI68_MXPOEN ns bclk XI68_p1 VDD pm1p2_svt_lp L=6e-08 W=1.5e-07
MI68_MXPA1 XI68_p1 s VDD VDD pm1p2_svt_lp L=6e-08 W=1.5e-07
MI28_MXPA1 s ns VDD VDD pm1p2_svt_lp L=6e-08 W=1.2e-07
MI75_MXPA1 Q ns VDD VDD pm1p2_svt_lp L=6e-08 W=2.95e-07
MI23_MXPA1 bclk nclk VDD VDD pm1p2_svt_lp L=6e-08 W=1.9e-07
MI22_MXPA1 nclk CK VDD VDD pm1p2_svt_lp L=6e-08 W=1.7e-07
.ENDS

.SUBCKT MDFFQX1H9R Q VDD VSS CK D0 D1 S0
MI70_MXNA1 ns0 S0 VSS VSS nm1p2_svt_lp L=6e-08 W=2.8e-07
MI112_MXNA1 nd1 D1 VSS VSS nm1p2_svt_lp L=6e-08 W=2.6e-07
MI110_MXNOE nenmux S0 nd1 VSS nm1p2_svt_lp L=6e-08 W=2.6e-07
MI111_MXNOE nenmux ns0 nd0 VSS nm1p2_svt_lp L=6e-08 W=2.6e-07
MI113_MXNA1 nd0 D0 VSS VSS nm1p2_svt_lp L=6e-08 W=2.6e-07
MI93_MXNA1 semux nenmux VSS VSS nm1p2_svt_lp L=6e-08 W=2.6e-07
MI33_MXNOE m nclk semux VSS nm1p2_svt_lp L=6e-08 W=2.6e-07
MI31_MXNOE m bclk XI31_n1 VSS nm1p2_svt_lp L=6e-08 W=1.5e-07
MI31_MXNA1 XI31_n1 nm VSS VSS nm1p2_svt_lp L=6e-08 W=1.5e-07
MI32_MXNA1 nm m VSS VSS nm1p2_svt_lp L=6e-08 W=2.2e-07
MI20_MXNOE ns bclk nm VSS nm1p2_svt_lp L=6e-08 W=2.6e-07
MI68_MXNOE ns nclk XI68_n1 VSS nm1p2_svt_lp L=6e-08 W=1.5e-07
MI68_MXNA1 XI68_n1 s VSS VSS nm1p2_svt_lp L=6e-08 W=1.5e-07
MI28_MXNA1 s ns VSS VSS nm1p2_svt_lp L=6e-08 W=1.2e-07
MI75_MXNA1 Q ns VSS VSS nm1p2_svt_lp L=6e-08 W=4.2e-07
MI23_MXNA1 bclk nclk VSS VSS nm1p2_svt_lp L=6e-08 W=1.5e-07
MI22_MXNA1 nclk CK VSS VSS nm1p2_svt_lp L=6e-08 W=1.7e-07
MI70_MXPA1 ns0 S0 VDD VDD pm1p2_svt_lp L=6e-08 W=3.9e-07
MI112_MXPA1 nd1 D1 VDD VDD pm1p2_svt_lp L=6e-08 W=5.2e-07
MI110_MXPOEN nenmux ns0 nd1 VDD pm1p2_svt_lp L=6e-08 W=2.6e-07
MI111_MXPOEN nenmux S0 nd0 VDD pm1p2_svt_lp L=6e-08 W=2.6e-07
MI113_MXPA1 nd0 D0 VDD VDD pm1p2_svt_lp L=6e-08 W=5.2e-07
MI93_MXPA1 semux nenmux VDD VDD pm1p2_svt_lp L=6e-08 W=2.6e-07
MI33_MXPOEN m bclk semux VDD pm1p2_svt_lp L=6e-08 W=2.6e-07
MI31_MXPOEN m nclk XI31_p1 VDD pm1p2_svt_lp L=6e-08 W=1.5e-07
MI31_MXPA1 XI31_p1 nm VDD VDD pm1p2_svt_lp L=6e-08 W=1.5e-07
MI32_MXPA1 nm m VDD VDD pm1p2_svt_lp L=6e-08 W=3.1e-07
MI20_MXPOEN ns nclk nm VDD pm1p2_svt_lp L=6e-08 W=2.6e-07
MI68_MXPOEN ns bclk XI68_p1 VDD pm1p2_svt_lp L=6e-08 W=1.5e-07
MI68_MXPA1 XI68_p1 s VDD VDD pm1p2_svt_lp L=6e-08 W=1.5e-07
MI28_MXPA1 s ns VDD VDD pm1p2_svt_lp L=6e-08 W=1.2e-07
MI75_MXPA1 Q ns VDD VDD pm1p2_svt_lp L=6e-08 W=5.85e-07
MI23_MXPA1 bclk nclk VDD VDD pm1p2_svt_lp L=6e-08 W=3e-07
MI22_MXPA1 nclk CK VDD VDD pm1p2_svt_lp L=6e-08 W=1.9e-07
.ENDS

.SUBCKT MDFFQX2H9R Q VDD VSS CK D0 D1 S0
MI70_MXNA1 ns0 S0 VSS VSS nm1p2_svt_lp L=6e-08 W=3.25e-07
MI112_MXNA1 nd1 D1 VSS VSS nm1p2_svt_lp L=6e-08 W=3.2e-07
MI110_MXNOE nenmux S0 nd1 VSS nm1p2_svt_lp L=6e-08 W=3.2e-07
MI111_MXNOE nenmux ns0 nd0 VSS nm1p2_svt_lp L=6e-08 W=3.2e-07
MI113_MXNA1 nd0 D0 VSS VSS nm1p2_svt_lp L=6e-08 W=3.2e-07
MI93_MXNA1 semux nenmux VSS VSS nm1p2_svt_lp L=6e-08 W=3.2e-07
MI33_MXNOE m nclk semux VSS nm1p2_svt_lp L=6e-08 W=3.2e-07
MI31_MXNOE m bclk XI31_n1 VSS nm1p2_svt_lp L=6e-08 W=1.5e-07
MI31_MXNA1 XI31_n1 nm VSS VSS nm1p2_svt_lp L=6e-08 W=1.5e-07
MI32_MXNA1 nm m VSS VSS nm1p2_svt_lp L=6e-08 W=2.5e-07
MI20_MXNOE ns bclk nm VSS nm1p2_svt_lp L=6e-08 W=3.2e-07
MI68_MXNOE ns nclk XI68_n1 VSS nm1p2_svt_lp L=6e-08 W=1.5e-07
MI68_MXNA1 XI68_n1 s VSS VSS nm1p2_svt_lp L=6e-08 W=1.5e-07
MI28_MXNA1 s ns VSS VSS nm1p2_svt_lp L=6e-08 W=1.2e-07
MI75_MXNA1 Q ns VSS VSS nm1p2_svt_lp L=6e-08 W=4.2e-07
MI75_MXNA1_2 Q ns VSS VSS nm1p2_svt_lp L=6e-08 W=4.2e-07
MI23_MXNA1 bclk nclk VSS VSS nm1p2_svt_lp L=6e-08 W=1.7e-07
MI22_MXNA1 nclk CK VSS VSS nm1p2_svt_lp L=6e-08 W=2.1e-07
MI70_MXPA1 ns0 S0 VDD VDD pm1p2_svt_lp L=6e-08 W=4.55e-07
MI112_MXPA1 nd1 D1 VDD VDD pm1p2_svt_lp L=6e-08 W=5.8e-07
MI110_MXPOEN nenmux ns0 nd1 VDD pm1p2_svt_lp L=6e-08 W=3.2e-07
MI111_MXPOEN nenmux S0 nd0 VDD pm1p2_svt_lp L=6e-08 W=3.2e-07
MI113_MXPA1 nd0 D0 VDD VDD pm1p2_svt_lp L=6e-08 W=5.8e-07
MI93_MXPA1 semux nenmux VDD VDD pm1p2_svt_lp L=6e-08 W=3.2e-07
MI33_MXPOEN m bclk semux VDD pm1p2_svt_lp L=6e-08 W=3.2e-07
MI31_MXPOEN m nclk XI31_p1 VDD pm1p2_svt_lp L=6e-08 W=1.5e-07
MI31_MXPA1 XI31_p1 nm VDD VDD pm1p2_svt_lp L=6e-08 W=1.5e-07
MI32_MXPA1 nm m VDD VDD pm1p2_svt_lp L=6e-08 W=4e-07
MI20_MXPOEN ns nclk nm VDD pm1p2_svt_lp L=6e-08 W=3.2e-07
MI68_MXPOEN ns bclk XI68_p1 VDD pm1p2_svt_lp L=6e-08 W=1.5e-07
MI68_MXPA1 XI68_p1 s VDD VDD pm1p2_svt_lp L=6e-08 W=1.5e-07
MI28_MXPA1 s ns VDD VDD pm1p2_svt_lp L=6e-08 W=1.2e-07
MI75_MXPA1 Q ns VDD VDD pm1p2_svt_lp L=6e-08 W=5.85e-07
MI75_MXPA1_2 Q ns VDD VDD pm1p2_svt_lp L=6e-08 W=5.85e-07
MI23_MXPA1 bclk nclk VDD VDD pm1p2_svt_lp L=6e-08 W=3.3e-07
MI22_MXPA1 nclk CK VDD VDD pm1p2_svt_lp L=6e-08 W=2.3e-07
.ENDS

.SUBCKT MDFFQX3H9R Q VDD VSS CK D0 D1 S0
MI70_MXNA1 ns0 S0 VSS VSS nm1p2_svt_lp L=6e-08 W=3.3e-07
MI112_MXNA1 nd1 D1 VSS VSS nm1p2_svt_lp L=6e-08 W=3.4e-07
MI110_MXNOE nenmux S0 nd1 VSS nm1p2_svt_lp L=6e-08 W=3.4e-07
MI111_MXNOE nenmux ns0 nd0 VSS nm1p2_svt_lp L=6e-08 W=3.4e-07
MI113_MXNA1 nd0 D0 VSS VSS nm1p2_svt_lp L=6e-08 W=3.4e-07
MI93_MXNA1 semux nenmux VSS VSS nm1p2_svt_lp L=6e-08 W=3.9e-07
MI33_MXNOE m nclk semux VSS nm1p2_svt_lp L=6e-08 W=3.9e-07
MI31_MXNOE m bclk XI31_n1 VSS nm1p2_svt_lp L=6e-08 W=1.5e-07
MI31_MXNA1 XI31_n1 nm VSS VSS nm1p2_svt_lp L=6e-08 W=1.5e-07
MI32_MXNA1 nm m VSS VSS nm1p2_svt_lp L=6e-08 W=2.8e-07
MI20_MXNOE ns bclk nm VSS nm1p2_svt_lp L=6e-08 W=3.9e-07
MI68_MXNOE ns nclk XI68_n1 VSS nm1p2_svt_lp L=6e-08 W=1.5e-07
MI68_MXNA1 XI68_n1 s VSS VSS nm1p2_svt_lp L=6e-08 W=1.5e-07
MI28_MXNA1 s ns VSS VSS nm1p2_svt_lp L=6e-08 W=1.2e-07
MI75_MXNA1 Q ns VSS VSS nm1p2_svt_lp L=6e-08 W=4.2e-07
MI75_MXNA1_2 Q ns VSS VSS nm1p2_svt_lp L=6e-08 W=4.2e-07
MI75_MXNA1_3 Q ns VSS VSS nm1p2_svt_lp L=6e-08 W=4.2e-07
MI23_MXNA1 bclk nclk VSS VSS nm1p2_svt_lp L=6e-08 W=1.8e-07
MI22_MXNA1 nclk CK VSS VSS nm1p2_svt_lp L=6e-08 W=2.2e-07
MI70_MXPA1 ns0 S0 VDD VDD pm1p2_svt_lp L=6e-08 W=4.65e-07
MI112_MXPA1 nd1 D1 VDD VDD pm1p2_svt_lp L=6e-08 W=5.6e-07
MI110_MXPOEN nenmux ns0 nd1 VDD pm1p2_svt_lp L=6e-08 W=4.4e-07
MI111_MXPOEN nenmux S0 nd0 VDD pm1p2_svt_lp L=6e-08 W=4.4e-07
MI113_MXPA1 nd0 D0 VDD VDD pm1p2_svt_lp L=6e-08 W=5.6e-07
MI93_MXPA1 semux nenmux VDD VDD pm1p2_svt_lp L=6e-08 W=3.9e-07
MI33_MXPOEN m bclk semux VDD pm1p2_svt_lp L=6e-08 W=3.9e-07
MI31_MXPOEN m nclk XI31_p1 VDD pm1p2_svt_lp L=6e-08 W=1.5e-07
MI31_MXPA1 XI31_p1 nm VDD VDD pm1p2_svt_lp L=6e-08 W=1.5e-07
MI32_MXPA1 nm m VDD VDD pm1p2_svt_lp L=6e-08 W=5.1e-07
MI20_MXPOEN ns nclk nm VDD pm1p2_svt_lp L=6e-08 W=3.9e-07
MI68_MXPOEN ns bclk XI68_p1 VDD pm1p2_svt_lp L=6e-08 W=1.5e-07
MI68_MXPA1 XI68_p1 s VDD VDD pm1p2_svt_lp L=6e-08 W=1.5e-07
MI28_MXPA1 s ns VDD VDD pm1p2_svt_lp L=6e-08 W=1.2e-07
MI75_MXPA1 Q ns VDD VDD pm1p2_svt_lp L=6e-08 W=5.85e-07
MI75_MXPA1_2 Q ns VDD VDD pm1p2_svt_lp L=6e-08 W=5.85e-07
MI75_MXPA1_3 Q ns VDD VDD pm1p2_svt_lp L=6e-08 W=5.85e-07
MI23_MXPA1 bclk nclk VDD VDD pm1p2_svt_lp L=6e-08 W=3.6e-07
MI22_MXPA1 nclk CK VDD VDD pm1p2_svt_lp L=6e-08 W=2.4e-07
.ENDS

.SUBCKT MDFFQX4H9R Q VDD VSS CK D0 D1 S0
MI70_MXNA1 ns0 S0 VSS VSS nm1p2_svt_lp L=6e-08 W=3.65e-07
MI112_MXNA1 nd1 D1 VSS VSS nm1p2_svt_lp L=6e-08 W=3.7e-07
MI110_MXNOE nenmux S0 nd1 VSS nm1p2_svt_lp L=6e-08 W=3.7e-07
MI111_MXNOE nenmux ns0 nd0 VSS nm1p2_svt_lp L=6e-08 W=3.7e-07
MI113_MXNA1 nd0 D0 VSS VSS nm1p2_svt_lp L=6e-08 W=3.7e-07
MI93_MXNA1 semux nenmux VSS VSS nm1p2_svt_lp L=6e-08 W=4.5e-07
MI33_MXNOE m nclk semux VSS nm1p2_svt_lp L=6e-08 W=4.5e-07
MI31_MXNOE m bclk XI31_n1 VSS nm1p2_svt_lp L=6e-08 W=1.5e-07
MI31_MXNA1 XI31_n1 nm VSS VSS nm1p2_svt_lp L=6e-08 W=1.5e-07
MI32_MXNA1 nm m VSS VSS nm1p2_svt_lp L=6e-08 W=2.6e-07
MI20_MXNOE ns bclk nm VSS nm1p2_svt_lp L=6e-08 W=4.5e-07
MI68_MXNOE ns nclk XI68_n1 VSS nm1p2_svt_lp L=6e-08 W=1.5e-07
MI68_MXNA1 XI68_n1 s VSS VSS nm1p2_svt_lp L=6e-08 W=1.5e-07
MI28_MXNA1 s ns VSS VSS nm1p2_svt_lp L=6e-08 W=1.2e-07
MI75_MXNA1 Q ns VSS VSS nm1p2_svt_lp L=6e-08 W=4.2e-07
MI75_MXNA1_2 Q ns VSS VSS nm1p2_svt_lp L=6e-08 W=4.2e-07
MI75_MXNA1_3 Q ns VSS VSS nm1p2_svt_lp L=6e-08 W=4.2e-07
MI75_MXNA1_4 Q ns VSS VSS nm1p2_svt_lp L=6e-08 W=4.2e-07
MI23_MXNA1 bclk nclk VSS VSS nm1p2_svt_lp L=6e-08 W=2.1e-07
MI22_MXNA1 nclk CK VSS VSS nm1p2_svt_lp L=6e-08 W=2.5e-07
MI70_MXPA1 ns0 S0 VDD VDD pm1p2_svt_lp L=6e-08 W=5.1e-07
MI112_MXPA1 nd1 D1 VDD VDD pm1p2_svt_lp L=6e-08 W=5.6e-07
MI110_MXPOEN nenmux ns0 nd1 VDD pm1p2_svt_lp L=6e-08 W=4.8e-07
MI111_MXPOEN nenmux S0 nd0 VDD pm1p2_svt_lp L=6e-08 W=4.8e-07
MI113_MXPA1 nd0 D0 VDD VDD pm1p2_svt_lp L=6e-08 W=5.6e-07
MI93_MXPA1 semux nenmux VDD VDD pm1p2_svt_lp L=6e-08 W=4.5e-07
MI33_MXPOEN m bclk semux VDD pm1p2_svt_lp L=6e-08 W=4.5e-07
MI31_MXPOEN m nclk XI31_p1 VDD pm1p2_svt_lp L=6e-08 W=1.5e-07
MI31_MXPA1 XI31_p1 nm VDD VDD pm1p2_svt_lp L=6e-08 W=1.5e-07
MI32_MXPA1 nm m VDD VDD pm1p2_svt_lp L=6e-08 W=5.1e-07
MI20_MXPOEN ns nclk nm VDD pm1p2_svt_lp L=6e-08 W=4.5e-07
MI68_MXPOEN ns bclk XI68_p1 VDD pm1p2_svt_lp L=6e-08 W=1.5e-07
MI68_MXPA1 XI68_p1 s VDD VDD pm1p2_svt_lp L=6e-08 W=1.5e-07
MI28_MXPA1 s ns VDD VDD pm1p2_svt_lp L=6e-08 W=1.2e-07
MI75_MXPA1 Q ns VDD VDD pm1p2_svt_lp L=6e-08 W=5.85e-07
MI75_MXPA1_2 Q ns VDD VDD pm1p2_svt_lp L=6e-08 W=5.85e-07
MI75_MXPA1_3 Q ns VDD VDD pm1p2_svt_lp L=6e-08 W=5.85e-07
MI75_MXPA1_4 Q ns VDD VDD pm1p2_svt_lp L=6e-08 W=5.85e-07
MI23_MXPA1 bclk nclk VDD VDD pm1p2_svt_lp L=6e-08 W=4.2e-07
MI22_MXPA1 nclk CK VDD VDD pm1p2_svt_lp L=6e-08 W=2.8e-07
.ENDS

.SUBCKT MDFFQNX0P5H9R QN VDD VSS CK D0 D1 S0
MI70_MXNA1 ns0 S0 VSS VSS nm1p2_svt_lp L=6e-08 W=2.3e-07
MI112_MXNA1 nd1 D1 VSS VSS nm1p2_svt_lp L=6e-08 W=2e-07
MI110_MXNOE nenmux S0 nd1 VSS nm1p2_svt_lp L=6e-08 W=2e-07
MI111_MXNOE nenmux ns0 nd0 VSS nm1p2_svt_lp L=6e-08 W=2e-07
MI113_MXNA1 nd0 D0 VSS VSS nm1p2_svt_lp L=6e-08 W=2e-07
MI93_MXNA1 semux nenmux VSS VSS nm1p2_svt_lp L=6e-08 W=1.5e-07
MI33_MXNOE m nclk semux VSS nm1p2_svt_lp L=6e-08 W=1.5e-07
MI31_MXNOE m bclk XI31_n1 VSS nm1p2_svt_lp L=6e-08 W=1.5e-07
MI31_MXNA1 XI31_n1 nm VSS VSS nm1p2_svt_lp L=6e-08 W=1.5e-07
MI32_MXNA1 nm m VSS VSS nm1p2_svt_lp L=6e-08 W=1.5e-07
MI20_MXNOE ns bclk nm VSS nm1p2_svt_lp L=6e-08 W=1.5e-07
MI29_MXNOE ns nclk XI29_n1 VSS nm1p2_svt_lp L=6e-08 W=1.5e-07
MI29_MXNA1 XI29_n1 s VSS VSS nm1p2_svt_lp L=6e-08 W=1.5e-07
MI28_MXNA1 s ns VSS VSS nm1p2_svt_lp L=6e-08 W=1.5e-07
MI8_MXNA1 QN s VSS VSS nm1p2_svt_lp L=6e-08 W=2.1e-07
MI23_MXNA1 bclk nclk VSS VSS nm1p2_svt_lp L=6e-08 W=1.5e-07
MI22_MXNA1 nclk CK VSS VSS nm1p2_svt_lp L=6e-08 W=1.5e-07
MI70_MXPA1 ns0 S0 VDD VDD pm1p2_svt_lp L=6e-08 W=3.25e-07
MI112_MXPA1 nd1 D1 VDD VDD pm1p2_svt_lp L=6e-08 W=4.4e-07
MI110_MXPOEN nenmux ns0 nd1 VDD pm1p2_svt_lp L=6e-08 W=2.5e-07
MI111_MXPOEN nenmux S0 nd0 VDD pm1p2_svt_lp L=6e-08 W=2.5e-07
MI113_MXPA1 nd0 D0 VDD VDD pm1p2_svt_lp L=6e-08 W=4.4e-07
MI93_MXPA1 semux nenmux VDD VDD pm1p2_svt_lp L=6e-08 W=1.5e-07
MI33_MXPOEN m bclk semux VDD pm1p2_svt_lp L=6e-08 W=1.5e-07
MI31_MXPOEN m nclk XI31_p1 VDD pm1p2_svt_lp L=6e-08 W=1.5e-07
MI31_MXPA1 XI31_p1 nm VDD VDD pm1p2_svt_lp L=6e-08 W=1.5e-07
MI32_MXPA1 nm m VDD VDD pm1p2_svt_lp L=6e-08 W=1.7e-07
MI20_MXPOEN ns nclk nm VDD pm1p2_svt_lp L=6e-08 W=1.5e-07
MI29_MXPOEN ns bclk XI29_p1 VDD pm1p2_svt_lp L=6e-08 W=1.5e-07
MI29_MXPA1 XI29_p1 s VDD VDD pm1p2_svt_lp L=6e-08 W=1.5e-07
MI28_MXPA1 s ns VDD VDD pm1p2_svt_lp L=6e-08 W=2.4e-07
MI8_MXPA1 QN s VDD VDD pm1p2_svt_lp L=6e-08 W=2.95e-07
MI23_MXPA1 bclk nclk VDD VDD pm1p2_svt_lp L=6e-08 W=1.9e-07
MI22_MXPA1 nclk CK VDD VDD pm1p2_svt_lp L=6e-08 W=1.7e-07
.ENDS

.SUBCKT MDFFQNX1H9R QN VDD VSS CK D0 D1 S0
MI70_MXNA1 ns0 S0 VSS VSS nm1p2_svt_lp L=6e-08 W=2.85e-07
MI112_MXNA1 nd1 D1 VSS VSS nm1p2_svt_lp L=6e-08 W=2.6e-07
MI110_MXNOE nenmux S0 nd1 VSS nm1p2_svt_lp L=6e-08 W=2.6e-07
MI111_MXNOE nenmux ns0 nd0 VSS nm1p2_svt_lp L=6e-08 W=2.6e-07
MI113_MXNA1 nd0 D0 VSS VSS nm1p2_svt_lp L=6e-08 W=2.6e-07
MI93_MXNA1 semux nenmux VSS VSS nm1p2_svt_lp L=6e-08 W=2.6e-07
MI33_MXNOE m nclk semux VSS nm1p2_svt_lp L=6e-08 W=2.6e-07
MI31_MXNOE m bclk XI31_n1 VSS nm1p2_svt_lp L=6e-08 W=1.5e-07
MI31_MXNA1 XI31_n1 nm VSS VSS nm1p2_svt_lp L=6e-08 W=1.5e-07
MI32_MXNA1 nm m VSS VSS nm1p2_svt_lp L=6e-08 W=2.2e-07
MI20_MXNOE ns bclk nm VSS nm1p2_svt_lp L=6e-08 W=2.6e-07
MI29_MXNOE ns nclk XI29_n1 VSS nm1p2_svt_lp L=6e-08 W=1.5e-07
MI29_MXNA1 XI29_n1 s VSS VSS nm1p2_svt_lp L=6e-08 W=1.5e-07
MI28_MXNA1 s ns VSS VSS nm1p2_svt_lp L=6e-08 W=2e-07
MI8_MXNA1 QN s VSS VSS nm1p2_svt_lp L=6e-08 W=4.2e-07
MI23_MXNA1 bclk nclk VSS VSS nm1p2_svt_lp L=6e-08 W=1.5e-07
MI22_MXNA1 nclk CK VSS VSS nm1p2_svt_lp L=6e-08 W=1.7e-07
MI70_MXPA1 ns0 S0 VDD VDD pm1p2_svt_lp L=6e-08 W=4e-07
MI112_MXPA1 nd1 D1 VDD VDD pm1p2_svt_lp L=6e-08 W=5.6e-07
MI110_MXPOEN nenmux ns0 nd1 VDD pm1p2_svt_lp L=6e-08 W=2.6e-07
MI111_MXPOEN nenmux S0 nd0 VDD pm1p2_svt_lp L=6e-08 W=2.6e-07
MI113_MXPA1 nd0 D0 VDD VDD pm1p2_svt_lp L=6e-08 W=5.6e-07
MI93_MXPA1 semux nenmux VDD VDD pm1p2_svt_lp L=6e-08 W=2.6e-07
MI33_MXPOEN m bclk semux VDD pm1p2_svt_lp L=6e-08 W=2.6e-07
MI31_MXPOEN m nclk XI31_p1 VDD pm1p2_svt_lp L=6e-08 W=1.5e-07
MI31_MXPA1 XI31_p1 nm VDD VDD pm1p2_svt_lp L=6e-08 W=1.5e-07
MI32_MXPA1 nm m VDD VDD pm1p2_svt_lp L=6e-08 W=3.4e-07
MI20_MXPOEN ns nclk nm VDD pm1p2_svt_lp L=6e-08 W=2.6e-07
MI29_MXPOEN ns bclk XI29_p1 VDD pm1p2_svt_lp L=6e-08 W=1.5e-07
MI29_MXPA1 XI29_p1 s VDD VDD pm1p2_svt_lp L=6e-08 W=1.5e-07
MI28_MXPA1 s ns VDD VDD pm1p2_svt_lp L=6e-08 W=3.6e-07
MI8_MXPA1 QN s VDD VDD pm1p2_svt_lp L=6e-08 W=5.85e-07
MI23_MXPA1 bclk nclk VDD VDD pm1p2_svt_lp L=6e-08 W=3e-07
MI22_MXPA1 nclk CK VDD VDD pm1p2_svt_lp L=6e-08 W=1.9e-07
.ENDS

.SUBCKT MDFFQNX2H9R QN VDD VSS CK D0 D1 S0
MI70_MXNA1 ns0 S0 VSS VSS nm1p2_svt_lp L=6e-08 W=3.05e-07
MI112_MXNA1 nd1 D1 VSS VSS nm1p2_svt_lp L=6e-08 W=3e-07
MI110_MXNOE nenmux S0 nd1 VSS nm1p2_svt_lp L=6e-08 W=3e-07
MI111_MXNOE nenmux ns0 nd0 VSS nm1p2_svt_lp L=6e-08 W=3e-07
MI113_MXNA1 nd0 D0 VSS VSS nm1p2_svt_lp L=6e-08 W=3e-07
MI93_MXNA1 semux nenmux VSS VSS nm1p2_svt_lp L=6e-08 W=3.2e-07
MI33_MXNOE m nclk semux VSS nm1p2_svt_lp L=6e-08 W=3.2e-07
MI31_MXNOE m bclk XI31_n1 VSS nm1p2_svt_lp L=6e-08 W=1.5e-07
MI31_MXNA1 XI31_n1 nm VSS VSS nm1p2_svt_lp L=6e-08 W=1.5e-07
MI32_MXNA1 nm m VSS VSS nm1p2_svt_lp L=6e-08 W=2.9e-07
MI20_MXNOE ns bclk nm VSS nm1p2_svt_lp L=6e-08 W=3.2e-07
MI29_MXNOE ns nclk XI29_n1 VSS nm1p2_svt_lp L=6e-08 W=1.5e-07
MI29_MXNA1 XI29_n1 s VSS VSS nm1p2_svt_lp L=6e-08 W=1.5e-07
MI28_MXNA1 s ns VSS VSS nm1p2_svt_lp L=6e-08 W=2.5e-07
MI8_MXNA1 QN s VSS VSS nm1p2_svt_lp L=6e-08 W=4.2e-07
MI8_MXNA1_2 QN s VSS VSS nm1p2_svt_lp L=6e-08 W=4.2e-07
MI23_MXNA1 bclk nclk VSS VSS nm1p2_svt_lp L=6e-08 W=1.7e-07
MI22_MXNA1 nclk CK VSS VSS nm1p2_svt_lp L=6e-08 W=2.1e-07
MI70_MXPA1 ns0 S0 VDD VDD pm1p2_svt_lp L=6e-08 W=4.3e-07
MI112_MXPA1 nd1 D1 VDD VDD pm1p2_svt_lp L=6e-08 W=5.7e-07
MI110_MXPOEN nenmux ns0 nd1 VDD pm1p2_svt_lp L=6e-08 W=3.4e-07
MI111_MXPOEN nenmux S0 nd0 VDD pm1p2_svt_lp L=6e-08 W=3.4e-07
MI113_MXPA1 nd0 D0 VDD VDD pm1p2_svt_lp L=6e-08 W=5.7e-07
MI93_MXPA1 semux nenmux VDD VDD pm1p2_svt_lp L=6e-08 W=3.2e-07
MI33_MXPOEN m bclk semux VDD pm1p2_svt_lp L=6e-08 W=3.2e-07
MI31_MXPOEN m nclk XI31_p1 VDD pm1p2_svt_lp L=6e-08 W=1.5e-07
MI31_MXPA1 XI31_p1 nm VDD VDD pm1p2_svt_lp L=6e-08 W=1.5e-07
MI32_MXPA1 nm m VDD VDD pm1p2_svt_lp L=6e-08 W=4.4e-07
MI20_MXPOEN ns nclk nm VDD pm1p2_svt_lp L=6e-08 W=3.2e-07
MI29_MXPOEN ns bclk XI29_p1 VDD pm1p2_svt_lp L=6e-08 W=1.5e-07
MI29_MXPA1 XI29_p1 s VDD VDD pm1p2_svt_lp L=6e-08 W=1.5e-07
MI28_MXPA1 s ns VDD VDD pm1p2_svt_lp L=6e-08 W=4.7e-07
MI8_MXPA1 QN s VDD VDD pm1p2_svt_lp L=6e-08 W=5.85e-07
MI8_MXPA1_2 QN s VDD VDD pm1p2_svt_lp L=6e-08 W=5.85e-07
MI23_MXPA1 bclk nclk VDD VDD pm1p2_svt_lp L=6e-08 W=3.3e-07
MI22_MXPA1 nclk CK VDD VDD pm1p2_svt_lp L=6e-08 W=2.3e-07
.ENDS

.SUBCKT MDFFQNX3H9R QN VDD VSS CK D0 D1 S0
MI70_MXNA1 ns0 S0 VSS VSS nm1p2_svt_lp L=6e-08 W=3.3e-07
MI112_MXNA1 nd1 D1 VSS VSS nm1p2_svt_lp L=6e-08 W=2e-07
MI110_MXNOE nenmux S0 nd1 VSS nm1p2_svt_lp L=6e-08 W=2e-07
MI111_MXNOE nenmux ns0 nd0 VSS nm1p2_svt_lp L=6e-08 W=2e-07
MI113_MXNA1 nd0 D0 VSS VSS nm1p2_svt_lp L=6e-08 W=2e-07
MI93_MXNA1 semux nenmux VSS VSS nm1p2_svt_lp L=6e-08 W=3.9e-07
MI33_MXNOE m nclk semux VSS nm1p2_svt_lp L=6e-08 W=3.9e-07
MI31_MXNOE m bclk XI31_n1 VSS nm1p2_svt_lp L=6e-08 W=1.5e-07
MI31_MXNA1 XI31_n1 nm VSS VSS nm1p2_svt_lp L=6e-08 W=1.5e-07
MI32_MXNA1 nm m VSS VSS nm1p2_svt_lp L=6e-08 W=3.9e-07
MI20_MXNOE ns bclk nm VSS nm1p2_svt_lp L=6e-08 W=3.9e-07
MI29_MXNOE ns nclk XI29_n1 VSS nm1p2_svt_lp L=6e-08 W=1.5e-07
MI29_MXNA1 XI29_n1 s VSS VSS nm1p2_svt_lp L=6e-08 W=1.5e-07
MI28_MXNA1 s ns VSS VSS nm1p2_svt_lp L=6e-08 W=2.9e-07
MI8_MXNA1 QN s VSS VSS nm1p2_svt_lp L=6e-08 W=4.2e-07
MI8_MXNA1_2 QN s VSS VSS nm1p2_svt_lp L=6e-08 W=4.2e-07
MI8_MXNA1_3 QN s VSS VSS nm1p2_svt_lp L=6e-08 W=4.2e-07
MI23_MXNA1 bclk nclk VSS VSS nm1p2_svt_lp L=6e-08 W=1.8e-07
MI22_MXNA1 nclk CK VSS VSS nm1p2_svt_lp L=6e-08 W=2.2e-07
MI70_MXPA1 ns0 S0 VDD VDD pm1p2_svt_lp L=6e-08 W=4.65e-07
MI112_MXPA1 nd1 D1 VDD VDD pm1p2_svt_lp L=6e-08 W=5e-07
MI110_MXPOEN nenmux ns0 nd1 VDD pm1p2_svt_lp L=6e-08 W=5.8e-07
MI111_MXPOEN nenmux S0 nd0 VDD pm1p2_svt_lp L=6e-08 W=5.8e-07
MI113_MXPA1 nd0 D0 VDD VDD pm1p2_svt_lp L=6e-08 W=5e-07
MI93_MXPA1 semux nenmux VDD VDD pm1p2_svt_lp L=6e-08 W=5.8e-07
MI33_MXPOEN m bclk semux VDD pm1p2_svt_lp L=6e-08 W=3.9e-07
MI31_MXPOEN m nclk XI31_p1 VDD pm1p2_svt_lp L=6e-08 W=1.5e-07
MI31_MXPA1 XI31_p1 nm VDD VDD pm1p2_svt_lp L=6e-08 W=1.5e-07
MI32_MXPA1 nm m VDD VDD pm1p2_svt_lp L=6e-08 W=5.2e-07
MI20_MXPOEN ns nclk nm VDD pm1p2_svt_lp L=6e-08 W=3.9e-07
MI29_MXPOEN ns bclk XI29_p1 VDD pm1p2_svt_lp L=6e-08 W=1.5e-07
MI29_MXPA1 XI29_p1 s VDD VDD pm1p2_svt_lp L=6e-08 W=1.5e-07
MI28_MXPA1 s ns VDD VDD pm1p2_svt_lp L=6e-08 W=5.4e-07
MI8_MXPA1 QN s VDD VDD pm1p2_svt_lp L=6e-08 W=5.85e-07
MI8_MXPA1_2 QN s VDD VDD pm1p2_svt_lp L=6e-08 W=5.85e-07
MI8_MXPA1_3 QN s VDD VDD pm1p2_svt_lp L=6e-08 W=5.85e-07
MI23_MXPA1 bclk nclk VDD VDD pm1p2_svt_lp L=6e-08 W=3.6e-07
MI22_MXPA1 nclk CK VDD VDD pm1p2_svt_lp L=6e-08 W=2.4e-07
.ENDS

.SUBCKT ADFFQX0P5H9R Q VDD VSS A B CK
MI0_MXNA1 nin A XI0_n1 VSS nm1p2_svt_lp L=6e-08 W=2.75e-07
MI0_MXNA2 XI0_n1 B VSS VSS nm1p2_svt_lp L=6e-08 W=2.75e-07
MI23_MXNA1 bclk nclk VSS VSS nm1p2_svt_lp L=6e-08 W=1.5e-07
MI33_MXNOE nm nclk nin VSS nm1p2_svt_lp L=6e-08 W=1.5e-07
MI31_MXNOE nm bclk XI31_n1 VSS nm1p2_svt_lp L=6e-08 W=1.5e-07
MI31_MXNA1 XI31_n1 m VSS VSS nm1p2_svt_lp L=6e-08 W=1.5e-07
MI32_MXNA1 m nm VSS VSS nm1p2_svt_lp L=6e-08 W=1.5e-07
MI20_MXNOE s bclk m VSS nm1p2_svt_lp L=6e-08 W=1.5e-07
MI29_MXNOE s nclk XI29_n1 VSS nm1p2_svt_lp L=6e-08 W=1.5e-07
MI29_MXNA1 XI29_n1 ns VSS VSS nm1p2_svt_lp L=6e-08 W=1.5e-07
MI8_MXNA1 Q ns VSS VSS nm1p2_svt_lp L=6e-08 W=2.1e-07
MI28_MXNA1 ns s VSS VSS nm1p2_svt_lp L=6e-08 W=1.5e-07
MI22_MXNA1 nclk CK VSS VSS nm1p2_svt_lp L=6e-08 W=1.5e-07
MI0_MXPA1 nin A VDD VDD pm1p2_svt_lp L=6e-08 W=1.5e-07
MI0_MXPA2 nin B VDD VDD pm1p2_svt_lp L=6e-08 W=1.5e-07
MI23_MXPA1 bclk nclk VDD VDD pm1p2_svt_lp L=6e-08 W=1.9e-07
MI33_MXPOEN nm bclk nin VDD pm1p2_svt_lp L=6e-08 W=1.5e-07
MI31_MXPOEN nm nclk XI31_p1 VDD pm1p2_svt_lp L=6e-08 W=1.5e-07
MI31_MXPA1 XI31_p1 m VDD VDD pm1p2_svt_lp L=6e-08 W=1.5e-07
MI32_MXPA1 m nm VDD VDD pm1p2_svt_lp L=6e-08 W=2.3e-07
MI20_MXPOEN s nclk m VDD pm1p2_svt_lp L=6e-08 W=1.5e-07
MI29_MXPOEN s bclk XI29_p1 VDD pm1p2_svt_lp L=6e-08 W=1.5e-07
MI29_MXPA1 XI29_p1 ns VDD VDD pm1p2_svt_lp L=6e-08 W=1.5e-07
MI8_MXPA1 Q ns VDD VDD pm1p2_svt_lp L=6e-08 W=2.95e-07
MI28_MXPA1 ns s VDD VDD pm1p2_svt_lp L=6e-08 W=3.2e-07
MI22_MXPA1 nclk CK VDD VDD pm1p2_svt_lp L=6e-08 W=1.7e-07
.ENDS

.SUBCKT ADFFQX1H9R Q VDD VSS A B CK
MI0_MXNA1 nin A XI0_n1 VSS nm1p2_svt_lp L=6e-08 W=4.1e-07
MI0_MXNA2 XI0_n1 B VSS VSS nm1p2_svt_lp L=6e-08 W=4.1e-07
MI23_MXNA1 bclk nclk VSS VSS nm1p2_svt_lp L=6e-08 W=1.5e-07
MI33_MXNOE nm nclk nin VSS nm1p2_svt_lp L=6e-08 W=2.6e-07
MI31_MXNOE nm bclk XI31_n1 VSS nm1p2_svt_lp L=6e-08 W=1.5e-07
MI31_MXNA1 XI31_n1 m VSS VSS nm1p2_svt_lp L=6e-08 W=1.5e-07
MI32_MXNA1 m nm VSS VSS nm1p2_svt_lp L=6e-08 W=2.05e-07
MI20_MXNOE s bclk m VSS nm1p2_svt_lp L=6e-08 W=2.6e-07
MI29_MXNOE s nclk XI29_n1 VSS nm1p2_svt_lp L=6e-08 W=1.5e-07
MI29_MXNA1 XI29_n1 ns VSS VSS nm1p2_svt_lp L=6e-08 W=1.5e-07
MI8_MXNA1 Q ns VSS VSS nm1p2_svt_lp L=6e-08 W=4.2e-07
MI28_MXNA1 ns s VSS VSS nm1p2_svt_lp L=6e-08 W=2.1e-07
MI22_MXNA1 nclk CK VSS VSS nm1p2_svt_lp L=6e-08 W=1.7e-07
MI0_MXPA1 nin A VDD VDD pm1p2_svt_lp L=6e-08 W=2.2e-07
MI0_MXPA2 nin B VDD VDD pm1p2_svt_lp L=6e-08 W=2.2e-07
MI23_MXPA1 bclk nclk VDD VDD pm1p2_svt_lp L=6e-08 W=3e-07
MI33_MXPOEN nm bclk nin VDD pm1p2_svt_lp L=6e-08 W=2.6e-07
MI31_MXPOEN nm nclk XI31_p1 VDD pm1p2_svt_lp L=6e-08 W=1.5e-07
MI31_MXPA1 XI31_p1 m VDD VDD pm1p2_svt_lp L=6e-08 W=1.5e-07
MI32_MXPA1 m nm VDD VDD pm1p2_svt_lp L=6e-08 W=3.3e-07
MI20_MXPOEN s nclk m VDD pm1p2_svt_lp L=6e-08 W=2.6e-07
MI29_MXPOEN s bclk XI29_p1 VDD pm1p2_svt_lp L=6e-08 W=1.5e-07
MI29_MXPA1 XI29_p1 ns VDD VDD pm1p2_svt_lp L=6e-08 W=1.5e-07
MI8_MXPA1 Q ns VDD VDD pm1p2_svt_lp L=6e-08 W=5.85e-07
MI28_MXPA1 ns s VDD VDD pm1p2_svt_lp L=6e-08 W=3.7e-07
MI22_MXPA1 nclk CK VDD VDD pm1p2_svt_lp L=6e-08 W=1.9e-07
.ENDS

.SUBCKT ADFFQX2H9R Q VDD VSS A B CK
MI0_MXNA1 nin A XI0_n1 VSS nm1p2_svt_lp L=6e-08 W=4.7e-07
MI0_MXNA2 XI0_n1 B VSS VSS nm1p2_svt_lp L=6e-08 W=4.7e-07
MI23_MXNA1 bclk nclk VSS VSS nm1p2_svt_lp L=6e-08 W=1.7e-07
MI33_MXNOE nm nclk nin VSS nm1p2_svt_lp L=6e-08 W=3.2e-07
MI31_MXNOE nm bclk XI31_n1 VSS nm1p2_svt_lp L=6e-08 W=1.5e-07
MI31_MXNA1 XI31_n1 m VSS VSS nm1p2_svt_lp L=6e-08 W=1.5e-07
MI32_MXNA1 m nm VSS VSS nm1p2_svt_lp L=6e-08 W=3.2e-07
MI20_MXNOE s bclk m VSS nm1p2_svt_lp L=6e-08 W=3.2e-07
MI29_MXNOE s nclk XI29_n1 VSS nm1p2_svt_lp L=6e-08 W=1.5e-07
MI29_MXNA1 XI29_n1 ns VSS VSS nm1p2_svt_lp L=6e-08 W=1.5e-07
MI8_MXNA1 Q ns VSS VSS nm1p2_svt_lp L=6e-08 W=4.2e-07
MI8_MXNA1_2 Q ns VSS VSS nm1p2_svt_lp L=6e-08 W=4.2e-07
MI28_MXNA1 ns s VSS VSS nm1p2_svt_lp L=6e-08 W=2.4e-07
MI22_MXNA1 nclk CK VSS VSS nm1p2_svt_lp L=6e-08 W=2.1e-07
MI0_MXPA1 nin A VDD VDD pm1p2_svt_lp L=6e-08 W=2.4e-07
MI0_MXPA2 nin B VDD VDD pm1p2_svt_lp L=6e-08 W=2.4e-07
MI23_MXPA1 bclk nclk VDD VDD pm1p2_svt_lp L=6e-08 W=3.3e-07
MI33_MXPOEN nm bclk nin VDD pm1p2_svt_lp L=6e-08 W=3.2e-07
MI31_MXPOEN nm nclk XI31_p1 VDD pm1p2_svt_lp L=6e-08 W=1.5e-07
MI31_MXPA1 XI31_p1 m VDD VDD pm1p2_svt_lp L=6e-08 W=1.5e-07
MI32_MXPA1 m nm VDD VDD pm1p2_svt_lp L=6e-08 W=4e-07
MI20_MXPOEN s nclk m VDD pm1p2_svt_lp L=6e-08 W=3.2e-07
MI29_MXPOEN s bclk XI29_p1 VDD pm1p2_svt_lp L=6e-08 W=1.5e-07
MI29_MXPA1 XI29_p1 ns VDD VDD pm1p2_svt_lp L=6e-08 W=1.5e-07
MI8_MXPA1 Q ns VDD VDD pm1p2_svt_lp L=6e-08 W=5.85e-07
MI8_MXPA1_2 Q ns VDD VDD pm1p2_svt_lp L=6e-08 W=5.85e-07
MI28_MXPA1 ns s VDD VDD pm1p2_svt_lp L=6e-08 W=4.2e-07
MI22_MXPA1 nclk CK VDD VDD pm1p2_svt_lp L=6e-08 W=2.3e-07
.ENDS

.SUBCKT ADFFQX3H9R Q VDD VSS A B CK
MI0_MXNA1 nin A XI0_n1 VSS nm1p2_svt_lp L=6e-08 W=4.95e-07
MI0_MXNA2 XI0_n1 B VSS VSS nm1p2_svt_lp L=6e-08 W=4.95e-07
MI23_MXNA1 bclk nclk VSS VSS nm1p2_svt_lp L=6e-08 W=1.8e-07
MI33_MXNOE nm nclk nin VSS nm1p2_svt_lp L=6e-08 W=3.9e-07
MI31_MXNOE nm bclk XI31_n1 VSS nm1p2_svt_lp L=6e-08 W=1.5e-07
MI31_MXNA1 XI31_n1 m VSS VSS nm1p2_svt_lp L=6e-08 W=1.5e-07
MI32_MXNA1 m nm VSS VSS nm1p2_svt_lp L=6e-08 W=4.4e-07
MI20_MXNOE s bclk m VSS nm1p2_svt_lp L=6e-08 W=3.9e-07
MI29_MXNOE s nclk XI29_n1 VSS nm1p2_svt_lp L=6e-08 W=1.5e-07
MI29_MXNA1 XI29_n1 ns VSS VSS nm1p2_svt_lp L=6e-08 W=1.5e-07
MI8_MXNA1 Q ns VSS VSS nm1p2_svt_lp L=6e-08 W=4.2e-07
MI8_MXNA1_2 Q ns VSS VSS nm1p2_svt_lp L=6e-08 W=4.2e-07
MI8_MXNA1_3 Q ns VSS VSS nm1p2_svt_lp L=6e-08 W=4.2e-07
MI28_MXNA1 ns s VSS VSS nm1p2_svt_lp L=6e-08 W=3e-07
MI22_MXNA1 nclk CK VSS VSS nm1p2_svt_lp L=6e-08 W=2.2e-07
MI0_MXPA1 nin A VDD VDD pm1p2_svt_lp L=6e-08 W=2.5e-07
MI0_MXPA2 nin B VDD VDD pm1p2_svt_lp L=6e-08 W=2.5e-07
MI23_MXPA1 bclk nclk VDD VDD pm1p2_svt_lp L=6e-08 W=3.6e-07
MI33_MXPOEN nm bclk nin VDD pm1p2_svt_lp L=6e-08 W=3.9e-07
MI31_MXPOEN nm nclk XI31_p1 VDD pm1p2_svt_lp L=6e-08 W=1.5e-07
MI31_MXPA1 XI31_p1 m VDD VDD pm1p2_svt_lp L=6e-08 W=1.5e-07
MI32_MXPA1 m nm VDD VDD pm1p2_svt_lp L=6e-08 W=5.1e-07
MI20_MXPOEN s nclk m VDD pm1p2_svt_lp L=6e-08 W=3.9e-07
MI29_MXPOEN s bclk XI29_p1 VDD pm1p2_svt_lp L=6e-08 W=1.5e-07
MI29_MXPA1 XI29_p1 ns VDD VDD pm1p2_svt_lp L=6e-08 W=1.5e-07
MI8_MXPA1 Q ns VDD VDD pm1p2_svt_lp L=6e-08 W=5.85e-07
MI8_MXPA1_2 Q ns VDD VDD pm1p2_svt_lp L=6e-08 W=5.85e-07
MI8_MXPA1_3 Q ns VDD VDD pm1p2_svt_lp L=6e-08 W=5.85e-07
MI28_MXPA1 ns s VDD VDD pm1p2_svt_lp L=6e-08 W=5.4e-07
MI22_MXPA1 nclk CK VDD VDD pm1p2_svt_lp L=6e-08 W=2.4e-07
.ENDS

.SUBCKT ADFFQX4H9R Q VDD VSS A B CK
MI0_MXNA1 nin A XI0_n1 VSS nm1p2_svt_lp L=6e-08 W=4.95e-07
MI0_MXNA2 XI0_n1 B VSS VSS nm1p2_svt_lp L=6e-08 W=4.95e-07
MI23_MXNA1 bclk nclk VSS VSS nm1p2_svt_lp L=6e-08 W=2.1e-07
MI33_MXNOE nm nclk nin VSS nm1p2_svt_lp L=6e-08 W=4.5e-07
MI31_MXNOE nm bclk XI31_n1 VSS nm1p2_svt_lp L=6e-08 W=1.5e-07
MI31_MXNA1 XI31_n1 m VSS VSS nm1p2_svt_lp L=6e-08 W=1.5e-07
MI32_MXNA1 m nm VSS VSS nm1p2_svt_lp L=6e-08 W=4.5e-07
MI20_MXNOE s bclk m VSS nm1p2_svt_lp L=6e-08 W=4.5e-07
MI29_MXNOE s nclk XI29_n1 VSS nm1p2_svt_lp L=6e-08 W=1.5e-07
MI29_MXNA1 XI29_n1 ns VSS VSS nm1p2_svt_lp L=6e-08 W=1.5e-07
MI8_MXNA1 Q ns VSS VSS nm1p2_svt_lp L=6e-08 W=4.2e-07
MI8_MXNA1_2 Q ns VSS VSS nm1p2_svt_lp L=6e-08 W=4.2e-07
MI8_MXNA1_3 Q ns VSS VSS nm1p2_svt_lp L=6e-08 W=4.2e-07
MI8_MXNA1_4 Q ns VSS VSS nm1p2_svt_lp L=6e-08 W=4.2e-07
MI28_MXNA1 ns s VSS VSS nm1p2_svt_lp L=6e-08 W=3.6e-07
MI28_MXNA1_2 ns s VSS VSS nm1p2_svt_lp L=6e-08 W=3.6e-07
MI22_MXNA1 nclk CK VSS VSS nm1p2_svt_lp L=6e-08 W=2.5e-07
MI0_MXPA1 nin A VDD VDD pm1p2_svt_lp L=6e-08 W=2.7e-07
MI0_MXPA2 nin B VDD VDD pm1p2_svt_lp L=6e-08 W=2.7e-07
MI23_MXPA1 bclk nclk VDD VDD pm1p2_svt_lp L=6e-08 W=4.2e-07
MI33_MXPOEN nm bclk nin VDD pm1p2_svt_lp L=6e-08 W=4.5e-07
MI31_MXPOEN nm nclk XI31_p1 VDD pm1p2_svt_lp L=6e-08 W=1.5e-07
MI31_MXPA1 XI31_p1 m VDD VDD pm1p2_svt_lp L=6e-08 W=1.5e-07
MI32_MXPA1 m nm VDD VDD pm1p2_svt_lp L=6e-08 W=5.5e-07
MI20_MXPOEN s nclk m VDD pm1p2_svt_lp L=6e-08 W=4.5e-07
MI29_MXPOEN s bclk XI29_p1 VDD pm1p2_svt_lp L=6e-08 W=1.5e-07
MI29_MXPA1 XI29_p1 ns VDD VDD pm1p2_svt_lp L=6e-08 W=1.5e-07
MI8_MXPA1 Q ns VDD VDD pm1p2_svt_lp L=6e-08 W=5.85e-07
MI8_MXPA1_2 Q ns VDD VDD pm1p2_svt_lp L=6e-08 W=5.85e-07
MI8_MXPA1_3 Q ns VDD VDD pm1p2_svt_lp L=6e-08 W=5.85e-07
MI8_MXPA1_4 Q ns VDD VDD pm1p2_svt_lp L=6e-08 W=5.85e-07
MI28_MXPA1 ns s VDD VDD pm1p2_svt_lp L=6e-08 W=4.8e-07
MI28_MXPA1_2 ns s VDD VDD pm1p2_svt_lp L=6e-08 W=4.8e-07
MI22_MXPA1 nclk CK VDD VDD pm1p2_svt_lp L=6e-08 W=2.8e-07
.ENDS

.SUBCKT ADFFQNX0P5H9R QN VDD VSS A B CK
MI0_MXNA1 nin A XI0_n1 VSS nm1p2_svt_lp L=6e-08 W=3.3e-07
MI0_MXNA2 XI0_n1 B VSS VSS nm1p2_svt_lp L=6e-08 W=3.3e-07
MI23_MXNA1 bclk nclk VSS VSS nm1p2_svt_lp L=6e-08 W=1.5e-07
MI33_MXNOE nm nclk nin VSS nm1p2_svt_lp L=6e-08 W=1.5e-07
MI31_MXNOE nm bclk XI31_n1 VSS nm1p2_svt_lp L=6e-08 W=1.5e-07
MI31_MXNA1 XI31_n1 m VSS VSS nm1p2_svt_lp L=6e-08 W=1.5e-07
MI32_MXNA1 m nm VSS VSS nm1p2_svt_lp L=6e-08 W=1.9e-07
MI20_MXNOE s bclk m VSS nm1p2_svt_lp L=6e-08 W=1.5e-07
MI69_MXNOE s nclk XI69_n1 VSS nm1p2_svt_lp L=6e-08 W=1.5e-07
MI69_MXNA1 XI69_n1 ns VSS VSS nm1p2_svt_lp L=6e-08 W=1.5e-07
MI28_MXNA1 ns s VSS VSS nm1p2_svt_lp L=6e-08 W=1.2e-07
MI22_MXNA1 nclk CK VSS VSS nm1p2_svt_lp L=6e-08 W=1.5e-07
MI75_MXNA1 QN s VSS VSS nm1p2_svt_lp L=6e-08 W=2.1e-07
MI0_MXPA1 nin A VDD VDD pm1p2_svt_lp L=6e-08 W=1.5e-07
MI0_MXPA2 nin B VDD VDD pm1p2_svt_lp L=6e-08 W=1.5e-07
MI23_MXPA1 bclk nclk VDD VDD pm1p2_svt_lp L=6e-08 W=1.9e-07
MI33_MXPOEN nm bclk nin VDD pm1p2_svt_lp L=6e-08 W=1.5e-07
MI31_MXPOEN nm nclk XI31_p1 VDD pm1p2_svt_lp L=6e-08 W=1.5e-07
MI31_MXPA1 XI31_p1 m VDD VDD pm1p2_svt_lp L=6e-08 W=1.5e-07
MI32_MXPA1 m nm VDD VDD pm1p2_svt_lp L=6e-08 W=1.9e-07
MI20_MXPOEN s nclk m VDD pm1p2_svt_lp L=6e-08 W=1.5e-07
MI69_MXPOEN s bclk XI69_p1 VDD pm1p2_svt_lp L=6e-08 W=1.5e-07
MI69_MXPA1 XI69_p1 ns VDD VDD pm1p2_svt_lp L=6e-08 W=1.5e-07
MI28_MXPA1 ns s VDD VDD pm1p2_svt_lp L=6e-08 W=1.2e-07
MI22_MXPA1 nclk CK VDD VDD pm1p2_svt_lp L=6e-08 W=1.7e-07
MI75_MXPA1 QN s VDD VDD pm1p2_svt_lp L=6e-08 W=2.95e-07
.ENDS

.SUBCKT ADFFQNX1H9R QN VDD VSS A B CK
MI0_MXNA1 nin A XI0_n1 VSS nm1p2_svt_lp L=6e-08 W=3.9e-07
MI0_MXNA2 XI0_n1 B VSS VSS nm1p2_svt_lp L=6e-08 W=3.9e-07
MI23_MXNA1 bclk nclk VSS VSS nm1p2_svt_lp L=6e-08 W=1.5e-07
MI33_MXNOE nm nclk nin VSS nm1p2_svt_lp L=6e-08 W=2.6e-07
MI31_MXNOE nm bclk XI31_n1 VSS nm1p2_svt_lp L=6e-08 W=1.5e-07
MI31_MXNA1 XI31_n1 m VSS VSS nm1p2_svt_lp L=6e-08 W=1.5e-07
MI32_MXNA1 m nm VSS VSS nm1p2_svt_lp L=6e-08 W=2e-07
MI20_MXNOE s bclk m VSS nm1p2_svt_lp L=6e-08 W=2.6e-07
MI69_MXNOE s nclk XI69_n1 VSS nm1p2_svt_lp L=6e-08 W=1.5e-07
MI69_MXNA1 XI69_n1 ns VSS VSS nm1p2_svt_lp L=6e-08 W=1.5e-07
MI28_MXNA1 ns s VSS VSS nm1p2_svt_lp L=6e-08 W=1.2e-07
MI75_MXNA1 QN s VSS VSS nm1p2_svt_lp L=6e-08 W=4.2e-07
MI22_MXNA1 nclk CK VSS VSS nm1p2_svt_lp L=6e-08 W=1.7e-07
MI0_MXPA1 nin A VDD VDD pm1p2_svt_lp L=6e-08 W=2.1e-07
MI0_MXPA2 nin B VDD VDD pm1p2_svt_lp L=6e-08 W=2.1e-07
MI23_MXPA1 bclk nclk VDD VDD pm1p2_svt_lp L=6e-08 W=3e-07
MI33_MXPOEN nm bclk nin VDD pm1p2_svt_lp L=6e-08 W=2.6e-07
MI31_MXPOEN nm nclk XI31_p1 VDD pm1p2_svt_lp L=6e-08 W=1.5e-07
MI31_MXPA1 XI31_p1 m VDD VDD pm1p2_svt_lp L=6e-08 W=1.5e-07
MI32_MXPA1 m nm VDD VDD pm1p2_svt_lp L=6e-08 W=2.8e-07
MI20_MXPOEN s nclk m VDD pm1p2_svt_lp L=6e-08 W=2.6e-07
MI69_MXPOEN s bclk XI69_p1 VDD pm1p2_svt_lp L=6e-08 W=1.5e-07
MI69_MXPA1 XI69_p1 ns VDD VDD pm1p2_svt_lp L=6e-08 W=1.5e-07
MI28_MXPA1 ns s VDD VDD pm1p2_svt_lp L=6e-08 W=1.2e-07
MI75_MXPA1 QN s VDD VDD pm1p2_svt_lp L=6e-08 W=5.85e-07
MI22_MXPA1 nclk CK VDD VDD pm1p2_svt_lp L=6e-08 W=1.9e-07
.ENDS

.SUBCKT ADFFQNX2H9R QN VDD VSS A B CK
MI0_MXNA1 nin A XI0_n1 VSS nm1p2_svt_lp L=6e-08 W=4.4e-07
MI0_MXNA2 XI0_n1 B VSS VSS nm1p2_svt_lp L=6e-08 W=4.4e-07
MI23_MXNA1 bclk nclk VSS VSS nm1p2_svt_lp L=6e-08 W=1.7e-07
MI33_MXNOE nm nclk nin VSS nm1p2_svt_lp L=6e-08 W=3.2e-07
MI31_MXNOE nm bclk XI31_n1 VSS nm1p2_svt_lp L=6e-08 W=1.5e-07
MI31_MXNA1 XI31_n1 m VSS VSS nm1p2_svt_lp L=6e-08 W=1.5e-07
MI32_MXNA1 m nm VSS VSS nm1p2_svt_lp L=6e-08 W=2.5e-07
MI20_MXNOE s bclk m VSS nm1p2_svt_lp L=6e-08 W=3.2e-07
MI69_MXNOE s nclk XI69_n1 VSS nm1p2_svt_lp L=6e-08 W=1.5e-07
MI69_MXNA1 XI69_n1 ns VSS VSS nm1p2_svt_lp L=6e-08 W=1.5e-07
MI28_MXNA1 ns s VSS VSS nm1p2_svt_lp L=6e-08 W=1.2e-07
MI75_MXNA1 QN s VSS VSS nm1p2_svt_lp L=6e-08 W=4.2e-07
MI75_MXNA1_2 QN s VSS VSS nm1p2_svt_lp L=6e-08 W=4.2e-07
MI22_MXNA1 nclk CK VSS VSS nm1p2_svt_lp L=6e-08 W=2.1e-07
MI0_MXPA1 nin A VDD VDD pm1p2_svt_lp L=6e-08 W=2.5e-07
MI0_MXPA2 nin B VDD VDD pm1p2_svt_lp L=6e-08 W=2.5e-07
MI23_MXPA1 bclk nclk VDD VDD pm1p2_svt_lp L=6e-08 W=3.3e-07
MI33_MXPOEN nm bclk nin VDD pm1p2_svt_lp L=6e-08 W=3.2e-07
MI31_MXPOEN nm nclk XI31_p1 VDD pm1p2_svt_lp L=6e-08 W=1.5e-07
MI31_MXPA1 XI31_p1 m VDD VDD pm1p2_svt_lp L=6e-08 W=1.5e-07
MI32_MXPA1 m nm VDD VDD pm1p2_svt_lp L=6e-08 W=3.9e-07
MI20_MXPOEN s nclk m VDD pm1p2_svt_lp L=6e-08 W=3.2e-07
MI69_MXPOEN s bclk XI69_p1 VDD pm1p2_svt_lp L=6e-08 W=1.5e-07
MI69_MXPA1 XI69_p1 ns VDD VDD pm1p2_svt_lp L=6e-08 W=1.5e-07
MI28_MXPA1 ns s VDD VDD pm1p2_svt_lp L=6e-08 W=1.2e-07
MI75_MXPA1 QN s VDD VDD pm1p2_svt_lp L=6e-08 W=5.85e-07
MI75_MXPA1_2 QN s VDD VDD pm1p2_svt_lp L=6e-08 W=5.85e-07
MI22_MXPA1 nclk CK VDD VDD pm1p2_svt_lp L=6e-08 W=2.3e-07
.ENDS

.SUBCKT ADFFQNX3H9R QN VDD VSS A B CK
MI0_MXNA1 nin A XI0_n1 VSS nm1p2_svt_lp L=6e-08 W=4e-07
MI0_MXNA2 XI0_n1 B VSS VSS nm1p2_svt_lp L=6e-08 W=4e-07
MI23_MXNA1 bclk nclk VSS VSS nm1p2_svt_lp L=6e-08 W=1.8e-07
MI33_MXNOE nm nclk nin VSS nm1p2_svt_lp L=6e-08 W=3.9e-07
MI31_MXNOE nm bclk XI31_n1 VSS nm1p2_svt_lp L=6e-08 W=1.5e-07
MI31_MXNA1 XI31_n1 m VSS VSS nm1p2_svt_lp L=6e-08 W=1.5e-07
MI32_MXNA1 m nm VSS VSS nm1p2_svt_lp L=6e-08 W=3.4e-07
MI20_MXNOE s bclk m VSS nm1p2_svt_lp L=6e-08 W=3.9e-07
MI69_MXNOE s nclk XI69_n1 VSS nm1p2_svt_lp L=6e-08 W=1.5e-07
MI69_MXNA1 XI69_n1 ns VSS VSS nm1p2_svt_lp L=6e-08 W=1.5e-07
MI28_MXNA1 ns s VSS VSS nm1p2_svt_lp L=6e-08 W=1.2e-07
MI75_MXNA1 QN s VSS VSS nm1p2_svt_lp L=6e-08 W=4.35e-07
MI75_MXNA1_2 QN s VSS VSS nm1p2_svt_lp L=6e-08 W=4.35e-07
MI75_MXNA1_3 QN s VSS VSS nm1p2_svt_lp L=6e-08 W=4.3e-07
MI22_MXNA1 nclk CK VSS VSS nm1p2_svt_lp L=6e-08 W=2.2e-07
MI0_MXPA1 nin A VDD VDD pm1p2_svt_lp L=6e-08 W=2.5e-07
MI0_MXPA2 nin B VDD VDD pm1p2_svt_lp L=6e-08 W=2.5e-07
MI23_MXPA1 bclk nclk VDD VDD pm1p2_svt_lp L=6e-08 W=3.6e-07
MI33_MXPOEN nm bclk nin VDD pm1p2_svt_lp L=6e-08 W=3.9e-07
MI31_MXPOEN nm nclk XI31_p1 VDD pm1p2_svt_lp L=6e-08 W=1.5e-07
MI31_MXPA1 XI31_p1 m VDD VDD pm1p2_svt_lp L=6e-08 W=1.5e-07
MI32_MXPA1 m nm VDD VDD pm1p2_svt_lp L=6e-08 W=5.85e-07
MI20_MXPOEN s nclk m VDD pm1p2_svt_lp L=6e-08 W=3.9e-07
MI69_MXPOEN s bclk XI69_p1 VDD pm1p2_svt_lp L=6e-08 W=1.5e-07
MI69_MXPA1 XI69_p1 ns VDD VDD pm1p2_svt_lp L=6e-08 W=1.5e-07
MI28_MXPA1 ns s VDD VDD pm1p2_svt_lp L=6e-08 W=1.2e-07
MI75_MXPA1 QN s VDD VDD pm1p2_svt_lp L=6e-08 W=5.85e-07
MI75_MXPA1_2 QN s VDD VDD pm1p2_svt_lp L=6e-08 W=5.85e-07
MI75_MXPA1_3 QN s VDD VDD pm1p2_svt_lp L=6e-08 W=5.85e-07
MI22_MXPA1 nclk CK VDD VDD pm1p2_svt_lp L=6e-08 W=2.4e-07
.ENDS

.SUBCKT EDFFQX0P5H9R Q VDD VSS CK D E
MI70_MXNA1 ne E VSS VSS nm1p2_svt_lp L=6e-08 W=2.5e-07
MI112_MXNA1 nd D VSS VSS nm1p2_svt_lp L=6e-08 W=1.5e-07
MI110_MXNOE nenmux E nd VSS nm1p2_svt_lp L=6e-08 W=1.5e-07
MI99_MXNOE nenmux ne nfb VSS nm1p2_svt_lp L=6e-08 W=1.5e-07
MI93_MXNA1 semux nenmux VSS VSS nm1p2_svt_lp L=6e-08 W=2e-07
MI33_MXNOE m nclk semux VSS nm1p2_svt_lp L=6e-08 W=1.5e-07
MI31_MXNOE m bclk XI31_n1 VSS nm1p2_svt_lp L=6e-08 W=1.5e-07
MI31_MXNA1 XI31_n1 nm VSS VSS nm1p2_svt_lp L=6e-08 W=1.5e-07
MI32_MXNA1 nm m VSS VSS nm1p2_svt_lp L=6e-08 W=1.5e-07
MI20_MXNOE ns bclk nm VSS nm1p2_svt_lp L=6e-08 W=1.5e-07
MI68_MXNOE ns nclk XI68_n1 VSS nm1p2_svt_lp L=6e-08 W=1.5e-07
MI68_MXNA1 XI68_n1 s VSS VSS nm1p2_svt_lp L=6e-08 W=1.5e-07
MI103_MXNA1 nfb s VSS VSS nm1p2_svt_lp L=6e-08 W=1.5e-07
MI28_MXNA1 s ns VSS VSS nm1p2_svt_lp L=6e-08 W=1.2e-07
MI75_MXNA1 Q ns VSS VSS nm1p2_svt_lp L=6e-08 W=2.1e-07
MI23_MXNA1 bclk nclk VSS VSS nm1p2_svt_lp L=6e-08 W=1.5e-07
MI22_MXNA1 nclk CK VSS VSS nm1p2_svt_lp L=6e-08 W=1.5e-07
MI70_MXPA1 ne E VDD VDD pm1p2_svt_lp L=6e-08 W=3.55e-07
MI112_MXPA1 nd D VDD VDD pm1p2_svt_lp L=6e-08 W=3e-07
MI110_MXPOEN nenmux ne nd VDD pm1p2_svt_lp L=6e-08 W=2.5e-07
MI99_MXPOEN nenmux E nfb VDD pm1p2_svt_lp L=6e-08 W=2.5e-07
MI93_MXPA1 semux nenmux VDD VDD pm1p2_svt_lp L=6e-08 W=2e-07
MI33_MXPOEN m bclk semux VDD pm1p2_svt_lp L=6e-08 W=1.5e-07
MI31_MXPOEN m nclk XI31_p1 VDD pm1p2_svt_lp L=6e-08 W=1.5e-07
MI31_MXPA1 XI31_p1 nm VDD VDD pm1p2_svt_lp L=6e-08 W=1.5e-07
MI32_MXPA1 nm m VDD VDD pm1p2_svt_lp L=6e-08 W=1.7e-07
MI20_MXPOEN ns nclk nm VDD pm1p2_svt_lp L=6e-08 W=1.5e-07
MI68_MXPOEN ns bclk XI68_p1 VDD pm1p2_svt_lp L=6e-08 W=1.5e-07
MI68_MXPA1 XI68_p1 s VDD VDD pm1p2_svt_lp L=6e-08 W=1.5e-07
MI103_MXPA1 nfb s VDD VDD pm1p2_svt_lp L=6e-08 W=3e-07
MI28_MXPA1 s ns VDD VDD pm1p2_svt_lp L=6e-08 W=1.2e-07
MI75_MXPA1 Q ns VDD VDD pm1p2_svt_lp L=6e-08 W=2.95e-07
MI23_MXPA1 bclk nclk VDD VDD pm1p2_svt_lp L=6e-08 W=1.9e-07
MI22_MXPA1 nclk CK VDD VDD pm1p2_svt_lp L=6e-08 W=1.7e-07
.ENDS

.SUBCKT EDFFQX1H9R Q VDD VSS CK D E
MI70_MXNA1 ne E VSS VSS nm1p2_svt_lp L=6e-08 W=3e-07
MI112_MXNA1 nd D VSS VSS nm1p2_svt_lp L=6e-08 W=2.6e-07
MI110_MXNOE nenmux E nd VSS nm1p2_svt_lp L=6e-08 W=2.6e-07
MI99_MXNOE nenmux ne nfb VSS nm1p2_svt_lp L=6e-08 W=2.6e-07
MI93_MXNA1 semux nenmux VSS VSS nm1p2_svt_lp L=6e-08 W=2.6e-07
MI33_MXNOE m nclk semux VSS nm1p2_svt_lp L=6e-08 W=2.6e-07
MI31_MXNOE m bclk XI31_n1 VSS nm1p2_svt_lp L=6e-08 W=1.5e-07
MI31_MXNA1 XI31_n1 nm VSS VSS nm1p2_svt_lp L=6e-08 W=1.5e-07
MI32_MXNA1 nm m VSS VSS nm1p2_svt_lp L=6e-08 W=2.2e-07
MI20_MXNOE ns bclk nm VSS nm1p2_svt_lp L=6e-08 W=2.6e-07
MI68_MXNOE ns nclk XI68_n1 VSS nm1p2_svt_lp L=6e-08 W=1.5e-07
MI68_MXNA1 XI68_n1 s VSS VSS nm1p2_svt_lp L=6e-08 W=1.5e-07
MI103_MXNA1 nfb s VSS VSS nm1p2_svt_lp L=6e-08 W=2.6e-07
MI28_MXNA1 s ns VSS VSS nm1p2_svt_lp L=6e-08 W=1.2e-07
MI75_MXNA1 Q ns VSS VSS nm1p2_svt_lp L=6e-08 W=4.2e-07
MI23_MXNA1 bclk nclk VSS VSS nm1p2_svt_lp L=6e-08 W=1.5e-07
MI22_MXNA1 nclk CK VSS VSS nm1p2_svt_lp L=6e-08 W=1.7e-07
MI70_MXPA1 ne E VDD VDD pm1p2_svt_lp L=6e-08 W=4.2e-07
MI112_MXPA1 nd D VDD VDD pm1p2_svt_lp L=6e-08 W=5.3e-07
MI110_MXPOEN nenmux ne nd VDD pm1p2_svt_lp L=6e-08 W=3.2e-07
MI99_MXPOEN nenmux E nfb VDD pm1p2_svt_lp L=6e-08 W=3.2e-07
MI93_MXPA1 semux nenmux VDD VDD pm1p2_svt_lp L=6e-08 W=2.6e-07
MI33_MXPOEN m bclk semux VDD pm1p2_svt_lp L=6e-08 W=2.6e-07
MI31_MXPOEN m nclk XI31_p1 VDD pm1p2_svt_lp L=6e-08 W=1.5e-07
MI31_MXPA1 XI31_p1 nm VDD VDD pm1p2_svt_lp L=6e-08 W=1.5e-07
MI32_MXPA1 nm m VDD VDD pm1p2_svt_lp L=6e-08 W=3.1e-07
MI20_MXPOEN ns nclk nm VDD pm1p2_svt_lp L=6e-08 W=2.6e-07
MI68_MXPOEN ns bclk XI68_p1 VDD pm1p2_svt_lp L=6e-08 W=1.5e-07
MI68_MXPA1 XI68_p1 s VDD VDD pm1p2_svt_lp L=6e-08 W=1.5e-07
MI103_MXPA1 nfb s VDD VDD pm1p2_svt_lp L=6e-08 W=5.3e-07
MI28_MXPA1 s ns VDD VDD pm1p2_svt_lp L=6e-08 W=1.2e-07
MI75_MXPA1 Q ns VDD VDD pm1p2_svt_lp L=6e-08 W=5.85e-07
MI23_MXPA1 bclk nclk VDD VDD pm1p2_svt_lp L=6e-08 W=3e-07
MI22_MXPA1 nclk CK VDD VDD pm1p2_svt_lp L=6e-08 W=1.9e-07
.ENDS

.SUBCKT EDFFQX2H9R Q VDD VSS CK D E
MI70_MXNA1 ne E VSS VSS nm1p2_svt_lp L=6e-08 W=3.3e-07
MI112_MXNA1 nd D VSS VSS nm1p2_svt_lp L=6e-08 W=2.6e-07
MI110_MXNOE nenmux E nd VSS nm1p2_svt_lp L=6e-08 W=2.6e-07
MI99_MXNOE nenmux ne nfb VSS nm1p2_svt_lp L=6e-08 W=2.6e-07
MI93_MXNA1 semux nenmux VSS VSS nm1p2_svt_lp L=6e-08 W=3.2e-07
MI33_MXNOE m nclk semux VSS nm1p2_svt_lp L=6e-08 W=3.2e-07
MI31_MXNOE m bclk XI31_n1 VSS nm1p2_svt_lp L=6e-08 W=1.5e-07
MI31_MXNA1 XI31_n1 nm VSS VSS nm1p2_svt_lp L=6e-08 W=1.5e-07
MI32_MXNA1 nm m VSS VSS nm1p2_svt_lp L=6e-08 W=2.8e-07
MI20_MXNOE ns bclk nm VSS nm1p2_svt_lp L=6e-08 W=3.2e-07
MI68_MXNOE ns nclk XI68_n1 VSS nm1p2_svt_lp L=6e-08 W=1.5e-07
MI68_MXNA1 XI68_n1 s VSS VSS nm1p2_svt_lp L=6e-08 W=1.5e-07
MI103_MXNA1 nfb s VSS VSS nm1p2_svt_lp L=6e-08 W=2.6e-07
MI28_MXNA1 s ns VSS VSS nm1p2_svt_lp L=6e-08 W=1.2e-07
MI75_MXNA1 Q ns VSS VSS nm1p2_svt_lp L=6e-08 W=4.2e-07
MI75_MXNA1_2 Q ns VSS VSS nm1p2_svt_lp L=6e-08 W=4.2e-07
MI23_MXNA1 bclk nclk VSS VSS nm1p2_svt_lp L=6e-08 W=1.7e-07
MI22_MXNA1 nclk CK VSS VSS nm1p2_svt_lp L=6e-08 W=2.1e-07
MI70_MXPA1 ne E VDD VDD pm1p2_svt_lp L=6e-08 W=4.65e-07
MI112_MXPA1 nd D VDD VDD pm1p2_svt_lp L=6e-08 W=5.2e-07
MI110_MXPOEN nenmux ne nd VDD pm1p2_svt_lp L=6e-08 W=3.8e-07
MI99_MXPOEN nenmux E nfb VDD pm1p2_svt_lp L=6e-08 W=3.8e-07
MI93_MXPA1 semux nenmux VDD VDD pm1p2_svt_lp L=6e-08 W=3.2e-07
MI33_MXPOEN m bclk semux VDD pm1p2_svt_lp L=6e-08 W=3.2e-07
MI31_MXPOEN m nclk XI31_p1 VDD pm1p2_svt_lp L=6e-08 W=1.5e-07
MI31_MXPA1 XI31_p1 nm VDD VDD pm1p2_svt_lp L=6e-08 W=1.5e-07
MI32_MXPA1 nm m VDD VDD pm1p2_svt_lp L=6e-08 W=4e-07
MI20_MXPOEN ns nclk nm VDD pm1p2_svt_lp L=6e-08 W=3.2e-07
MI68_MXPOEN ns bclk XI68_p1 VDD pm1p2_svt_lp L=6e-08 W=1.5e-07
MI68_MXPA1 XI68_p1 s VDD VDD pm1p2_svt_lp L=6e-08 W=1.5e-07
MI103_MXPA1 nfb s VDD VDD pm1p2_svt_lp L=6e-08 W=5.2e-07
MI28_MXPA1 s ns VDD VDD pm1p2_svt_lp L=6e-08 W=1.2e-07
MI75_MXPA1 Q ns VDD VDD pm1p2_svt_lp L=6e-08 W=5.85e-07
MI75_MXPA1_2 Q ns VDD VDD pm1p2_svt_lp L=6e-08 W=5.85e-07
MI23_MXPA1 bclk nclk VDD VDD pm1p2_svt_lp L=6e-08 W=3.3e-07
MI22_MXPA1 nclk CK VDD VDD pm1p2_svt_lp L=6e-08 W=2.3e-07
.ENDS

.SUBCKT EDFFQX3H9R Q VDD VSS CK D E
MI70_MXNA1 ne E VSS VSS nm1p2_svt_lp L=6e-08 W=3.7e-07
MI112_MXNA1 nd D VSS VSS nm1p2_svt_lp L=6e-08 W=3e-07
MI110_MXNOE nenmux E nd VSS nm1p2_svt_lp L=6e-08 W=3e-07
MI99_MXNOE nenmux ne nfb VSS nm1p2_svt_lp L=6e-08 W=3e-07
MI93_MXNA1 semux nenmux VSS VSS nm1p2_svt_lp L=6e-08 W=3.9e-07
MI33_MXNOE m nclk semux VSS nm1p2_svt_lp L=6e-08 W=3.9e-07
MI31_MXNOE m bclk XI31_n1 VSS nm1p2_svt_lp L=6e-08 W=1.5e-07
MI31_MXNA1 XI31_n1 nm VSS VSS nm1p2_svt_lp L=6e-08 W=1.5e-07
MI32_MXNA1 nm m VSS VSS nm1p2_svt_lp L=6e-08 W=2.8e-07
MI20_MXNOE ns bclk nm VSS nm1p2_svt_lp L=6e-08 W=3.9e-07
MI68_MXNOE ns nclk XI68_n1 VSS nm1p2_svt_lp L=6e-08 W=1.5e-07
MI68_MXNA1 XI68_n1 s VSS VSS nm1p2_svt_lp L=6e-08 W=1.5e-07
MI103_MXNA1 nfb s VSS VSS nm1p2_svt_lp L=6e-08 W=3e-07
MI28_MXNA1 s ns VSS VSS nm1p2_svt_lp L=6e-08 W=1.2e-07
MI75_MXNA1 Q ns VSS VSS nm1p2_svt_lp L=6e-08 W=4.2e-07
MI75_MXNA1_2 Q ns VSS VSS nm1p2_svt_lp L=6e-08 W=4.2e-07
MI75_MXNA1_3 Q ns VSS VSS nm1p2_svt_lp L=6e-08 W=4.2e-07
MI23_MXNA1 bclk nclk VSS VSS nm1p2_svt_lp L=6e-08 W=1.8e-07
MI22_MXNA1 nclk CK VSS VSS nm1p2_svt_lp L=6e-08 W=2.2e-07
MI70_MXPA1 ne E VDD VDD pm1p2_svt_lp L=6e-08 W=5.2e-07
MI112_MXPA1 nd D VDD VDD pm1p2_svt_lp L=6e-08 W=5.5e-07
MI110_MXPOEN nenmux ne nd VDD pm1p2_svt_lp L=6e-08 W=4.5e-07
MI99_MXPOEN nenmux E nfb VDD pm1p2_svt_lp L=6e-08 W=4.5e-07
MI93_MXPA1 semux nenmux VDD VDD pm1p2_svt_lp L=6e-08 W=3.9e-07
MI33_MXPOEN m bclk semux VDD pm1p2_svt_lp L=6e-08 W=3.9e-07
MI31_MXPOEN m nclk XI31_p1 VDD pm1p2_svt_lp L=6e-08 W=1.5e-07
MI31_MXPA1 XI31_p1 nm VDD VDD pm1p2_svt_lp L=6e-08 W=1.5e-07
MI32_MXPA1 nm m VDD VDD pm1p2_svt_lp L=6e-08 W=5.1e-07
MI20_MXPOEN ns nclk nm VDD pm1p2_svt_lp L=6e-08 W=3.9e-07
MI68_MXPOEN ns bclk XI68_p1 VDD pm1p2_svt_lp L=6e-08 W=1.5e-07
MI68_MXPA1 XI68_p1 s VDD VDD pm1p2_svt_lp L=6e-08 W=1.5e-07
MI103_MXPA1 nfb s VDD VDD pm1p2_svt_lp L=6e-08 W=5.5e-07
MI28_MXPA1 s ns VDD VDD pm1p2_svt_lp L=6e-08 W=1.2e-07
MI75_MXPA1 Q ns VDD VDD pm1p2_svt_lp L=6e-08 W=5.85e-07
MI75_MXPA1_2 Q ns VDD VDD pm1p2_svt_lp L=6e-08 W=5.85e-07
MI75_MXPA1_3 Q ns VDD VDD pm1p2_svt_lp L=6e-08 W=5.85e-07
MI23_MXPA1 bclk nclk VDD VDD pm1p2_svt_lp L=6e-08 W=3.6e-07
MI22_MXPA1 nclk CK VDD VDD pm1p2_svt_lp L=6e-08 W=2.4e-07
.ENDS

.SUBCKT EDFFQNX0P5H9R QN VDD VSS CK D E
MI70_MXNA1 ne E VSS VSS nm1p2_svt_lp L=6e-08 W=2.5e-07
MI112_MXNA1 nd D VSS VSS nm1p2_svt_lp L=6e-08 W=2e-07
MI110_MXNOE nenmux E nd VSS nm1p2_svt_lp L=6e-08 W=2e-07
MI99_MXNOE nenmux ne nfb VSS nm1p2_svt_lp L=6e-08 W=2e-07
MI93_MXNA1 semux nenmux VSS VSS nm1p2_svt_lp L=6e-08 W=2e-07
MI33_MXNOE m nclk semux VSS nm1p2_svt_lp L=6e-08 W=1.5e-07
MI31_MXNOE m bclk XI31_n1 VSS nm1p2_svt_lp L=6e-08 W=1.5e-07
MI31_MXNA1 XI31_n1 nm VSS VSS nm1p2_svt_lp L=6e-08 W=1.5e-07
MI32_MXNA1 nm m VSS VSS nm1p2_svt_lp L=6e-08 W=1.5e-07
MI20_MXNOE ns bclk nm VSS nm1p2_svt_lp L=6e-08 W=1.5e-07
MI29_MXNOE ns nclk XI29_n1 VSS nm1p2_svt_lp L=6e-08 W=1.5e-07
MI29_MXNA1 XI29_n1 s VSS VSS nm1p2_svt_lp L=6e-08 W=1.5e-07
MI28_MXNA1 s ns VSS VSS nm1p2_svt_lp L=6e-08 W=1.5e-07
MI103_MXNA1 nfb s VSS VSS nm1p2_svt_lp L=6e-08 W=2e-07
MI75_MXNA1 QN s VSS VSS nm1p2_svt_lp L=6e-08 W=2.1e-07
MI23_MXNA1 bclk nclk VSS VSS nm1p2_svt_lp L=6e-08 W=1.5e-07
MI22_MXNA1 nclk CK VSS VSS nm1p2_svt_lp L=6e-08 W=1.5e-07
MI70_MXPA1 ne E VDD VDD pm1p2_svt_lp L=6e-08 W=3.5e-07
MI112_MXPA1 nd D VDD VDD pm1p2_svt_lp L=6e-08 W=4.4e-07
MI110_MXPOEN nenmux ne nd VDD pm1p2_svt_lp L=6e-08 W=2.7e-07
MI99_MXPOEN nenmux E nfb VDD pm1p2_svt_lp L=6e-08 W=2.7e-07
MI93_MXPA1 semux nenmux VDD VDD pm1p2_svt_lp L=6e-08 W=2e-07
MI33_MXPOEN m bclk semux VDD pm1p2_svt_lp L=6e-08 W=1.5e-07
MI31_MXPOEN m nclk XI31_p1 VDD pm1p2_svt_lp L=6e-08 W=1.5e-07
MI31_MXPA1 XI31_p1 nm VDD VDD pm1p2_svt_lp L=6e-08 W=1.5e-07
MI32_MXPA1 nm m VDD VDD pm1p2_svt_lp L=6e-08 W=1.6e-07
MI20_MXPOEN ns nclk nm VDD pm1p2_svt_lp L=6e-08 W=1.5e-07
MI29_MXPOEN ns bclk XI29_p1 VDD pm1p2_svt_lp L=6e-08 W=1.5e-07
MI29_MXPA1 XI29_p1 s VDD VDD pm1p2_svt_lp L=6e-08 W=1.5e-07
MI28_MXPA1 s ns VDD VDD pm1p2_svt_lp L=6e-08 W=2.4e-07
MI103_MXPA1 nfb s VDD VDD pm1p2_svt_lp L=6e-08 W=4.4e-07
MI75_MXPA1 QN s VDD VDD pm1p2_svt_lp L=6e-08 W=2.95e-07
MI23_MXPA1 bclk nclk VDD VDD pm1p2_svt_lp L=6e-08 W=1.9e-07
MI22_MXPA1 nclk CK VDD VDD pm1p2_svt_lp L=6e-08 W=1.7e-07
.ENDS

.SUBCKT EDFFQNX1H9R QN VDD VSS CK D E
MI70_MXNA1 ne E VSS VSS nm1p2_svt_lp L=6e-08 W=2.9e-07
MI112_MXNA1 nd D VSS VSS nm1p2_svt_lp L=6e-08 W=2e-07
MI110_MXNOE nenmux E nd VSS nm1p2_svt_lp L=6e-08 W=2e-07
MI99_MXNOE nenmux ne nfb VSS nm1p2_svt_lp L=6e-08 W=2e-07
MI93_MXNA1 semux nenmux VSS VSS nm1p2_svt_lp L=6e-08 W=2.4e-07
MI33_MXNOE m nclk semux VSS nm1p2_svt_lp L=6e-08 W=2.6e-07
MI31_MXNOE m bclk XI31_n1 VSS nm1p2_svt_lp L=6e-08 W=1.5e-07
MI31_MXNA1 XI31_n1 nm VSS VSS nm1p2_svt_lp L=6e-08 W=1.5e-07
MI32_MXNA1 nm m VSS VSS nm1p2_svt_lp L=6e-08 W=2.2e-07
MI20_MXNOE ns bclk nm VSS nm1p2_svt_lp L=6e-08 W=2.6e-07
MI29_MXNOE ns nclk XI29_n1 VSS nm1p2_svt_lp L=6e-08 W=1.5e-07
MI29_MXNA1 XI29_n1 s VSS VSS nm1p2_svt_lp L=6e-08 W=1.5e-07
MI28_MXNA1 s ns VSS VSS nm1p2_svt_lp L=6e-08 W=1.9e-07
MI103_MXNA1 nfb s VSS VSS nm1p2_svt_lp L=6e-08 W=2e-07
MI75_MXNA1 QN s VSS VSS nm1p2_svt_lp L=6e-08 W=4.2e-07
MI23_MXNA1 bclk nclk VSS VSS nm1p2_svt_lp L=6e-08 W=1.5e-07
MI22_MXNA1 nclk CK VSS VSS nm1p2_svt_lp L=6e-08 W=1.7e-07
MI70_MXPA1 ne E VDD VDD pm1p2_svt_lp L=6e-08 W=4.1e-07
MI112_MXPA1 nd D VDD VDD pm1p2_svt_lp L=6e-08 W=4.8e-07
MI110_MXPOEN nenmux ne nd VDD pm1p2_svt_lp L=6e-08 W=3.4e-07
MI99_MXPOEN nenmux E nfb VDD pm1p2_svt_lp L=6e-08 W=3.4e-07
MI93_MXPA1 semux nenmux VDD VDD pm1p2_svt_lp L=6e-08 W=3e-07
MI33_MXPOEN m bclk semux VDD pm1p2_svt_lp L=6e-08 W=2.6e-07
MI31_MXPOEN m nclk XI31_p1 VDD pm1p2_svt_lp L=6e-08 W=1.5e-07
MI31_MXPA1 XI31_p1 nm VDD VDD pm1p2_svt_lp L=6e-08 W=1.5e-07
MI32_MXPA1 nm m VDD VDD pm1p2_svt_lp L=6e-08 W=3.4e-07
MI20_MXPOEN ns nclk nm VDD pm1p2_svt_lp L=6e-08 W=2.6e-07
MI29_MXPOEN ns bclk XI29_p1 VDD pm1p2_svt_lp L=6e-08 W=1.5e-07
MI29_MXPA1 XI29_p1 s VDD VDD pm1p2_svt_lp L=6e-08 W=1.5e-07
MI28_MXPA1 s ns VDD VDD pm1p2_svt_lp L=6e-08 W=3.5e-07
MI103_MXPA1 nfb s VDD VDD pm1p2_svt_lp L=6e-08 W=4.8e-07
MI75_MXPA1 QN s VDD VDD pm1p2_svt_lp L=6e-08 W=5.85e-07
MI23_MXPA1 bclk nclk VDD VDD pm1p2_svt_lp L=6e-08 W=3e-07
MI22_MXPA1 nclk CK VDD VDD pm1p2_svt_lp L=6e-08 W=1.9e-07
.ENDS

.SUBCKT EDFFQNX2H9R QN VDD VSS CK D E
MI70_MXNA1 ne E VSS VSS nm1p2_svt_lp L=6e-08 W=3.3e-07
MI112_MXNA1 nd D VSS VSS nm1p2_svt_lp L=6e-08 W=2.6e-07
MI110_MXNOE nenmux E nd VSS nm1p2_svt_lp L=6e-08 W=2.6e-07
MI99_MXNOE nenmux ne nfb VSS nm1p2_svt_lp L=6e-08 W=2.6e-07
MI93_MXNA1 semux nenmux VSS VSS nm1p2_svt_lp L=6e-08 W=3.2e-07
MI33_MXNOE m nclk semux VSS nm1p2_svt_lp L=6e-08 W=3.2e-07
MI31_MXNOE m bclk XI31_n1 VSS nm1p2_svt_lp L=6e-08 W=1.5e-07
MI31_MXNA1 XI31_n1 nm VSS VSS nm1p2_svt_lp L=6e-08 W=1.5e-07
MI32_MXNA1 nm m VSS VSS nm1p2_svt_lp L=6e-08 W=2.9e-07
MI20_MXNOE ns bclk nm VSS nm1p2_svt_lp L=6e-08 W=3.2e-07
MI29_MXNOE ns nclk XI29_n1 VSS nm1p2_svt_lp L=6e-08 W=1.5e-07
MI29_MXNA1 XI29_n1 s VSS VSS nm1p2_svt_lp L=6e-08 W=1.5e-07
MI28_MXNA1 s ns VSS VSS nm1p2_svt_lp L=6e-08 W=2.4e-07
MI103_MXNA1 nfb s VSS VSS nm1p2_svt_lp L=6e-08 W=2.6e-07
MI75_MXNA1 QN s VSS VSS nm1p2_svt_lp L=6e-08 W=4.2e-07
MI75_MXNA1_2 QN s VSS VSS nm1p2_svt_lp L=6e-08 W=4.2e-07
MI23_MXNA1 bclk nclk VSS VSS nm1p2_svt_lp L=6e-08 W=1.7e-07
MI22_MXNA1 nclk CK VSS VSS nm1p2_svt_lp L=6e-08 W=2.1e-07
MI70_MXPA1 ne E VDD VDD pm1p2_svt_lp L=6e-08 W=4.65e-07
MI112_MXPA1 nd D VDD VDD pm1p2_svt_lp L=6e-08 W=5.3e-07
MI110_MXPOEN nenmux ne nd VDD pm1p2_svt_lp L=6e-08 W=3.9e-07
MI99_MXPOEN nenmux E nfb VDD pm1p2_svt_lp L=6e-08 W=3.9e-07
MI93_MXPA1 semux nenmux VDD VDD pm1p2_svt_lp L=6e-08 W=3.2e-07
MI33_MXPOEN m bclk semux VDD pm1p2_svt_lp L=6e-08 W=3.2e-07
MI31_MXPOEN m nclk XI31_p1 VDD pm1p2_svt_lp L=6e-08 W=1.5e-07
MI31_MXPA1 XI31_p1 nm VDD VDD pm1p2_svt_lp L=6e-08 W=1.5e-07
MI32_MXPA1 nm m VDD VDD pm1p2_svt_lp L=6e-08 W=4.4e-07
MI20_MXPOEN ns nclk nm VDD pm1p2_svt_lp L=6e-08 W=3.2e-07
MI29_MXPOEN ns bclk XI29_p1 VDD pm1p2_svt_lp L=6e-08 W=1.5e-07
MI29_MXPA1 XI29_p1 s VDD VDD pm1p2_svt_lp L=6e-08 W=1.5e-07
MI28_MXPA1 s ns VDD VDD pm1p2_svt_lp L=6e-08 W=4.7e-07
MI103_MXPA1 nfb s VDD VDD pm1p2_svt_lp L=6e-08 W=5.3e-07
MI75_MXPA1 QN s VDD VDD pm1p2_svt_lp L=6e-08 W=5.85e-07
MI75_MXPA1_2 QN s VDD VDD pm1p2_svt_lp L=6e-08 W=5.85e-07
MI23_MXPA1 bclk nclk VDD VDD pm1p2_svt_lp L=6e-08 W=3.3e-07
MI22_MXPA1 nclk CK VDD VDD pm1p2_svt_lp L=6e-08 W=2.3e-07
.ENDS

.SUBCKT EDFFQNX3H9R QN VDD VSS CK D E
MI70_MXNA1 ne E VSS VSS nm1p2_svt_lp L=6e-08 W=3.7e-07
MI112_MXNA1 nd D VSS VSS nm1p2_svt_lp L=6e-08 W=2.6e-07
MI110_MXNOE nenmux E nd VSS nm1p2_svt_lp L=6e-08 W=2.6e-07
MI99_MXNOE nenmux ne nfb VSS nm1p2_svt_lp L=6e-08 W=2.6e-07
MI93_MXNA1 semux nenmux VSS VSS nm1p2_svt_lp L=6e-08 W=3.9e-07
MI33_MXNOE m nclk semux VSS nm1p2_svt_lp L=6e-08 W=3.9e-07
MI31_MXNOE m bclk XI31_n1 VSS nm1p2_svt_lp L=6e-08 W=1.5e-07
MI31_MXNA1 XI31_n1 nm VSS VSS nm1p2_svt_lp L=6e-08 W=1.5e-07
MI32_MXNA1 nm m VSS VSS nm1p2_svt_lp L=6e-08 W=3.9e-07
MI20_MXNOE ns bclk nm VSS nm1p2_svt_lp L=6e-08 W=3.9e-07
MI29_MXNOE ns nclk XI29_n1 VSS nm1p2_svt_lp L=6e-08 W=1.5e-07
MI29_MXNA1 XI29_n1 s VSS VSS nm1p2_svt_lp L=6e-08 W=1.5e-07
MI28_MXNA1 s ns VSS VSS nm1p2_svt_lp L=6e-08 W=2.8e-07
MI103_MXNA1 nfb s VSS VSS nm1p2_svt_lp L=6e-08 W=2.6e-07
MI75_MXNA1 QN s VSS VSS nm1p2_svt_lp L=6e-08 W=4.2e-07
MI75_MXNA1_2 QN s VSS VSS nm1p2_svt_lp L=6e-08 W=4.2e-07
MI75_MXNA1_3 QN s VSS VSS nm1p2_svt_lp L=6e-08 W=4.2e-07
MI23_MXNA1 bclk nclk VSS VSS nm1p2_svt_lp L=6e-08 W=1.8e-07
MI22_MXNA1 nclk CK VSS VSS nm1p2_svt_lp L=6e-08 W=2.2e-07
MI70_MXPA1 ne E VDD VDD pm1p2_svt_lp L=6e-08 W=5.2e-07
MI112_MXPA1 nd D VDD VDD pm1p2_svt_lp L=6e-08 W=5.65e-07
MI110_MXPOEN nenmux ne nd VDD pm1p2_svt_lp L=6e-08 W=4.5e-07
MI99_MXPOEN nenmux E nfb VDD pm1p2_svt_lp L=6e-08 W=4.5e-07
MI93_MXPA1 semux nenmux VDD VDD pm1p2_svt_lp L=6e-08 W=3.9e-07
MI33_MXPOEN m bclk semux VDD pm1p2_svt_lp L=6e-08 W=3.9e-07
MI31_MXPOEN m nclk XI31_p1 VDD pm1p2_svt_lp L=6e-08 W=1.5e-07
MI31_MXPA1 XI31_p1 nm VDD VDD pm1p2_svt_lp L=6e-08 W=1.5e-07
MI32_MXPA1 nm m VDD VDD pm1p2_svt_lp L=6e-08 W=5.2e-07
MI20_MXPOEN ns nclk nm VDD pm1p2_svt_lp L=6e-08 W=3.9e-07
MI29_MXPOEN ns bclk XI29_p1 VDD pm1p2_svt_lp L=6e-08 W=1.5e-07
MI29_MXPA1 XI29_p1 s VDD VDD pm1p2_svt_lp L=6e-08 W=1.5e-07
MI28_MXPA1 s ns VDD VDD pm1p2_svt_lp L=6e-08 W=5.55e-07
MI103_MXPA1 nfb s VDD VDD pm1p2_svt_lp L=6e-08 W=5.65e-07
MI75_MXPA1 QN s VDD VDD pm1p2_svt_lp L=6e-08 W=5.85e-07
MI75_MXPA1_2 QN s VDD VDD pm1p2_svt_lp L=6e-08 W=5.85e-07
MI75_MXPA1_3 QN s VDD VDD pm1p2_svt_lp L=6e-08 W=5.85e-07
MI23_MXPA1 bclk nclk VDD VDD pm1p2_svt_lp L=6e-08 W=3.6e-07
MI22_MXPA1 nclk CK VDD VDD pm1p2_svt_lp L=6e-08 W=2.4e-07
.ENDS

.SUBCKT SDFFQX0P5H9R Q VDD VSS CK D SE SI
MI57_MXNA1 nse SE VSS VSS nm1p2_svt_lp L=6e-08 W=1.5e-07
MI14_MXNOE nmux SE XI14_n1 VSS nm1p2_svt_lp L=6e-08 W=1.5e-07
MI14_MXNA1 XI14_n1 SI VSS VSS nm1p2_svt_lp L=6e-08 W=1.5e-07
MXN3 n1 nse VSS VSS nm1p2_svt_lp L=6e-08 W=1.5e-07
MXN2 nmux D n1 VSS nm1p2_svt_lp L=6e-08 W=1.5e-07
MI33_MXNOE nm nclk nmux VSS nm1p2_svt_lp L=6e-08 W=1.5e-07
MI31_MXNOE nm bclk XI31_n1 VSS nm1p2_svt_lp L=6e-08 W=1.5e-07
MI31_MXNA1 XI31_n1 m VSS VSS nm1p2_svt_lp L=6e-08 W=1.5e-07
MI32_MXNA1 m nm VSS VSS nm1p2_svt_lp L=6e-08 W=1.5e-07
MI20_MXNOE s bclk m VSS nm1p2_svt_lp L=6e-08 W=1.5e-07
MI29_MXNOE s nclk XI29_n1 VSS nm1p2_svt_lp L=6e-08 W=1.5e-07
MI29_MXNA1 XI29_n1 ns VSS VSS nm1p2_svt_lp L=6e-08 W=1.5e-07
MI28_MXNA1 ns s VSS VSS nm1p2_svt_lp L=6e-08 W=1.5e-07
MI8_MXNA1 Q ns VSS VSS nm1p2_svt_lp L=6e-08 W=2.1e-07
MI23_MXNA1 bclk nclk VSS VSS nm1p2_svt_lp L=6e-08 W=1.5e-07
MI22_MXNA1 nclk CK VSS VSS nm1p2_svt_lp L=6e-08 W=1.5e-07
MI57_MXPA1 nse SE VDD VDD pm1p2_svt_lp L=6e-08 W=2e-07
MI14_MXPOEN nmux nse XI14_p1 VDD pm1p2_svt_lp L=6e-08 W=1.5e-07
MI14_MXPA1 XI14_p1 SI VDD VDD pm1p2_svt_lp L=6e-08 W=1.5e-07
MXP2 p1 SE VDD VDD pm1p2_svt_lp L=6e-08 W=2e-07
MXP3 nmux D p1 VDD pm1p2_svt_lp L=6e-08 W=2e-07
MI33_MXPOEN nm bclk nmux VDD pm1p2_svt_lp L=6e-08 W=1.5e-07
MI31_MXPOEN nm nclk XI31_p1 VDD pm1p2_svt_lp L=6e-08 W=1.5e-07
MI31_MXPA1 XI31_p1 m VDD VDD pm1p2_svt_lp L=6e-08 W=1.5e-07
MI32_MXPA1 m nm VDD VDD pm1p2_svt_lp L=6e-08 W=1.9e-07
MI20_MXPOEN s nclk m VDD pm1p2_svt_lp L=6e-08 W=1.5e-07
MI29_MXPOEN s bclk XI29_p1 VDD pm1p2_svt_lp L=6e-08 W=1.5e-07
MI29_MXPA1 XI29_p1 ns VDD VDD pm1p2_svt_lp L=6e-08 W=1.5e-07
MI28_MXPA1 ns s VDD VDD pm1p2_svt_lp L=6e-08 W=1.5e-07
MI8_MXPA1 Q ns VDD VDD pm1p2_svt_lp L=6e-08 W=2.95e-07
MI23_MXPA1 bclk nclk VDD VDD pm1p2_svt_lp L=6e-08 W=1.9e-07
MI22_MXPA1 nclk CK VDD VDD pm1p2_svt_lp L=6e-08 W=1.7e-07
.ENDS

.SUBCKT SDFFQX1H9R Q VDD VSS CK D SE SI
MI57_MXNA1 nse SE VSS VSS nm1p2_svt_lp L=6e-08 W=1.5e-07
MI14_MXNOE nmux SE XI14_n1 VSS nm1p2_svt_lp L=6e-08 W=1.5e-07
MI14_MXNA1 XI14_n1 SI VSS VSS nm1p2_svt_lp L=6e-08 W=1.5e-07
MXN3 n1 nse VSS VSS nm1p2_svt_lp L=6e-08 W=2.55e-07
MXN2 nmux D n1 VSS nm1p2_svt_lp L=6e-08 W=2.55e-07
MI33_MXNOE nm nclk nmux VSS nm1p2_svt_lp L=6e-08 W=2.6e-07
MI31_MXNOE nm bclk XI31_n1 VSS nm1p2_svt_lp L=6e-08 W=1.5e-07
MI31_MXNA1 XI31_n1 m VSS VSS nm1p2_svt_lp L=6e-08 W=1.5e-07
MI32_MXNA1 m nm VSS VSS nm1p2_svt_lp L=6e-08 W=2.2e-07
MI20_MXNOE s bclk m VSS nm1p2_svt_lp L=6e-08 W=2.6e-07
MI29_MXNOE s nclk XI29_n1 VSS nm1p2_svt_lp L=6e-08 W=1.5e-07
MI29_MXNA1 XI29_n1 ns VSS VSS nm1p2_svt_lp L=6e-08 W=1.5e-07
MI28_MXNA1 ns s VSS VSS nm1p2_svt_lp L=6e-08 W=2.1e-07
MI8_MXNA1 Q ns VSS VSS nm1p2_svt_lp L=6e-08 W=4.2e-07
MI23_MXNA1 bclk nclk VSS VSS nm1p2_svt_lp L=6e-08 W=1.5e-07
MI22_MXNA1 nclk CK VSS VSS nm1p2_svt_lp L=6e-08 W=1.7e-07
MI57_MXPA1 nse SE VDD VDD pm1p2_svt_lp L=6e-08 W=2e-07
MI14_MXPOEN nmux nse XI14_p1 VDD pm1p2_svt_lp L=6e-08 W=2e-07
MI14_MXPA1 XI14_p1 SI VDD VDD pm1p2_svt_lp L=6e-08 W=2e-07
MXP2 p1 SE VDD VDD pm1p2_svt_lp L=6e-08 W=3.2e-07
MXP3 nmux D p1 VDD pm1p2_svt_lp L=6e-08 W=3.2e-07
MI33_MXPOEN nm bclk nmux VDD pm1p2_svt_lp L=6e-08 W=2.6e-07
MI31_MXPOEN nm nclk XI31_p1 VDD pm1p2_svt_lp L=6e-08 W=1.5e-07
MI31_MXPA1 XI31_p1 m VDD VDD pm1p2_svt_lp L=6e-08 W=1.5e-07
MI32_MXPA1 m nm VDD VDD pm1p2_svt_lp L=6e-08 W=3.1e-07
MI20_MXPOEN s nclk m VDD pm1p2_svt_lp L=6e-08 W=2.6e-07
MI29_MXPOEN s bclk XI29_p1 VDD pm1p2_svt_lp L=6e-08 W=1.5e-07
MI29_MXPA1 XI29_p1 ns VDD VDD pm1p2_svt_lp L=6e-08 W=1.5e-07
MI28_MXPA1 ns s VDD VDD pm1p2_svt_lp L=6e-08 W=3.7e-07
MI8_MXPA1 Q ns VDD VDD pm1p2_svt_lp L=6e-08 W=5.85e-07
MI23_MXPA1 bclk nclk VDD VDD pm1p2_svt_lp L=6e-08 W=3e-07
MI22_MXPA1 nclk CK VDD VDD pm1p2_svt_lp L=6e-08 W=1.9e-07
.ENDS

.SUBCKT SDFFQX2H9R Q VDD VSS CK D SE SI
MI57_MXNA1 nse SE VSS VSS nm1p2_svt_lp L=6e-08 W=1.5e-07
MI14_MXNOE nmux SE XI14_n1 VSS nm1p2_svt_lp L=6e-08 W=1.5e-07
MI14_MXNA1 XI14_n1 SI VSS VSS nm1p2_svt_lp L=6e-08 W=1.5e-07
MXN3 n1 nse VSS VSS nm1p2_svt_lp L=6e-08 W=3.7e-07
MXN2 nmux D n1 VSS nm1p2_svt_lp L=6e-08 W=3.7e-07
MI33_MXNOE nm nclk nmux VSS nm1p2_svt_lp L=6e-08 W=3.2e-07
MI31_MXNOE nm bclk XI31_n1 VSS nm1p2_svt_lp L=6e-08 W=1.5e-07
MI31_MXNA1 XI31_n1 m VSS VSS nm1p2_svt_lp L=6e-08 W=1.5e-07
MI32_MXNA1 m nm VSS VSS nm1p2_svt_lp L=6e-08 W=2.9e-07
MI20_MXNOE s bclk m VSS nm1p2_svt_lp L=6e-08 W=3.2e-07
MI29_MXNOE s nclk XI29_n1 VSS nm1p2_svt_lp L=6e-08 W=1.5e-07
MI29_MXNA1 XI29_n1 ns VSS VSS nm1p2_svt_lp L=6e-08 W=1.5e-07
MI28_MXNA1 ns s VSS VSS nm1p2_svt_lp L=6e-08 W=3e-07
MI8_MXNA1 Q ns VSS VSS nm1p2_svt_lp L=6e-08 W=4.2e-07
MI8_MXNA1_2 Q ns VSS VSS nm1p2_svt_lp L=6e-08 W=4.2e-07
MI23_MXNA1 bclk nclk VSS VSS nm1p2_svt_lp L=6e-08 W=1.7e-07
MI22_MXNA1 nclk CK VSS VSS nm1p2_svt_lp L=6e-08 W=2.1e-07
MI57_MXPA1 nse SE VDD VDD pm1p2_svt_lp L=6e-08 W=2e-07
MI14_MXPOEN nmux nse XI14_p1 VDD pm1p2_svt_lp L=6e-08 W=2e-07
MI14_MXPA1 XI14_p1 SI VDD VDD pm1p2_svt_lp L=6e-08 W=2e-07
MXP2 p1 SE VDD VDD pm1p2_svt_lp L=6e-08 W=4.3e-07
MXP3 nmux D p1 VDD pm1p2_svt_lp L=6e-08 W=4.3e-07
MI33_MXPOEN nm bclk nmux VDD pm1p2_svt_lp L=6e-08 W=3.2e-07
MI31_MXPOEN nm nclk XI31_p1 VDD pm1p2_svt_lp L=6e-08 W=1.5e-07
MI31_MXPA1 XI31_p1 m VDD VDD pm1p2_svt_lp L=6e-08 W=1.5e-07
MI32_MXPA1 m nm VDD VDD pm1p2_svt_lp L=6e-08 W=3.9e-07
MI20_MXPOEN s nclk m VDD pm1p2_svt_lp L=6e-08 W=3.2e-07
MI29_MXPOEN s bclk XI29_p1 VDD pm1p2_svt_lp L=6e-08 W=1.5e-07
MI29_MXPA1 XI29_p1 ns VDD VDD pm1p2_svt_lp L=6e-08 W=1.5e-07
MI28_MXPA1 ns s VDD VDD pm1p2_svt_lp L=6e-08 W=5.2e-07
MI8_MXPA1 Q ns VDD VDD pm1p2_svt_lp L=6e-08 W=5.85e-07
MI8_MXPA1_2 Q ns VDD VDD pm1p2_svt_lp L=6e-08 W=5.85e-07
MI23_MXPA1 bclk nclk VDD VDD pm1p2_svt_lp L=6e-08 W=3.3e-07
MI22_MXPA1 nclk CK VDD VDD pm1p2_svt_lp L=6e-08 W=2.3e-07
.ENDS

.SUBCKT SDFFQX3H9R Q VDD VSS CK D SE SI
MI57_MXNA1 nse SE VSS VSS nm1p2_svt_lp L=6e-08 W=1.5e-07
MI14_MXNOE nmux SE XI14_n1 VSS nm1p2_svt_lp L=6e-08 W=1.5e-07
MI14_MXNA1 XI14_n1 SI VSS VSS nm1p2_svt_lp L=6e-08 W=1.5e-07
MXN3 n1 nse VSS VSS nm1p2_svt_lp L=6e-08 W=4.4e-07
MXN2 nmux D n1 VSS nm1p2_svt_lp L=6e-08 W=4.4e-07
MI33_MXNOE nm nclk nmux VSS nm1p2_svt_lp L=6e-08 W=3.9e-07
MI31_MXNOE nm bclk XI31_n1 VSS nm1p2_svt_lp L=6e-08 W=1.5e-07
MI31_MXNA1 XI31_n1 m VSS VSS nm1p2_svt_lp L=6e-08 W=1.5e-07
MI32_MXNA1 m nm VSS VSS nm1p2_svt_lp L=6e-08 W=3.9e-07
MI20_MXNOE s bclk m VSS nm1p2_svt_lp L=6e-08 W=3.9e-07
MI29_MXNOE s nclk XI29_n1 VSS nm1p2_svt_lp L=6e-08 W=1.5e-07
MI29_MXNA1 XI29_n1 ns VSS VSS nm1p2_svt_lp L=6e-08 W=1.5e-07
MI28_MXNA1 ns s VSS VSS nm1p2_svt_lp L=6e-08 W=3.2e-07
MI8_MXNA1 Q ns VSS VSS nm1p2_svt_lp L=6e-08 W=4.2e-07
MI8_MXNA1_2 Q ns VSS VSS nm1p2_svt_lp L=6e-08 W=4.2e-07
MI8_MXNA1_3 Q ns VSS VSS nm1p2_svt_lp L=6e-08 W=4.2e-07
MI23_MXNA1 bclk nclk VSS VSS nm1p2_svt_lp L=6e-08 W=1.8e-07
MI22_MXNA1 nclk CK VSS VSS nm1p2_svt_lp L=6e-08 W=2.2e-07
MI57_MXPA1 nse SE VDD VDD pm1p2_svt_lp L=6e-08 W=2e-07
MI14_MXPOEN nmux nse XI14_p1 VDD pm1p2_svt_lp L=6e-08 W=2e-07
MI14_MXPA1 XI14_p1 SI VDD VDD pm1p2_svt_lp L=6e-08 W=2e-07
MXP2 p1 SE VDD VDD pm1p2_svt_lp L=6e-08 W=5e-07
MXP3 nmux D p1 VDD pm1p2_svt_lp L=6e-08 W=5e-07
MI33_MXPOEN nm bclk nmux VDD pm1p2_svt_lp L=6e-08 W=3.9e-07
MI31_MXPOEN nm nclk XI31_p1 VDD pm1p2_svt_lp L=6e-08 W=1.5e-07
MI31_MXPA1 XI31_p1 m VDD VDD pm1p2_svt_lp L=6e-08 W=1.5e-07
MI32_MXPA1 m nm VDD VDD pm1p2_svt_lp L=6e-08 W=5.05e-07
MI20_MXPOEN s nclk m VDD pm1p2_svt_lp L=6e-08 W=3.9e-07
MI29_MXPOEN s bclk XI29_p1 VDD pm1p2_svt_lp L=6e-08 W=1.5e-07
MI29_MXPA1 XI29_p1 ns VDD VDD pm1p2_svt_lp L=6e-08 W=1.5e-07
MI28_MXPA1 ns s VDD VDD pm1p2_svt_lp L=6e-08 W=5.8e-07
MI8_MXPA1 Q ns VDD VDD pm1p2_svt_lp L=6e-08 W=5.85e-07
MI8_MXPA1_2 Q ns VDD VDD pm1p2_svt_lp L=6e-08 W=5.85e-07
MI8_MXPA1_3 Q ns VDD VDD pm1p2_svt_lp L=6e-08 W=5.85e-07
MI23_MXPA1 bclk nclk VDD VDD pm1p2_svt_lp L=6e-08 W=3.6e-07
MI22_MXPA1 nclk CK VDD VDD pm1p2_svt_lp L=6e-08 W=2.4e-07
.ENDS

.SUBCKT SDFFQX4H9R Q VDD VSS CK D SE SI
MI57_MXNA1 nse SE VSS VSS nm1p2_svt_lp L=6e-08 W=1.5e-07
MI14_MXNOE nmux SE XI14_n1 VSS nm1p2_svt_lp L=6e-08 W=1.5e-07
MI14_MXNA1 XI14_n1 SI VSS VSS nm1p2_svt_lp L=6e-08 W=1.5e-07
MXN3 n1 nse VSS VSS nm1p2_svt_lp L=6e-08 W=4.5e-07
MXN2 nmux D n1 VSS nm1p2_svt_lp L=6e-08 W=4.5e-07
MI33_MXNOE nm nclk nmux VSS nm1p2_svt_lp L=6e-08 W=4.5e-07
MI31_MXNOE nm bclk XI31_n1 VSS nm1p2_svt_lp L=6e-08 W=1.5e-07
MI31_MXNA1 XI31_n1 m VSS VSS nm1p2_svt_lp L=6e-08 W=1.5e-07
MI32_MXNA1 m nm VSS VSS nm1p2_svt_lp L=6e-08 W=4.2e-07
MI20_MXNOE s bclk m VSS nm1p2_svt_lp L=6e-08 W=4.5e-07
MI29_MXNOE s nclk XI29_n1 VSS nm1p2_svt_lp L=6e-08 W=1.5e-07
MI29_MXNA1 XI29_n1 ns VSS VSS nm1p2_svt_lp L=6e-08 W=1.5e-07
MI28_MXNA1 ns s VSS VSS nm1p2_svt_lp L=6e-08 W=3.1e-07
MI28_MXNA1_2 ns s VSS VSS nm1p2_svt_lp L=6e-08 W=3.1e-07
MI8_MXNA1 Q ns VSS VSS nm1p2_svt_lp L=6e-08 W=4.2e-07
MI8_MXNA1_2 Q ns VSS VSS nm1p2_svt_lp L=6e-08 W=4.2e-07
MI8_MXNA1_3 Q ns VSS VSS nm1p2_svt_lp L=6e-08 W=4.2e-07
MI8_MXNA1_4 Q ns VSS VSS nm1p2_svt_lp L=6e-08 W=4.2e-07
MI23_MXNA1 bclk nclk VSS VSS nm1p2_svt_lp L=6e-08 W=2.1e-07
MI22_MXNA1 nclk CK VSS VSS nm1p2_svt_lp L=6e-08 W=2.5e-07
MI57_MXPA1 nse SE VDD VDD pm1p2_svt_lp L=6e-08 W=2e-07
MI14_MXPOEN nmux nse XI14_p1 VDD pm1p2_svt_lp L=6e-08 W=2e-07
MI14_MXPA1 XI14_p1 SI VDD VDD pm1p2_svt_lp L=6e-08 W=2e-07
MXP2 p1 SE VDD VDD pm1p2_svt_lp L=6e-08 W=5.4e-07
MXP3 nmux D p1 VDD pm1p2_svt_lp L=6e-08 W=5.4e-07
MI33_MXPOEN nm bclk nmux VDD pm1p2_svt_lp L=6e-08 W=4.5e-07
MI31_MXPOEN nm nclk XI31_p1 VDD pm1p2_svt_lp L=6e-08 W=1.5e-07
MI31_MXPA1 XI31_p1 m VDD VDD pm1p2_svt_lp L=6e-08 W=1.5e-07
MI32_MXPA1 m nm VDD VDD pm1p2_svt_lp L=6e-08 W=5.85e-07
MI20_MXPOEN s nclk m VDD pm1p2_svt_lp L=6e-08 W=4.5e-07
MI29_MXPOEN s bclk XI29_p1 VDD pm1p2_svt_lp L=6e-08 W=1.5e-07
MI29_MXPA1 XI29_p1 ns VDD VDD pm1p2_svt_lp L=6e-08 W=1.5e-07
MI28_MXPA1 ns s VDD VDD pm1p2_svt_lp L=6e-08 W=5e-07
MI28_MXPA1_2 ns s VDD VDD pm1p2_svt_lp L=6e-08 W=5e-07
MI8_MXPA1 Q ns VDD VDD pm1p2_svt_lp L=6e-08 W=5.85e-07
MI8_MXPA1_2 Q ns VDD VDD pm1p2_svt_lp L=6e-08 W=5.85e-07
MI8_MXPA1_3 Q ns VDD VDD pm1p2_svt_lp L=6e-08 W=5.85e-07
MI8_MXPA1_4 Q ns VDD VDD pm1p2_svt_lp L=6e-08 W=5.85e-07
MI23_MXPA1 bclk nclk VDD VDD pm1p2_svt_lp L=6e-08 W=4.2e-07
MI22_MXPA1 nclk CK VDD VDD pm1p2_svt_lp L=6e-08 W=2.8e-07
.ENDS

.SUBCKT SDFF2DQX1H9R Q VDD VSS CK D SE SI
MI57_MXNA1 nse SE VSS VSS nm1p2_svt_lp L=6e-08 W=1.5e-07
MI14_MXNOE nmux SE XI14_n1 VSS nm1p2_svt_lp L=6e-08 W=1.5e-07
MI14_MXNA1 XI14_n1 SI VSS VSS nm1p2_svt_lp L=6e-08 W=1.5e-07
MXN3 n1 nse VSS VSS nm1p2_svt_lp L=6e-08 W=2.3e-07
MXN2 nmux D n1 VSS nm1p2_svt_lp L=6e-08 W=2.3e-07
MI33_MXNOE nm nclk nmux VSS nm1p2_svt_lp L=6e-08 W=2.6e-07
MI31_MXNOE nm bclk XI31_n1 VSS nm1p2_svt_lp L=6e-08 W=3e-07
MI31_MXNA1 XI31_n1 m VSS VSS nm1p2_svt_lp L=6e-08 W=3e-07
MI32_MXNA1 m nm VSS VSS nm1p2_svt_lp L=6e-08 W=2.2e-07
MI20_MXNOE s bclk m VSS nm1p2_svt_lp L=6e-08 W=2.6e-07
MI29_MXNOE s nclk XI29_n1 VSS nm1p2_svt_lp L=6e-08 W=3e-07
MI29_MXNA1 XI29_n1 ns VSS VSS nm1p2_svt_lp L=6e-08 W=3e-07
MI28_MXNA1 ns s VSS VSS nm1p2_svt_lp L=6e-08 W=2.5e-07
MI8_MXNA1 Q ns VSS VSS nm1p2_svt_lp L=6e-08 W=4.2e-07
MI23_MXNA1 bclk nclk VSS VSS nm1p2_svt_lp L=6e-08 W=2.3e-07
MI22_MXNA1 nclk CK VSS VSS nm1p2_svt_lp L=6e-08 W=2.85e-07
MI57_MXPA1 nse SE VDD VDD pm1p2_svt_lp L=6e-08 W=2e-07
MI14_MXPOEN nmux nse XI14_p1 VDD pm1p2_svt_lp L=6e-08 W=2e-07
MI14_MXPA1 XI14_p1 SI VDD VDD pm1p2_svt_lp L=6e-08 W=2e-07
MXP2 p1 SE VDD VDD pm1p2_svt_lp L=6e-08 W=3.4e-07
MXP3 nmux D p1 VDD pm1p2_svt_lp L=6e-08 W=3.4e-07
MI33_MXPOEN nm bclk nmux VDD pm1p2_svt_lp L=6e-08 W=2.6e-07
MI31_MXPOEN nm nclk XI31_p1 VDD pm1p2_svt_lp L=6e-08 W=3e-07
MI31_MXPA1 XI31_p1 m VDD VDD pm1p2_svt_lp L=6e-08 W=3e-07
MI32_MXPA1 m nm VDD VDD pm1p2_svt_lp L=6e-08 W=3.1e-07
MI20_MXPOEN s nclk m VDD pm1p2_svt_lp L=6e-08 W=2.6e-07
MI29_MXPOEN s bclk XI29_p1 VDD pm1p2_svt_lp L=6e-08 W=3e-07
MI29_MXPA1 XI29_p1 ns VDD VDD pm1p2_svt_lp L=6e-08 W=3e-07
MI28_MXPA1 ns s VDD VDD pm1p2_svt_lp L=6e-08 W=3.4e-07
MI8_MXPA1 Q ns VDD VDD pm1p2_svt_lp L=6e-08 W=5.85e-07
MI23_MXPA1 bclk nclk VDD VDD pm1p2_svt_lp L=6e-08 W=4.6e-07
MI22_MXPA1 nclk CK VDD VDD pm1p2_svt_lp L=6e-08 W=3.15e-07
.ENDS

.SUBCKT SDFF2DQX2H9R Q VDD VSS CK D SE SI
MI57_MXNA1 nse SE VSS VSS nm1p2_svt_lp L=6e-08 W=1.5e-07
MI14_MXNOE nmux SE XI14_n1 VSS nm1p2_svt_lp L=6e-08 W=1.5e-07
MI14_MXNA1 XI14_n1 SI VSS VSS nm1p2_svt_lp L=6e-08 W=1.5e-07
MXN3 n1 nse VSS VSS nm1p2_svt_lp L=6e-08 W=3.4e-07
MXN2 nmux D n1 VSS nm1p2_svt_lp L=6e-08 W=3.4e-07
MI33_MXNOE nm nclk nmux VSS nm1p2_svt_lp L=6e-08 W=3.2e-07
MI31_MXNOE nm bclk XI31_n1 VSS nm1p2_svt_lp L=6e-08 W=3e-07
MI31_MXNA1 XI31_n1 m VSS VSS nm1p2_svt_lp L=6e-08 W=3e-07
MI32_MXNA1 m nm VSS VSS nm1p2_svt_lp L=6e-08 W=3e-07
MI20_MXNOE s bclk m VSS nm1p2_svt_lp L=6e-08 W=3.2e-07
MI29_MXNOE s nclk XI29_n1 VSS nm1p2_svt_lp L=6e-08 W=3e-07
MI29_MXNA1 XI29_n1 ns VSS VSS nm1p2_svt_lp L=6e-08 W=3e-07
MI28_MXNA1 ns s VSS VSS nm1p2_svt_lp L=6e-08 W=3.5e-07
MI8_MXNA1 Q ns VSS VSS nm1p2_svt_lp L=6e-08 W=4.2e-07
MI8_MXNA1_2 Q ns VSS VSS nm1p2_svt_lp L=6e-08 W=4.2e-07
MI23_MXNA1 bclk nclk VSS VSS nm1p2_svt_lp L=6e-08 W=2.4e-07
MI22_MXNA1 nclk CK VSS VSS nm1p2_svt_lp L=6e-08 W=3.1e-07
MI57_MXPA1 nse SE VDD VDD pm1p2_svt_lp L=6e-08 W=2e-07
MI14_MXPOEN nmux nse XI14_p1 VDD pm1p2_svt_lp L=6e-08 W=2e-07
MI14_MXPA1 XI14_p1 SI VDD VDD pm1p2_svt_lp L=6e-08 W=2e-07
MXP2 p1 SE VDD VDD pm1p2_svt_lp L=6e-08 W=4.5e-07
MXP3 nmux D p1 VDD pm1p2_svt_lp L=6e-08 W=4.5e-07
MI33_MXPOEN nm bclk nmux VDD pm1p2_svt_lp L=6e-08 W=3.2e-07
MI31_MXPOEN nm nclk XI31_p1 VDD pm1p2_svt_lp L=6e-08 W=3e-07
MI31_MXPA1 XI31_p1 m VDD VDD pm1p2_svt_lp L=6e-08 W=3e-07
MI32_MXPA1 m nm VDD VDD pm1p2_svt_lp L=6e-08 W=4.05e-07
MI20_MXPOEN s nclk m VDD pm1p2_svt_lp L=6e-08 W=3.2e-07
MI29_MXPOEN s bclk XI29_p1 VDD pm1p2_svt_lp L=6e-08 W=3e-07
MI29_MXPA1 XI29_p1 ns VDD VDD pm1p2_svt_lp L=6e-08 W=3e-07
MI28_MXPA1 ns s VDD VDD pm1p2_svt_lp L=6e-08 W=5e-07
MI8_MXPA1 Q ns VDD VDD pm1p2_svt_lp L=6e-08 W=5.85e-07
MI8_MXPA1_2 Q ns VDD VDD pm1p2_svt_lp L=6e-08 W=5.85e-07
MI23_MXPA1 bclk nclk VDD VDD pm1p2_svt_lp L=6e-08 W=4.8e-07
MI22_MXPA1 nclk CK VDD VDD pm1p2_svt_lp L=6e-08 W=3.4e-07
.ENDS

.SUBCKT SDFF2DQX3H9R Q VDD VSS CK D SE SI
MI57_MXNA1 nse SE VSS VSS nm1p2_svt_lp L=6e-08 W=1.5e-07
MI14_MXNOE nmux SE XI14_n1 VSS nm1p2_svt_lp L=6e-08 W=1.5e-07
MI14_MXNA1 XI14_n1 SI VSS VSS nm1p2_svt_lp L=6e-08 W=1.5e-07
MXN3 n1 nse VSS VSS nm1p2_svt_lp L=6e-08 W=3.9e-07
MXN2 nmux D n1 VSS nm1p2_svt_lp L=6e-08 W=3.9e-07
MI33_MXNOE nm nclk nmux VSS nm1p2_svt_lp L=6e-08 W=3.9e-07
MI31_MXNOE nm bclk XI31_n1 VSS nm1p2_svt_lp L=6e-08 W=3e-07
MI31_MXNA1 XI31_n1 m VSS VSS nm1p2_svt_lp L=6e-08 W=3e-07
MI32_MXNA1 m nm VSS VSS nm1p2_svt_lp L=6e-08 W=3.7e-07
MI20_MXNOE s bclk m VSS nm1p2_svt_lp L=6e-08 W=3.9e-07
MI29_MXNOE s nclk XI29_n1 VSS nm1p2_svt_lp L=6e-08 W=3e-07
MI29_MXNA1 XI29_n1 ns VSS VSS nm1p2_svt_lp L=6e-08 W=3e-07
MI28_MXNA1 ns s VSS VSS nm1p2_svt_lp L=6e-08 W=3.7e-07
MI8_MXNA1 Q ns VSS VSS nm1p2_svt_lp L=6e-08 W=4.2e-07
MI8_MXNA1_2 Q ns VSS VSS nm1p2_svt_lp L=6e-08 W=4.2e-07
MI8_MXNA1_3 Q ns VSS VSS nm1p2_svt_lp L=6e-08 W=4.2e-07
MI23_MXNA1 bclk nclk VSS VSS nm1p2_svt_lp L=6e-08 W=2.6e-07
MI22_MXNA1 nclk CK VSS VSS nm1p2_svt_lp L=6e-08 W=3.5e-07
MI57_MXPA1 nse SE VDD VDD pm1p2_svt_lp L=6e-08 W=2e-07
MI14_MXPOEN nmux nse XI14_p1 VDD pm1p2_svt_lp L=6e-08 W=2e-07
MI14_MXPA1 XI14_p1 SI VDD VDD pm1p2_svt_lp L=6e-08 W=2e-07
MXP2 p1 SE VDD VDD pm1p2_svt_lp L=6e-08 W=5.2e-07
MXP3 nmux D p1 VDD pm1p2_svt_lp L=6e-08 W=5.2e-07
MI33_MXPOEN nm bclk nmux VDD pm1p2_svt_lp L=6e-08 W=3.9e-07
MI31_MXPOEN nm nclk XI31_p1 VDD pm1p2_svt_lp L=6e-08 W=3e-07
MI31_MXPA1 XI31_p1 m VDD VDD pm1p2_svt_lp L=6e-08 W=3e-07
MI32_MXPA1 m nm VDD VDD pm1p2_svt_lp L=6e-08 W=5.05e-07
MI20_MXPOEN s nclk m VDD pm1p2_svt_lp L=6e-08 W=3.9e-07
MI29_MXPOEN s bclk XI29_p1 VDD pm1p2_svt_lp L=6e-08 W=3e-07
MI29_MXPA1 XI29_p1 ns VDD VDD pm1p2_svt_lp L=6e-08 W=3e-07
MI28_MXPA1 ns s VDD VDD pm1p2_svt_lp L=6e-08 W=5.4e-07
MI8_MXPA1 Q ns VDD VDD pm1p2_svt_lp L=6e-08 W=5.85e-07
MI8_MXPA1_2 Q ns VDD VDD pm1p2_svt_lp L=6e-08 W=5.85e-07
MI8_MXPA1_3 Q ns VDD VDD pm1p2_svt_lp L=6e-08 W=5.85e-07
MI23_MXPA1 bclk nclk VDD VDD pm1p2_svt_lp L=6e-08 W=5.2e-07
MI22_MXPA1 nclk CK VDD VDD pm1p2_svt_lp L=6e-08 W=3.85e-07
.ENDS

.SUBCKT SDFF2DQX4H9R Q VDD VSS CK D SE SI
MI57_MXNA1 nse SE VSS VSS nm1p2_svt_lp L=6e-08 W=1.5e-07
MI14_MXNOE nmux SE XI14_n1 VSS nm1p2_svt_lp L=6e-08 W=1.5e-07
MI14_MXNA1 XI14_n1 SI VSS VSS nm1p2_svt_lp L=6e-08 W=1.5e-07
MXN3 n1 nse VSS VSS nm1p2_svt_lp L=6e-08 W=4e-07
MXN2 nmux D n1 VSS nm1p2_svt_lp L=6e-08 W=4e-07
MI33_MXNOE nm nclk nmux VSS nm1p2_svt_lp L=6e-08 W=4.5e-07
MI31_MXNOE nm bclk XI31_n1 VSS nm1p2_svt_lp L=6e-08 W=3e-07
MI31_MXNA1 XI31_n1 m VSS VSS nm1p2_svt_lp L=6e-08 W=3e-07
MI32_MXNA1 m nm VSS VSS nm1p2_svt_lp L=6e-08 W=4.2e-07
MI20_MXNOE s bclk m VSS nm1p2_svt_lp L=6e-08 W=4.5e-07
MI29_MXNOE s nclk XI29_n1 VSS nm1p2_svt_lp L=6e-08 W=3e-07
MI29_MXNA1 XI29_n1 ns VSS VSS nm1p2_svt_lp L=6e-08 W=3e-07
MI28_MXNA1 ns s VSS VSS nm1p2_svt_lp L=6e-08 W=3.7e-07
MI28_MXNA1_2 ns s VSS VSS nm1p2_svt_lp L=6e-08 W=3.7e-07
MI8_MXNA1 Q ns VSS VSS nm1p2_svt_lp L=6e-08 W=4.2e-07
MI8_MXNA1_2 Q ns VSS VSS nm1p2_svt_lp L=6e-08 W=4.2e-07
MI8_MXNA1_3 Q ns VSS VSS nm1p2_svt_lp L=6e-08 W=4.2e-07
MI8_MXNA1_4 Q ns VSS VSS nm1p2_svt_lp L=6e-08 W=4.2e-07
MI23_MXNA1 bclk nclk VSS VSS nm1p2_svt_lp L=6e-08 W=3e-07
MI22_MXNA1 nclk CK VSS VSS nm1p2_svt_lp L=6e-08 W=4e-07
MI57_MXPA1 nse SE VDD VDD pm1p2_svt_lp L=6e-08 W=2e-07
MI14_MXPOEN nmux nse XI14_p1 VDD pm1p2_svt_lp L=6e-08 W=2e-07
MI14_MXPA1 XI14_p1 SI VDD VDD pm1p2_svt_lp L=6e-08 W=2e-07
MXP2 p1 SE VDD VDD pm1p2_svt_lp L=6e-08 W=5.4e-07
MXP3 nmux D p1 VDD pm1p2_svt_lp L=6e-08 W=5.4e-07
MI33_MXPOEN nm bclk nmux VDD pm1p2_svt_lp L=6e-08 W=4.5e-07
MI31_MXPOEN nm nclk XI31_p1 VDD pm1p2_svt_lp L=6e-08 W=3e-07
MI31_MXPA1 XI31_p1 m VDD VDD pm1p2_svt_lp L=6e-08 W=3e-07
MI32_MXPA1 m nm VDD VDD pm1p2_svt_lp L=6e-08 W=5.85e-07
MI20_MXPOEN s nclk m VDD pm1p2_svt_lp L=6e-08 W=4.5e-07
MI29_MXPOEN s bclk XI29_p1 VDD pm1p2_svt_lp L=6e-08 W=3e-07
MI29_MXPA1 XI29_p1 ns VDD VDD pm1p2_svt_lp L=6e-08 W=3e-07
MI28_MXPA1 ns s VDD VDD pm1p2_svt_lp L=6e-08 W=4.8e-07
MI28_MXPA1_2 ns s VDD VDD pm1p2_svt_lp L=6e-08 W=4.8e-07
MI8_MXPA1 Q ns VDD VDD pm1p2_svt_lp L=6e-08 W=5.85e-07
MI8_MXPA1_2 Q ns VDD VDD pm1p2_svt_lp L=6e-08 W=5.85e-07
MI8_MXPA1_3 Q ns VDD VDD pm1p2_svt_lp L=6e-08 W=5.85e-07
MI8_MXPA1_4 Q ns VDD VDD pm1p2_svt_lp L=6e-08 W=5.85e-07
MI23_MXPA1 bclk nclk VDD VDD pm1p2_svt_lp L=6e-08 W=5.85e-07
MI22_MXPA1 nclk CK VDD VDD pm1p2_svt_lp L=6e-08 W=4.4e-07
.ENDS

.SUBCKT SDFFQNX0P5H9R QN VDD VSS CK D SE SI
MI57_MXNA1 nse SE VSS VSS nm1p2_svt_lp L=6e-08 W=1.5e-07
MI14_MXNOE nmux SE XI14_n1 VSS nm1p2_svt_lp L=6e-08 W=1.5e-07
MI14_MXNA1 XI14_n1 SI VSS VSS nm1p2_svt_lp L=6e-08 W=1.5e-07
MXN3 n1 nse VSS VSS nm1p2_svt_lp L=6e-08 W=1.5e-07
MXN2 nmux D n1 VSS nm1p2_svt_lp L=6e-08 W=1.5e-07
MI33_MXNOE nm nclk nmux VSS nm1p2_svt_lp L=6e-08 W=1.5e-07
MI31_MXNOE nm bclk XI31_n1 VSS nm1p2_svt_lp L=6e-08 W=1.5e-07
MI31_MXNA1 XI31_n1 m VSS VSS nm1p2_svt_lp L=6e-08 W=1.5e-07
MI32_MXNA1 m nm VSS VSS nm1p2_svt_lp L=6e-08 W=1.5e-07
MI20_MXNOE s bclk m VSS nm1p2_svt_lp L=6e-08 W=1.5e-07
MI68_MXNOE s nclk XI68_n1 VSS nm1p2_svt_lp L=6e-08 W=1.5e-07
MI68_MXNA1 XI68_n1 ns VSS VSS nm1p2_svt_lp L=6e-08 W=1.5e-07
MI28_MXNA1 ns s VSS VSS nm1p2_svt_lp L=6e-08 W=1.2e-07
MI75_MXNA1 QN s VSS VSS nm1p2_svt_lp L=6e-08 W=2.1e-07
MI23_MXNA1 bclk nclk VSS VSS nm1p2_svt_lp L=6e-08 W=1.5e-07
MI22_MXNA1 nclk CK VSS VSS nm1p2_svt_lp L=6e-08 W=1.5e-07
MI57_MXPA1 nse SE VDD VDD pm1p2_svt_lp L=6e-08 W=2e-07
MI14_MXPOEN nmux nse XI14_p1 VDD pm1p2_svt_lp L=6e-08 W=1.5e-07
MI14_MXPA1 XI14_p1 SI VDD VDD pm1p2_svt_lp L=6e-08 W=1.5e-07
MXP2 p1 SE VDD VDD pm1p2_svt_lp L=6e-08 W=1.95e-07
MXP3 nmux D p1 VDD pm1p2_svt_lp L=6e-08 W=1.95e-07
MI33_MXPOEN nm bclk nmux VDD pm1p2_svt_lp L=6e-08 W=1.5e-07
MI31_MXPOEN nm nclk XI31_p1 VDD pm1p2_svt_lp L=6e-08 W=1.5e-07
MI31_MXPA1 XI31_p1 m VDD VDD pm1p2_svt_lp L=6e-08 W=1.5e-07
MI32_MXPA1 m nm VDD VDD pm1p2_svt_lp L=6e-08 W=2.1e-07
MI20_MXPOEN s nclk m VDD pm1p2_svt_lp L=6e-08 W=1.5e-07
MI68_MXPOEN s bclk XI68_p1 VDD pm1p2_svt_lp L=6e-08 W=1.5e-07
MI68_MXPA1 XI68_p1 ns VDD VDD pm1p2_svt_lp L=6e-08 W=1.5e-07
MI28_MXPA1 ns s VDD VDD pm1p2_svt_lp L=6e-08 W=1.2e-07
MI75_MXPA1 QN s VDD VDD pm1p2_svt_lp L=6e-08 W=2.95e-07
MI23_MXPA1 bclk nclk VDD VDD pm1p2_svt_lp L=6e-08 W=1.9e-07
MI22_MXPA1 nclk CK VDD VDD pm1p2_svt_lp L=6e-08 W=1.7e-07
.ENDS

.SUBCKT SDFFQNX1H9R QN VDD VSS CK D SE SI
MI57_MXNA1 nse SE VSS VSS nm1p2_svt_lp L=6e-08 W=1.5e-07
MI14_MXNOE nmux SE XI14_n1 VSS nm1p2_svt_lp L=6e-08 W=1.5e-07
MI14_MXNA1 XI14_n1 SI VSS VSS nm1p2_svt_lp L=6e-08 W=1.5e-07
MXN3 n1 nse VSS VSS nm1p2_svt_lp L=6e-08 W=2.7e-07
MXN2 nmux D n1 VSS nm1p2_svt_lp L=6e-08 W=2.7e-07
MI33_MXNOE nm nclk nmux VSS nm1p2_svt_lp L=6e-08 W=2.6e-07
MI31_MXNOE nm bclk XI31_n1 VSS nm1p2_svt_lp L=6e-08 W=1.5e-07
MI31_MXNA1 XI31_n1 m VSS VSS nm1p2_svt_lp L=6e-08 W=1.5e-07
MI32_MXNA1 m nm VSS VSS nm1p2_svt_lp L=6e-08 W=2.6e-07
MI20_MXNOE s bclk m VSS nm1p2_svt_lp L=6e-08 W=2.6e-07
MI68_MXNOE s nclk XI68_n1 VSS nm1p2_svt_lp L=6e-08 W=1.5e-07
MI68_MXNA1 XI68_n1 ns VSS VSS nm1p2_svt_lp L=6e-08 W=1.5e-07
MI28_MXNA1 ns s VSS VSS nm1p2_svt_lp L=6e-08 W=1.2e-07
MI75_MXNA1 QN s VSS VSS nm1p2_svt_lp L=6e-08 W=4.2e-07
MI23_MXNA1 bclk nclk VSS VSS nm1p2_svt_lp L=6e-08 W=1.5e-07
MI22_MXNA1 nclk CK VSS VSS nm1p2_svt_lp L=6e-08 W=1.7e-07
MI57_MXPA1 nse SE VDD VDD pm1p2_svt_lp L=6e-08 W=2e-07
MI14_MXPOEN nmux nse XI14_p1 VDD pm1p2_svt_lp L=6e-08 W=2e-07
MI14_MXPA1 XI14_p1 SI VDD VDD pm1p2_svt_lp L=6e-08 W=2e-07
MXP2 p1 SE VDD VDD pm1p2_svt_lp L=6e-08 W=3.2e-07
MXP3 nmux D p1 VDD pm1p2_svt_lp L=6e-08 W=3.2e-07
MI33_MXPOEN nm bclk nmux VDD pm1p2_svt_lp L=6e-08 W=2.6e-07
MI31_MXPOEN nm nclk XI31_p1 VDD pm1p2_svt_lp L=6e-08 W=1.5e-07
MI31_MXPA1 XI31_p1 m VDD VDD pm1p2_svt_lp L=6e-08 W=1.5e-07
MI32_MXPA1 m nm VDD VDD pm1p2_svt_lp L=6e-08 W=2.8e-07
MI20_MXPOEN s nclk m VDD pm1p2_svt_lp L=6e-08 W=2.6e-07
MI68_MXPOEN s bclk XI68_p1 VDD pm1p2_svt_lp L=6e-08 W=1.5e-07
MI68_MXPA1 XI68_p1 ns VDD VDD pm1p2_svt_lp L=6e-08 W=1.5e-07
MI28_MXPA1 ns s VDD VDD pm1p2_svt_lp L=6e-08 W=1.2e-07
MI75_MXPA1 QN s VDD VDD pm1p2_svt_lp L=6e-08 W=5.85e-07
MI23_MXPA1 bclk nclk VDD VDD pm1p2_svt_lp L=6e-08 W=3e-07
MI22_MXPA1 nclk CK VDD VDD pm1p2_svt_lp L=6e-08 W=1.9e-07
.ENDS

.SUBCKT SDFFQNX2H9R QN VDD VSS CK D SE SI
MI57_MXNA1 nse SE VSS VSS nm1p2_svt_lp L=6e-08 W=1.5e-07
MI14_MXNOE nmux SE XI14_n1 VSS nm1p2_svt_lp L=6e-08 W=1.5e-07
MI14_MXNA1 XI14_n1 SI VSS VSS nm1p2_svt_lp L=6e-08 W=1.5e-07
MXN3 n1 nse VSS VSS nm1p2_svt_lp L=6e-08 W=4.2e-07
MXN2 nmux D n1 VSS nm1p2_svt_lp L=6e-08 W=4.2e-07
MI33_MXNOE nm nclk nmux VSS nm1p2_svt_lp L=6e-08 W=3.2e-07
MI31_MXNOE nm bclk XI31_n1 VSS nm1p2_svt_lp L=6e-08 W=1.5e-07
MI31_MXNA1 XI31_n1 m VSS VSS nm1p2_svt_lp L=6e-08 W=1.5e-07
MI32_MXNA1 m nm VSS VSS nm1p2_svt_lp L=6e-08 W=3.5e-07
MI20_MXNOE s bclk m VSS nm1p2_svt_lp L=6e-08 W=3.2e-07
MI68_MXNOE s nclk XI68_n1 VSS nm1p2_svt_lp L=6e-08 W=1.5e-07
MI68_MXNA1 XI68_n1 ns VSS VSS nm1p2_svt_lp L=6e-08 W=1.5e-07
MI28_MXNA1 ns s VSS VSS nm1p2_svt_lp L=6e-08 W=1.2e-07
MI75_MXNA1 QN s VSS VSS nm1p2_svt_lp L=6e-08 W=4.2e-07
MI75_MXNA1_2 QN s VSS VSS nm1p2_svt_lp L=6e-08 W=4.2e-07
MI23_MXNA1 bclk nclk VSS VSS nm1p2_svt_lp L=6e-08 W=1.7e-07
MI22_MXNA1 nclk CK VSS VSS nm1p2_svt_lp L=6e-08 W=2.1e-07
MI57_MXPA1 nse SE VDD VDD pm1p2_svt_lp L=6e-08 W=2e-07
MI14_MXPOEN nmux nse XI14_p1 VDD pm1p2_svt_lp L=6e-08 W=2e-07
MI14_MXPA1 XI14_p1 SI VDD VDD pm1p2_svt_lp L=6e-08 W=2e-07
MXP2 p1 SE VDD VDD pm1p2_svt_lp L=6e-08 W=4.9e-07
MXP3 nmux D p1 VDD pm1p2_svt_lp L=6e-08 W=4.9e-07
MI33_MXPOEN nm bclk nmux VDD pm1p2_svt_lp L=6e-08 W=3.2e-07
MI31_MXPOEN nm nclk XI31_p1 VDD pm1p2_svt_lp L=6e-08 W=1.5e-07
MI31_MXPA1 XI31_p1 m VDD VDD pm1p2_svt_lp L=6e-08 W=1.5e-07
MI32_MXPA1 m nm VDD VDD pm1p2_svt_lp L=6e-08 W=4.55e-07
MI20_MXPOEN s nclk m VDD pm1p2_svt_lp L=6e-08 W=3.2e-07
MI68_MXPOEN s bclk XI68_p1 VDD pm1p2_svt_lp L=6e-08 W=1.5e-07
MI68_MXPA1 XI68_p1 ns VDD VDD pm1p2_svt_lp L=6e-08 W=1.5e-07
MI28_MXPA1 ns s VDD VDD pm1p2_svt_lp L=6e-08 W=1.2e-07
MI75_MXPA1 QN s VDD VDD pm1p2_svt_lp L=6e-08 W=5.85e-07
MI75_MXPA1_2 QN s VDD VDD pm1p2_svt_lp L=6e-08 W=5.85e-07
MI23_MXPA1 bclk nclk VDD VDD pm1p2_svt_lp L=6e-08 W=3.3e-07
MI22_MXPA1 nclk CK VDD VDD pm1p2_svt_lp L=6e-08 W=2.3e-07
.ENDS

.SUBCKT SDFFQNX3H9R QN VDD VSS CK D SE SI
MI57_MXNA1 nse SE VSS VSS nm1p2_svt_lp L=6e-08 W=1.5e-07
MI14_MXNOE nmux SE XI14_n1 VSS nm1p2_svt_lp L=6e-08 W=1.5e-07
MI14_MXNA1 XI14_n1 SI VSS VSS nm1p2_svt_lp L=6e-08 W=1.5e-07
MXN3 n1 nse VSS VSS nm1p2_svt_lp L=6e-08 W=4.4e-07
MXN2 nmux D n1 VSS nm1p2_svt_lp L=6e-08 W=4.4e-07
MI33_MXNOE nm nclk nmux VSS nm1p2_svt_lp L=6e-08 W=3.9e-07
MI31_MXNOE nm bclk XI31_n1 VSS nm1p2_svt_lp L=6e-08 W=1.5e-07
MI31_MXNA1 XI31_n1 m VSS VSS nm1p2_svt_lp L=6e-08 W=1.5e-07
MI32_MXNA1 m nm VSS VSS nm1p2_svt_lp L=6e-08 W=4e-07
MI20_MXNOE s bclk m VSS nm1p2_svt_lp L=6e-08 W=3.9e-07
MI68_MXNOE s nclk XI68_n1 VSS nm1p2_svt_lp L=6e-08 W=1.5e-07
MI68_MXNA1 XI68_n1 ns VSS VSS nm1p2_svt_lp L=6e-08 W=1.5e-07
MI28_MXNA1 ns s VSS VSS nm1p2_svt_lp L=6e-08 W=1.2e-07
MI75_MXNA1 QN s VSS VSS nm1p2_svt_lp L=6e-08 W=4.2e-07
MI75_MXNA1_2 QN s VSS VSS nm1p2_svt_lp L=6e-08 W=4.2e-07
MI75_MXNA1_3 QN s VSS VSS nm1p2_svt_lp L=6e-08 W=4.2e-07
MI23_MXNA1 bclk nclk VSS VSS nm1p2_svt_lp L=6e-08 W=1.8e-07
MI22_MXNA1 nclk CK VSS VSS nm1p2_svt_lp L=6e-08 W=2.2e-07
MI57_MXPA1 nse SE VDD VDD pm1p2_svt_lp L=6e-08 W=2e-07
MI14_MXPOEN nmux nse XI14_p1 VDD pm1p2_svt_lp L=6e-08 W=2e-07
MI14_MXPA1 XI14_p1 SI VDD VDD pm1p2_svt_lp L=6e-08 W=2e-07
MXP2 p1 SE VDD VDD pm1p2_svt_lp L=6e-08 W=5.2e-07
MXP3 nmux D p1 VDD pm1p2_svt_lp L=6e-08 W=5.2e-07
MI33_MXPOEN nm bclk nmux VDD pm1p2_svt_lp L=6e-08 W=3.9e-07
MI31_MXPOEN nm nclk XI31_p1 VDD pm1p2_svt_lp L=6e-08 W=1.5e-07
MI31_MXPA1 XI31_p1 m VDD VDD pm1p2_svt_lp L=6e-08 W=1.5e-07
MI32_MXPA1 m nm VDD VDD pm1p2_svt_lp L=6e-08 W=5.7e-07
MI20_MXPOEN s nclk m VDD pm1p2_svt_lp L=6e-08 W=3.9e-07
MI68_MXPOEN s bclk XI68_p1 VDD pm1p2_svt_lp L=6e-08 W=1.5e-07
MI68_MXPA1 XI68_p1 ns VDD VDD pm1p2_svt_lp L=6e-08 W=1.5e-07
MI28_MXPA1 ns s VDD VDD pm1p2_svt_lp L=6e-08 W=1.2e-07
MI75_MXPA1 QN s VDD VDD pm1p2_svt_lp L=6e-08 W=5.85e-07
MI75_MXPA1_2 QN s VDD VDD pm1p2_svt_lp L=6e-08 W=5.85e-07
MI75_MXPA1_3 QN s VDD VDD pm1p2_svt_lp L=6e-08 W=5.85e-07
MI23_MXPA1 bclk nclk VDD VDD pm1p2_svt_lp L=6e-08 W=3.6e-07
MI22_MXPA1 nclk CK VDD VDD pm1p2_svt_lp L=6e-08 W=2.4e-07
.ENDS

.SUBCKT SDFFNQX1H9R Q VDD VSS CKN D SE SI
MI57_MXNA1 nse SE VSS VSS nm1p2_svt_lp L=6e-08 W=1.5e-07
MXN3 n1 nse VSS VSS nm1p2_svt_lp L=6e-08 W=1.6e-07
MXN2 nmux D n1 VSS nm1p2_svt_lp L=6e-08 W=1.6e-07
MI14_MXNOE nmux SE XI14_n1 VSS nm1p2_svt_lp L=6e-08 W=1.5e-07
MI14_MXNA1 XI14_n1 SI VSS VSS nm1p2_svt_lp L=6e-08 W=1.5e-07
MI23_MXNA1 bclk_ nclk_ VSS VSS nm1p2_svt_lp L=6e-08 W=1.7e-07
MI33_MXNOE nm bclk_ nmux VSS nm1p2_svt_lp L=6e-08 W=1.5e-07
MI31_MXNOE nm nclk_ XI31_n1 VSS nm1p2_svt_lp L=6e-08 W=1.5e-07
MI31_MXNA1 XI31_n1 m VSS VSS nm1p2_svt_lp L=6e-08 W=1.5e-07
MI32_MXNA1 m nm VSS VSS nm1p2_svt_lp L=6e-08 W=2.2e-07
MI20_MXNOE s nclk_ m VSS nm1p2_svt_lp L=6e-08 W=1.5e-07
MI29_MXNOE s bclk_ XI29_n1 VSS nm1p2_svt_lp L=6e-08 W=1.5e-07
MI29_MXNA1 XI29_n1 ns VSS VSS nm1p2_svt_lp L=6e-08 W=1.5e-07
MI8_MXNA1 Q ns VSS VSS nm1p2_svt_lp L=6e-08 W=4.2e-07
MI28_MXNA1 ns s VSS VSS nm1p2_svt_lp L=6e-08 W=2.2e-07
MI22_MXNA1 nclk_ CKN VSS VSS nm1p2_svt_lp L=6e-08 W=1.5e-07
MI57_MXPA1 nse SE VDD VDD pm1p2_svt_lp L=6e-08 W=2e-07
MXP2 p1 SE VDD VDD pm1p2_svt_lp L=6e-08 W=4.2e-07
MXP3 nmux D p1 VDD pm1p2_svt_lp L=6e-08 W=4.2e-07
MI14_MXPOEN nmux nse XI14_p1 VDD pm1p2_svt_lp L=6e-08 W=2e-07
MI14_MXPA1 XI14_p1 SI VDD VDD pm1p2_svt_lp L=6e-08 W=2e-07
MI23_MXPA1 bclk_ nclk_ VDD VDD pm1p2_svt_lp L=6e-08 W=1.9e-07
MI33_MXPOEN nm nclk_ nmux VDD pm1p2_svt_lp L=6e-08 W=3.6e-07
MI31_MXPOEN nm bclk_ XI31_p1 VDD pm1p2_svt_lp L=6e-08 W=1.5e-07
MI31_MXPA1 XI31_p1 m VDD VDD pm1p2_svt_lp L=6e-08 W=1.5e-07
MI32_MXPA1 m nm VDD VDD pm1p2_svt_lp L=6e-08 W=3.1e-07
MI20_MXPOEN s bclk_ m VDD pm1p2_svt_lp L=6e-08 W=3.6e-07
MI29_MXPOEN s nclk_ XI29_p1 VDD pm1p2_svt_lp L=6e-08 W=1.5e-07
MI29_MXPA1 XI29_p1 ns VDD VDD pm1p2_svt_lp L=6e-08 W=1.5e-07
MI8_MXPA1 Q ns VDD VDD pm1p2_svt_lp L=6e-08 W=5.85e-07
MI28_MXPA1 ns s VDD VDD pm1p2_svt_lp L=6e-08 W=1.5e-07
MI22_MXPA1 nclk_ CKN VDD VDD pm1p2_svt_lp L=6e-08 W=3e-07
.ENDS

.SUBCKT SDFFNQX2H9R Q VDD VSS CKN D SE SI
MI57_MXNA1 nse SE VSS VSS nm1p2_svt_lp L=6e-08 W=1.5e-07
MXN3 n1 nse VSS VSS nm1p2_svt_lp L=6e-08 W=1.7e-07
MXN2 nmux D n1 VSS nm1p2_svt_lp L=6e-08 W=1.7e-07
MI14_MXNOE nmux SE XI14_n1 VSS nm1p2_svt_lp L=6e-08 W=1.5e-07
MI14_MXNA1 XI14_n1 SI VSS VSS nm1p2_svt_lp L=6e-08 W=1.5e-07
MI23_MXNA1 bclk_ nclk_ VSS VSS nm1p2_svt_lp L=6e-08 W=2.1e-07
MI33_MXNOE nm bclk_ nmux VSS nm1p2_svt_lp L=6e-08 W=1.8e-07
MI31_MXNOE nm nclk_ XI31_n1 VSS nm1p2_svt_lp L=6e-08 W=1.5e-07
MI31_MXNA1 XI31_n1 m VSS VSS nm1p2_svt_lp L=6e-08 W=1.5e-07
MI32_MXNA1 m nm VSS VSS nm1p2_svt_lp L=6e-08 W=2.9e-07
MI20_MXNOE s nclk_ m VSS nm1p2_svt_lp L=6e-08 W=1.8e-07
MI29_MXNOE s bclk_ XI29_n1 VSS nm1p2_svt_lp L=6e-08 W=1.5e-07
MI29_MXNA1 XI29_n1 ns VSS VSS nm1p2_svt_lp L=6e-08 W=1.5e-07
MI8_MXNA1 Q ns VSS VSS nm1p2_svt_lp L=6e-08 W=4.2e-07
MI8_MXNA1_2 Q ns VSS VSS nm1p2_svt_lp L=6e-08 W=4.2e-07
MI28_MXNA1 ns s VSS VSS nm1p2_svt_lp L=6e-08 W=3.4e-07
MI22_MXNA1 nclk_ CKN VSS VSS nm1p2_svt_lp L=6e-08 W=1.7e-07
MI57_MXPA1 nse SE VDD VDD pm1p2_svt_lp L=6e-08 W=2e-07
MXP2 p1 SE VDD VDD pm1p2_svt_lp L=6e-08 W=4.3e-07
MXP3 nmux D p1 VDD pm1p2_svt_lp L=6e-08 W=4.3e-07
MI14_MXPOEN nmux nse XI14_p1 VDD pm1p2_svt_lp L=6e-08 W=2e-07
MI14_MXPA1 XI14_p1 SI VDD VDD pm1p2_svt_lp L=6e-08 W=2e-07
MI23_MXPA1 bclk_ nclk_ VDD VDD pm1p2_svt_lp L=6e-08 W=2.3e-07
MI33_MXPOEN nm nclk_ nmux VDD pm1p2_svt_lp L=6e-08 W=4.5e-07
MI31_MXPOEN nm bclk_ XI31_p1 VDD pm1p2_svt_lp L=6e-08 W=1.5e-07
MI31_MXPA1 XI31_p1 m VDD VDD pm1p2_svt_lp L=6e-08 W=1.5e-07
MI32_MXPA1 m nm VDD VDD pm1p2_svt_lp L=6e-08 W=4.05e-07
MI20_MXPOEN s bclk_ m VDD pm1p2_svt_lp L=6e-08 W=4.5e-07
MI29_MXPOEN s nclk_ XI29_p1 VDD pm1p2_svt_lp L=6e-08 W=1.5e-07
MI29_MXPA1 XI29_p1 ns VDD VDD pm1p2_svt_lp L=6e-08 W=1.5e-07
MI8_MXPA1 Q ns VDD VDD pm1p2_svt_lp L=6e-08 W=5.85e-07
MI8_MXPA1_2 Q ns VDD VDD pm1p2_svt_lp L=6e-08 W=5.85e-07
MI28_MXPA1 ns s VDD VDD pm1p2_svt_lp L=6e-08 W=2.6e-07
MI22_MXPA1 nclk_ CKN VDD VDD pm1p2_svt_lp L=6e-08 W=3.3e-07
.ENDS

.SUBCKT SDFFNQX3H9R Q VDD VSS CKN D SE SI
MI57_MXNA1 nse SE VSS VSS nm1p2_svt_lp L=6e-08 W=1.5e-07
MXN3 n1 nse VSS VSS nm1p2_svt_lp L=6e-08 W=2e-07
MXN2 nmux D n1 VSS nm1p2_svt_lp L=6e-08 W=2e-07
MI14_MXNOE nmux SE XI14_n1 VSS nm1p2_svt_lp L=6e-08 W=1.5e-07
MI14_MXNA1 XI14_n1 SI VSS VSS nm1p2_svt_lp L=6e-08 W=1.5e-07
MI23_MXNA1 bclk_ nclk_ VSS VSS nm1p2_svt_lp L=6e-08 W=2.2e-07
MI33_MXNOE nm bclk_ nmux VSS nm1p2_svt_lp L=6e-08 W=1.8e-07
MI31_MXNOE nm nclk_ XI31_n1 VSS nm1p2_svt_lp L=6e-08 W=1.5e-07
MI31_MXNA1 XI31_n1 m VSS VSS nm1p2_svt_lp L=6e-08 W=1.5e-07
MI32_MXNA1 m nm VSS VSS nm1p2_svt_lp L=6e-08 W=3.9e-07
MI20_MXNOE s nclk_ m VSS nm1p2_svt_lp L=6e-08 W=1.8e-07
MI29_MXNOE s bclk_ XI29_n1 VSS nm1p2_svt_lp L=6e-08 W=1.5e-07
MI29_MXNA1 XI29_n1 ns VSS VSS nm1p2_svt_lp L=6e-08 W=1.5e-07
MI8_MXNA1 Q ns VSS VSS nm1p2_svt_lp L=6e-08 W=4.2e-07
MI8_MXNA1_2 Q ns VSS VSS nm1p2_svt_lp L=6e-08 W=4.2e-07
MI8_MXNA1_3 Q ns VSS VSS nm1p2_svt_lp L=6e-08 W=4.2e-07
MI28_MXNA1 ns s VSS VSS nm1p2_svt_lp L=6e-08 W=3.1e-07
MI22_MXNA1 nclk_ CKN VSS VSS nm1p2_svt_lp L=6e-08 W=1.8e-07
MI57_MXPA1 nse SE VDD VDD pm1p2_svt_lp L=6e-08 W=2e-07
MXP2 p1 SE VDD VDD pm1p2_svt_lp L=6e-08 W=5e-07
MXP3 nmux D p1 VDD pm1p2_svt_lp L=6e-08 W=5e-07
MI14_MXPOEN nmux nse XI14_p1 VDD pm1p2_svt_lp L=6e-08 W=2e-07
MI14_MXPA1 XI14_p1 SI VDD VDD pm1p2_svt_lp L=6e-08 W=2e-07
MI23_MXPA1 bclk_ nclk_ VDD VDD pm1p2_svt_lp L=6e-08 W=2.4e-07
MI33_MXPOEN nm nclk_ nmux VDD pm1p2_svt_lp L=6e-08 W=5.85e-07
MI31_MXPOEN nm bclk_ XI31_p1 VDD pm1p2_svt_lp L=6e-08 W=1.5e-07
MI31_MXPA1 XI31_p1 m VDD VDD pm1p2_svt_lp L=6e-08 W=1.5e-07
MI32_MXPA1 m nm VDD VDD pm1p2_svt_lp L=6e-08 W=5.05e-07
MI20_MXPOEN s bclk_ m VDD pm1p2_svt_lp L=6e-08 W=5.85e-07
MI29_MXPOEN s nclk_ XI29_p1 VDD pm1p2_svt_lp L=6e-08 W=1.5e-07
MI29_MXPA1 XI29_p1 ns VDD VDD pm1p2_svt_lp L=6e-08 W=1.5e-07
MI8_MXPA1 Q ns VDD VDD pm1p2_svt_lp L=6e-08 W=5.85e-07
MI8_MXPA1_2 Q ns VDD VDD pm1p2_svt_lp L=6e-08 W=5.85e-07
MI8_MXPA1_3 Q ns VDD VDD pm1p2_svt_lp L=6e-08 W=5.85e-07
MI28_MXPA1 ns s VDD VDD pm1p2_svt_lp L=6e-08 W=2.6e-07
MI22_MXPA1 nclk_ CKN VDD VDD pm1p2_svt_lp L=6e-08 W=3.6e-07
.ENDS

.SUBCKT SDFFRPQX0P5H9R Q VDD VSS CK D R SE SI
MI57_MXNA1 nse SE VSS VSS nm1p2_svt_lp L=6e-08 W=1.5e-07
MI14_MXNOE nmux SE XI14_n1 VSS nm1p2_svt_lp L=6e-08 W=1.5e-07
MI14_MXNA1 XI14_n1 SI VSS VSS nm1p2_svt_lp L=6e-08 W=1.5e-07
MXN3 n1 nse VSS VSS nm1p2_svt_lp L=6e-08 W=1.5e-07
MXN2 nmux D n1 VSS nm1p2_svt_lp L=6e-08 W=1.5e-07
MI33_MXNOE nm nclk nmux VSS nm1p2_svt_lp L=6e-08 W=1.5e-07
MI31_MXNOE nm bclk XI31_n1 VSS nm1p2_svt_lp L=6e-08 W=1.5e-07
MI31_MXNA1 XI31_n1 m VSS VSS nm1p2_svt_lp L=6e-08 W=1.5e-07
MI0_MXNA2 m nm VSS VSS nm1p2_svt_lp L=6e-08 W=1.5e-07
MI0_MXNA1 m R VSS VSS nm1p2_svt_lp L=6e-08 W=1.5e-07
MI20_MXNOE s bclk m VSS nm1p2_svt_lp L=6e-08 W=1.5e-07
MXN4 s nclk net62 VSS nm1p2_svt_lp L=6e-08 W=1.5e-07
MXN0 net62 ns VSS VSS nm1p2_svt_lp L=6e-08 W=1.5e-07
MXN1 s R VSS VSS nm1p2_svt_lp L=6e-08 W=1.5e-07
MI28_MXNA1 ns s VSS VSS nm1p2_svt_lp L=6e-08 W=2.6e-07
MI8_MXNA1 Q ns VSS VSS nm1p2_svt_lp L=6e-08 W=2.1e-07
MI23_MXNA1 bclk nclk VSS VSS nm1p2_svt_lp L=6e-08 W=1.5e-07
MI22_MXNA1 nclk CK VSS VSS nm1p2_svt_lp L=6e-08 W=1.5e-07
MI57_MXPA1 nse SE VDD VDD pm1p2_svt_lp L=6e-08 W=2e-07
MI14_MXPOEN nmux nse XI14_p1 VDD pm1p2_svt_lp L=6e-08 W=1.5e-07
MI14_MXPA1 XI14_p1 SI VDD VDD pm1p2_svt_lp L=6e-08 W=1.5e-07
MXP2 p1 SE VDD VDD pm1p2_svt_lp L=6e-08 W=2e-07
MXP3 nmux D p1 VDD pm1p2_svt_lp L=6e-08 W=2e-07
MI33_MXPOEN nm bclk nmux VDD pm1p2_svt_lp L=6e-08 W=1.5e-07
MI31_MXPOEN nm nclk XI31_p1 VDD pm1p2_svt_lp L=6e-08 W=1.5e-07
MI31_MXPA1 XI31_p1 m VDD VDD pm1p2_svt_lp L=6e-08 W=1.5e-07
MI0_MXPA2 XI0_p1 nm VDD VDD pm1p2_svt_lp L=6e-08 W=3e-07
MI0_MXPA1 m R XI0_p1 VDD pm1p2_svt_lp L=6e-08 W=3e-07
MI20_MXPOEN s nclk m VDD pm1p2_svt_lp L=6e-08 W=1.5e-07
MXP1 s bclk net85 VDD pm1p2_svt_lp L=6e-08 W=2e-07
MXP0 net85 ns net77 VDD pm1p2_svt_lp L=6e-08 W=2e-07
MXP5 net77 R VDD VDD pm1p2_svt_lp L=6e-08 W=2e-07
MI28_MXPA1 ns s VDD VDD pm1p2_svt_lp L=6e-08 W=2.2e-07
MI8_MXPA1 Q ns VDD VDD pm1p2_svt_lp L=6e-08 W=2.95e-07
MI23_MXPA1 bclk nclk VDD VDD pm1p2_svt_lp L=6e-08 W=1.9e-07
MI22_MXPA1 nclk CK VDD VDD pm1p2_svt_lp L=6e-08 W=1.7e-07
.ENDS

.SUBCKT SDFFRPQX1H9R Q VDD VSS CK D R SE SI
MI57_MXNA1 nse SE VSS VSS nm1p2_svt_lp L=6e-08 W=1.5e-07
MI14_MXNOE nmux SE XI14_n1 VSS nm1p2_svt_lp L=6e-08 W=1.5e-07
MI14_MXNA1 XI14_n1 SI VSS VSS nm1p2_svt_lp L=6e-08 W=1.5e-07
MXN3 n1 nse VSS VSS nm1p2_svt_lp L=6e-08 W=2.3e-07
MXN2 nmux D n1 VSS nm1p2_svt_lp L=6e-08 W=2.3e-07
MI33_MXNOE nm nclk nmux VSS nm1p2_svt_lp L=6e-08 W=2.6e-07
MI31_MXNOE nm bclk XI31_n1 VSS nm1p2_svt_lp L=6e-08 W=1.5e-07
MI31_MXNA1 XI31_n1 m VSS VSS nm1p2_svt_lp L=6e-08 W=1.5e-07
MI0_MXNA2 m nm VSS VSS nm1p2_svt_lp L=6e-08 W=2e-07
MI0_MXNA1 m R VSS VSS nm1p2_svt_lp L=6e-08 W=2e-07
MI20_MXNOE s bclk m VSS nm1p2_svt_lp L=6e-08 W=2.6e-07
MXN4 s nclk net45 VSS nm1p2_svt_lp L=6e-08 W=1.5e-07
MXN0 net45 ns VSS VSS nm1p2_svt_lp L=6e-08 W=1.5e-07
MXN1 s R VSS VSS nm1p2_svt_lp L=6e-08 W=1.5e-07
MI28_MXNA1 ns s VSS VSS nm1p2_svt_lp L=6e-08 W=2.5e-07
MI8_MXNA1 Q ns VSS VSS nm1p2_svt_lp L=6e-08 W=4.2e-07
MI23_MXNA1 bclk nclk VSS VSS nm1p2_svt_lp L=6e-08 W=1.5e-07
MI22_MXNA1 nclk CK VSS VSS nm1p2_svt_lp L=6e-08 W=1.7e-07
MI57_MXPA1 nse SE VDD VDD pm1p2_svt_lp L=6e-08 W=2e-07
MI14_MXPOEN nmux nse XI14_p1 VDD pm1p2_svt_lp L=6e-08 W=2e-07
MI14_MXPA1 XI14_p1 SI VDD VDD pm1p2_svt_lp L=6e-08 W=2e-07
MXP2 p1 SE VDD VDD pm1p2_svt_lp L=6e-08 W=3.15e-07
MXP3 nmux D p1 VDD pm1p2_svt_lp L=6e-08 W=3.15e-07
MI33_MXPOEN nm bclk nmux VDD pm1p2_svt_lp L=6e-08 W=2.6e-07
MI31_MXPOEN nm nclk XI31_p1 VDD pm1p2_svt_lp L=6e-08 W=1.5e-07
MI31_MXPA1 XI31_p1 m VDD VDD pm1p2_svt_lp L=6e-08 W=1.5e-07
MI0_MXPA2 XI0_p1 nm VDD VDD pm1p2_svt_lp L=6e-08 W=4.3e-07
MI0_MXPA1 m R XI0_p1 VDD pm1p2_svt_lp L=6e-08 W=4.3e-07
MI20_MXPOEN s nclk m VDD pm1p2_svt_lp L=6e-08 W=2.6e-07
MXP1 s bclk net80 VDD pm1p2_svt_lp L=6e-08 W=2e-07
MXP0 net80 ns net72 VDD pm1p2_svt_lp L=6e-08 W=2e-07
MXP5 net72 R VDD VDD pm1p2_svt_lp L=6e-08 W=2e-07
MI28_MXPA1 ns s VDD VDD pm1p2_svt_lp L=6e-08 W=3.5e-07
MI8_MXPA1 Q ns VDD VDD pm1p2_svt_lp L=6e-08 W=5.85e-07
MI23_MXPA1 bclk nclk VDD VDD pm1p2_svt_lp L=6e-08 W=3e-07
MI22_MXPA1 nclk CK VDD VDD pm1p2_svt_lp L=6e-08 W=1.9e-07
.ENDS

.SUBCKT SDFFRPQX2H9R Q VDD VSS CK D R SE SI
MI57_MXNA1 nse SE VSS VSS nm1p2_svt_lp L=6e-08 W=1.5e-07
MI14_MXNOE nmux SE XI14_n1 VSS nm1p2_svt_lp L=6e-08 W=1.5e-07
MI14_MXNA1 XI14_n1 SI VSS VSS nm1p2_svt_lp L=6e-08 W=1.5e-07
MXN3 n1 nse VSS VSS nm1p2_svt_lp L=6e-08 W=3.7e-07
MXN2 nmux D n1 VSS nm1p2_svt_lp L=6e-08 W=3.7e-07
MI33_MXNOE nm nclk nmux VSS nm1p2_svt_lp L=6e-08 W=3.2e-07
MI31_MXNOE nm bclk XI31_n1 VSS nm1p2_svt_lp L=6e-08 W=1.5e-07
MI31_MXNA1 XI31_n1 m VSS VSS nm1p2_svt_lp L=6e-08 W=1.5e-07
MI0_MXNA2 m nm VSS VSS nm1p2_svt_lp L=6e-08 W=2.2e-07
MI0_MXNA1 m R VSS VSS nm1p2_svt_lp L=6e-08 W=2.2e-07
MI20_MXNOE s bclk m VSS nm1p2_svt_lp L=6e-08 W=3.2e-07
MXN4 s nclk net62 VSS nm1p2_svt_lp L=6e-08 W=1.5e-07
MXN0 net62 ns VSS VSS nm1p2_svt_lp L=6e-08 W=1.5e-07
MXN1 s R VSS VSS nm1p2_svt_lp L=6e-08 W=1.5e-07
MI28_MXNA1 ns s VSS VSS nm1p2_svt_lp L=6e-08 W=3.7e-07
MI8_MXNA1 Q ns VSS VSS nm1p2_svt_lp L=6e-08 W=4.2e-07
MI8_MXNA1_2 Q ns VSS VSS nm1p2_svt_lp L=6e-08 W=4.2e-07
MI23_MXNA1 bclk nclk VSS VSS nm1p2_svt_lp L=6e-08 W=1.7e-07
MI22_MXNA1 nclk CK VSS VSS nm1p2_svt_lp L=6e-08 W=2.1e-07
MI57_MXPA1 nse SE VDD VDD pm1p2_svt_lp L=6e-08 W=2e-07
MI14_MXPOEN nmux nse XI14_p1 VDD pm1p2_svt_lp L=6e-08 W=2e-07
MI14_MXPA1 XI14_p1 SI VDD VDD pm1p2_svt_lp L=6e-08 W=2e-07
MXP2 p1 SE VDD VDD pm1p2_svt_lp L=6e-08 W=4.4e-07
MXP3 nmux D p1 VDD pm1p2_svt_lp L=6e-08 W=4.4e-07
MI33_MXPOEN nm bclk nmux VDD pm1p2_svt_lp L=6e-08 W=3.2e-07
MI31_MXPOEN nm nclk XI31_p1 VDD pm1p2_svt_lp L=6e-08 W=1.5e-07
MI31_MXPA1 XI31_p1 m VDD VDD pm1p2_svt_lp L=6e-08 W=1.5e-07
MI0_MXPA2 XI0_p1 nm VDD VDD pm1p2_svt_lp L=6e-08 W=4.7e-07
MI0_MXPA1 m R XI0_p1 VDD pm1p2_svt_lp L=6e-08 W=4.7e-07
MI20_MXPOEN s nclk m VDD pm1p2_svt_lp L=6e-08 W=3.2e-07
MXP1 s bclk net85 VDD pm1p2_svt_lp L=6e-08 W=2e-07
MXP0 net85 ns net77 VDD pm1p2_svt_lp L=6e-08 W=2e-07
MXP5 net77 R VDD VDD pm1p2_svt_lp L=6e-08 W=2e-07
MI28_MXPA1 ns s VDD VDD pm1p2_svt_lp L=6e-08 W=4.8e-07
MI8_MXPA1 Q ns VDD VDD pm1p2_svt_lp L=6e-08 W=5.85e-07
MI8_MXPA1_2 Q ns VDD VDD pm1p2_svt_lp L=6e-08 W=5.85e-07
MI23_MXPA1 bclk nclk VDD VDD pm1p2_svt_lp L=6e-08 W=3.3e-07
MI22_MXPA1 nclk CK VDD VDD pm1p2_svt_lp L=6e-08 W=2.3e-07
.ENDS

.SUBCKT SDFFRPQX3H9R Q VDD VSS CK D R SE SI
MI57_MXNA1 nse SE VSS VSS nm1p2_svt_lp L=6e-08 W=1.5e-07
MI14_MXNOE nmux SE XI14_n1 VSS nm1p2_svt_lp L=6e-08 W=1.5e-07
MI14_MXNA1 XI14_n1 SI VSS VSS nm1p2_svt_lp L=6e-08 W=1.5e-07
MXN3 n1 nse VSS VSS nm1p2_svt_lp L=6e-08 W=4.4e-07
MXN2 nmux D n1 VSS nm1p2_svt_lp L=6e-08 W=4.4e-07
MI33_MXNOE nm nclk nmux VSS nm1p2_svt_lp L=6e-08 W=3.9e-07
MI22_MXNA1 nclk CK VSS VSS nm1p2_svt_lp L=6e-08 W=2.2e-07
MI23_MXNA1 bclk nclk VSS VSS nm1p2_svt_lp L=6e-08 W=1.8e-07
MI31_MXNOE nm bclk XI31_n1 VSS nm1p2_svt_lp L=6e-08 W=1.5e-07
MI31_MXNA1 XI31_n1 m VSS VSS nm1p2_svt_lp L=6e-08 W=1.5e-07
MI0_MXNA2 m nm VSS VSS nm1p2_svt_lp L=6e-08 W=2.6e-07
MI0_MXNA1 m R VSS VSS nm1p2_svt_lp L=6e-08 W=2.6e-07
MI20_MXNOE s bclk m VSS nm1p2_svt_lp L=6e-08 W=3.9e-07
MXN4 s nclk net45 VSS nm1p2_svt_lp L=6e-08 W=1.5e-07
MXN0 net45 ns VSS VSS nm1p2_svt_lp L=6e-08 W=1.5e-07
MXN1 s R VSS VSS nm1p2_svt_lp L=6e-08 W=1.5e-07
MI28_MXNA1 ns s VSS VSS nm1p2_svt_lp L=6e-08 W=4e-07
MI8_MXNA1 Q ns VSS VSS nm1p2_svt_lp L=6e-08 W=4.2e-07
MI8_MXNA1_2 Q ns VSS VSS nm1p2_svt_lp L=6e-08 W=4.2e-07
MI8_MXNA1_3 Q ns VSS VSS nm1p2_svt_lp L=6e-08 W=4.2e-07
MI57_MXPA1 nse SE VDD VDD pm1p2_svt_lp L=6e-08 W=2e-07
MI14_MXPOEN nmux nse XI14_p1 VDD pm1p2_svt_lp L=6e-08 W=2e-07
MI14_MXPA1 XI14_p1 SI VDD VDD pm1p2_svt_lp L=6e-08 W=2e-07
MXP2 p1 SE VDD VDD pm1p2_svt_lp L=6e-08 W=5.1e-07
MXP3 nmux D p1 VDD pm1p2_svt_lp L=6e-08 W=5.1e-07
MI33_MXPOEN nm bclk nmux VDD pm1p2_svt_lp L=6e-08 W=3.9e-07
MI22_MXPA1 nclk CK VDD VDD pm1p2_svt_lp L=6e-08 W=2.4e-07
MI23_MXPA1 bclk nclk VDD VDD pm1p2_svt_lp L=6e-08 W=3.6e-07
MI31_MXPOEN nm nclk XI31_p1 VDD pm1p2_svt_lp L=6e-08 W=1.5e-07
MI31_MXPA1 XI31_p1 m VDD VDD pm1p2_svt_lp L=6e-08 W=1.5e-07
MI0_MXPA2 XI0_p1 nm VDD VDD pm1p2_svt_lp L=6e-08 W=5.2e-07
MI0_MXPA1 m R XI0_p1 VDD pm1p2_svt_lp L=6e-08 W=5.2e-07
MI20_MXPOEN s nclk m VDD pm1p2_svt_lp L=6e-08 W=3.9e-07
MXP1 s bclk net80 VDD pm1p2_svt_lp L=6e-08 W=2e-07
MXP0 net80 ns net72 VDD pm1p2_svt_lp L=6e-08 W=2e-07
MXP5 net72 R VDD VDD pm1p2_svt_lp L=6e-08 W=2e-07
MI28_MXPA1 ns s VDD VDD pm1p2_svt_lp L=6e-08 W=5.5e-07
MI8_MXPA1 Q ns VDD VDD pm1p2_svt_lp L=6e-08 W=5.85e-07
MI8_MXPA1_2 Q ns VDD VDD pm1p2_svt_lp L=6e-08 W=5.85e-07
MI8_MXPA1_3 Q ns VDD VDD pm1p2_svt_lp L=6e-08 W=5.85e-07
.ENDS

.SUBCKT SDFFRPQX4H9R Q VDD VSS CK D R SE SI
MI57_MXNA1 nse SE VSS VSS nm1p2_svt_lp L=6e-08 W=1.5e-07
MI14_MXNOE nmux SE XI14_n1 VSS nm1p2_svt_lp L=6e-08 W=1.5e-07
MI14_MXNA1 XI14_n1 SI VSS VSS nm1p2_svt_lp L=6e-08 W=1.5e-07
MXN3 n1 nse VSS VSS nm1p2_svt_lp L=6e-08 W=4.5e-07
MXN2 nmux D n1 VSS nm1p2_svt_lp L=6e-08 W=4.5e-07
MI33_MXNOE nm nclk nmux VSS nm1p2_svt_lp L=6e-08 W=4.5e-07
MI31_MXNOE nm bclk XI31_n1 VSS nm1p2_svt_lp L=6e-08 W=1.5e-07
MI31_MXNA1 XI31_n1 m VSS VSS nm1p2_svt_lp L=6e-08 W=1.5e-07
MI0_MXNA2 m nm VSS VSS nm1p2_svt_lp L=6e-08 W=2.8e-07
MI0_MXNA1 m R VSS VSS nm1p2_svt_lp L=6e-08 W=2.8e-07
MI20_MXNOE s bclk m VSS nm1p2_svt_lp L=6e-08 W=4.5e-07
MXN4 s nclk net62 VSS nm1p2_svt_lp L=6e-08 W=1.5e-07
MXN0 net62 ns VSS VSS nm1p2_svt_lp L=6e-08 W=1.5e-07
MXN1 s R VSS VSS nm1p2_svt_lp L=6e-08 W=1.5e-07
MI28_MXNA1 ns s VSS VSS nm1p2_svt_lp L=6e-08 W=4.3e-07
MI28_MXNA1_2 ns s VSS VSS nm1p2_svt_lp L=6e-08 W=4.3e-07
MI8_MXNA1 Q ns VSS VSS nm1p2_svt_lp L=6e-08 W=4.2e-07
MI8_MXNA1_2 Q ns VSS VSS nm1p2_svt_lp L=6e-08 W=4.2e-07
MI8_MXNA1_3 Q ns VSS VSS nm1p2_svt_lp L=6e-08 W=4.2e-07
MI8_MXNA1_4 Q ns VSS VSS nm1p2_svt_lp L=6e-08 W=4.2e-07
MI23_MXNA1 bclk nclk VSS VSS nm1p2_svt_lp L=6e-08 W=2.1e-07
MI22_MXNA1 nclk CK VSS VSS nm1p2_svt_lp L=6e-08 W=2.5e-07
MI57_MXPA1 nse SE VDD VDD pm1p2_svt_lp L=6e-08 W=2e-07
MI14_MXPOEN nmux nse XI14_p1 VDD pm1p2_svt_lp L=6e-08 W=2e-07
MI14_MXPA1 XI14_p1 SI VDD VDD pm1p2_svt_lp L=6e-08 W=2e-07
MXP2 p1 SE VDD VDD pm1p2_svt_lp L=6e-08 W=5.6e-07
MXP3 nmux D p1 VDD pm1p2_svt_lp L=6e-08 W=5.6e-07
MI33_MXPOEN nm bclk nmux VDD pm1p2_svt_lp L=6e-08 W=4.5e-07
MI31_MXPOEN nm nclk XI31_p1 VDD pm1p2_svt_lp L=6e-08 W=1.5e-07
MI31_MXPA1 XI31_p1 m VDD VDD pm1p2_svt_lp L=6e-08 W=1.5e-07
MI0_MXPA2 XI0_p1 nm VDD VDD pm1p2_svt_lp L=6e-08 W=5.85e-07
MI0_MXPA1 m R XI0_p1 VDD pm1p2_svt_lp L=6e-08 W=5.85e-07
MI20_MXPOEN s nclk m VDD pm1p2_svt_lp L=6e-08 W=4.5e-07
MXP1 s bclk net85 VDD pm1p2_svt_lp L=6e-08 W=2e-07
MXP0 net85 ns net77 VDD pm1p2_svt_lp L=6e-08 W=2e-07
MXP5 net77 R VDD VDD pm1p2_svt_lp L=6e-08 W=2e-07
MI28_MXPA1 ns s VDD VDD pm1p2_svt_lp L=6e-08 W=4.45e-07
MI28_MXPA1_2 ns s VDD VDD pm1p2_svt_lp L=6e-08 W=4.45e-07
MI8_MXPA1 Q ns VDD VDD pm1p2_svt_lp L=6e-08 W=5.85e-07
MI8_MXPA1_2 Q ns VDD VDD pm1p2_svt_lp L=6e-08 W=5.85e-07
MI8_MXPA1_3 Q ns VDD VDD pm1p2_svt_lp L=6e-08 W=5.85e-07
MI8_MXPA1_4 Q ns VDD VDD pm1p2_svt_lp L=6e-08 W=5.85e-07
MI23_MXPA1 bclk nclk VDD VDD pm1p2_svt_lp L=6e-08 W=4.2e-07
MI22_MXPA1 nclk CK VDD VDD pm1p2_svt_lp L=6e-08 W=2.8e-07
.ENDS

.SUBCKT SDFFRPQNX0P5H9R QN VDD VSS CK D R SE SI
MI57_MXNA1 nse SE VSS VSS nm1p2_svt_lp L=6e-08 W=1.5e-07
MI14_MXNOE nmux SE XI14_n1 VSS nm1p2_svt_lp L=6e-08 W=1.5e-07
MI14_MXNA1 XI14_n1 SI VSS VSS nm1p2_svt_lp L=6e-08 W=1.5e-07
MXN3 n1 nse VSS VSS nm1p2_svt_lp L=6e-08 W=2e-07
MXN2 nmux D n1 VSS nm1p2_svt_lp L=6e-08 W=2e-07
MI33_MXNOE nm nclk nmux VSS nm1p2_svt_lp L=6e-08 W=1.5e-07
MI31_MXNOE nm bclk XI31_n1 VSS nm1p2_svt_lp L=6e-08 W=1.5e-07
MI31_MXNA1 XI31_n1 m VSS VSS nm1p2_svt_lp L=6e-08 W=1.5e-07
MI0_MXNA2 m nm VSS VSS nm1p2_svt_lp L=6e-08 W=1.5e-07
MI0_MXNA1 m R VSS VSS nm1p2_svt_lp L=6e-08 W=1.5e-07
MI20_MXNOE s bclk m VSS nm1p2_svt_lp L=6e-08 W=1.5e-07
MXN6 s nclk net53 VSS nm1p2_svt_lp L=6e-08 W=1.5e-07
MXN5 net53 ns VSS VSS nm1p2_svt_lp L=6e-08 W=1.5e-07
MXN7 s R VSS VSS nm1p2_svt_lp L=6e-08 W=1.5e-07
MI78_MXNA1 ns s VSS VSS nm1p2_svt_lp L=6e-08 W=1.2e-07
MI8_MXNA1 QN s VSS VSS nm1p2_svt_lp L=6e-08 W=2.1e-07
MI23_MXNA1 bclk nclk VSS VSS nm1p2_svt_lp L=6e-08 W=1.5e-07
MI22_MXNA1 nclk CK VSS VSS nm1p2_svt_lp L=6e-08 W=1.5e-07
MI57_MXPA1 nse SE VDD VDD pm1p2_svt_lp L=6e-08 W=2e-07
MI14_MXPOEN nmux nse XI14_p1 VDD pm1p2_svt_lp L=6e-08 W=1.5e-07
MI14_MXPA1 XI14_p1 SI VDD VDD pm1p2_svt_lp L=6e-08 W=1.5e-07
MXP2 p1 SE VDD VDD pm1p2_svt_lp L=6e-08 W=2.8e-07
MXP3 nmux D p1 VDD pm1p2_svt_lp L=6e-08 W=2.8e-07
MI33_MXPOEN nm bclk nmux VDD pm1p2_svt_lp L=6e-08 W=1.5e-07
MI31_MXPOEN nm nclk XI31_p1 VDD pm1p2_svt_lp L=6e-08 W=1.5e-07
MI31_MXPA1 XI31_p1 m VDD VDD pm1p2_svt_lp L=6e-08 W=1.5e-07
MI0_MXPA2 XI0_p1 nm VDD VDD pm1p2_svt_lp L=6e-08 W=4.3e-07
MI0_MXPA1 m R XI0_p1 VDD pm1p2_svt_lp L=6e-08 W=4.3e-07
MI20_MXPOEN s nclk m VDD pm1p2_svt_lp L=6e-08 W=1.5e-07
MXP7 s bclk net74 VDD pm1p2_svt_lp L=6e-08 W=2e-07
MXP4 net74 ns net78 VDD pm1p2_svt_lp L=6e-08 W=2e-07
MXP6 net78 R VDD VDD pm1p2_svt_lp L=6e-08 W=2e-07
MI78_MXPA1 ns s VDD VDD pm1p2_svt_lp L=6e-08 W=1.2e-07
MI8_MXPA1 QN s VDD VDD pm1p2_svt_lp L=6e-08 W=2.95e-07
MI23_MXPA1 bclk nclk VDD VDD pm1p2_svt_lp L=6e-08 W=1.9e-07
MI22_MXPA1 nclk CK VDD VDD pm1p2_svt_lp L=6e-08 W=1.7e-07
.ENDS

.SUBCKT SDFFRPQNX1H9R QN VDD VSS CK D R SE SI
MI57_MXNA1 nse SE VSS VSS nm1p2_svt_lp L=6e-08 W=1.5e-07
MI14_MXNOE nmux SE XI14_n1 VSS nm1p2_svt_lp L=6e-08 W=1.5e-07
MI14_MXNA1 XI14_n1 SI VSS VSS nm1p2_svt_lp L=6e-08 W=1.5e-07
MXN3 n1 nse VSS VSS nm1p2_svt_lp L=6e-08 W=2.4e-07
MXN2 nmux D n1 VSS nm1p2_svt_lp L=6e-08 W=2.4e-07
MI33_MXNOE nm nclk nmux VSS nm1p2_svt_lp L=6e-08 W=2.6e-07
MI31_MXNOE nm bclk XI31_n1 VSS nm1p2_svt_lp L=6e-08 W=1.5e-07
MI31_MXNA1 XI31_n1 m VSS VSS nm1p2_svt_lp L=6e-08 W=1.5e-07
MI0_MXNA2 m nm VSS VSS nm1p2_svt_lp L=6e-08 W=2.15e-07
MI0_MXNA1 m R VSS VSS nm1p2_svt_lp L=6e-08 W=2.15e-07
MI20_MXNOE s bclk m VSS nm1p2_svt_lp L=6e-08 W=2.6e-07
MXN6 s nclk net53 VSS nm1p2_svt_lp L=6e-08 W=1.5e-07
MXN5 net53 ns VSS VSS nm1p2_svt_lp L=6e-08 W=1.5e-07
MXN7 s R VSS VSS nm1p2_svt_lp L=6e-08 W=1.5e-07
MI78_MXNA1 ns s VSS VSS nm1p2_svt_lp L=6e-08 W=1.2e-07
MI8_MXNA1 QN s VSS VSS nm1p2_svt_lp L=6e-08 W=4.2e-07
MI23_MXNA1 bclk nclk VSS VSS nm1p2_svt_lp L=6e-08 W=1.5e-07
MI22_MXNA1 nclk CK VSS VSS nm1p2_svt_lp L=6e-08 W=1.7e-07
MI57_MXPA1 nse SE VDD VDD pm1p2_svt_lp L=6e-08 W=2e-07
MI14_MXPOEN nmux nse XI14_p1 VDD pm1p2_svt_lp L=6e-08 W=2e-07
MI14_MXPA1 XI14_p1 SI VDD VDD pm1p2_svt_lp L=6e-08 W=2e-07
MXP2 p1 SE VDD VDD pm1p2_svt_lp L=6e-08 W=3.4e-07
MXP3 nmux D p1 VDD pm1p2_svt_lp L=6e-08 W=3.4e-07
MI33_MXPOEN nm bclk nmux VDD pm1p2_svt_lp L=6e-08 W=2.6e-07
MI31_MXPOEN nm nclk XI31_p1 VDD pm1p2_svt_lp L=6e-08 W=1.5e-07
MI31_MXPA1 XI31_p1 m VDD VDD pm1p2_svt_lp L=6e-08 W=1.5e-07
MI0_MXPA2 XI0_p1 nm VDD VDD pm1p2_svt_lp L=6e-08 W=5e-07
MI0_MXPA1 m R XI0_p1 VDD pm1p2_svt_lp L=6e-08 W=5e-07
MI20_MXPOEN s nclk m VDD pm1p2_svt_lp L=6e-08 W=2.6e-07
MXP7 s bclk net74 VDD pm1p2_svt_lp L=6e-08 W=2e-07
MXP4 net74 ns net78 VDD pm1p2_svt_lp L=6e-08 W=2e-07
MXP6 net78 R VDD VDD pm1p2_svt_lp L=6e-08 W=2e-07
MI78_MXPA1 ns s VDD VDD pm1p2_svt_lp L=6e-08 W=1.2e-07
MI8_MXPA1 QN s VDD VDD pm1p2_svt_lp L=6e-08 W=5.85e-07
MI23_MXPA1 bclk nclk VDD VDD pm1p2_svt_lp L=6e-08 W=3e-07
MI22_MXPA1 nclk CK VDD VDD pm1p2_svt_lp L=6e-08 W=1.9e-07
.ENDS

.SUBCKT SDFFRPQNX2H9R QN VDD VSS CK D R SE SI
MI57_MXNA1 nse SE VSS VSS nm1p2_svt_lp L=6e-08 W=1.5e-07
MI14_MXNOE nmux SE XI14_n1 VSS nm1p2_svt_lp L=6e-08 W=1.5e-07
MI14_MXNA1 XI14_n1 SI VSS VSS nm1p2_svt_lp L=6e-08 W=1.5e-07
MXN3 n1 nse VSS VSS nm1p2_svt_lp L=6e-08 W=3.3e-07
MXN2 nmux D n1 VSS nm1p2_svt_lp L=6e-08 W=3.3e-07
MI33_MXNOE nm nclk nmux VSS nm1p2_svt_lp L=6e-08 W=3.2e-07
MI31_MXNOE nm bclk XI31_n1 VSS nm1p2_svt_lp L=6e-08 W=1.5e-07
MI31_MXNA1 XI31_n1 m VSS VSS nm1p2_svt_lp L=6e-08 W=1.5e-07
MI0_MXNA2 m nm VSS VSS nm1p2_svt_lp L=6e-08 W=1.85e-07
MI0_MXNA1 m R VSS VSS nm1p2_svt_lp L=6e-08 W=1.85e-07
MI20_MXNOE s bclk m VSS nm1p2_svt_lp L=6e-08 W=3.2e-07
MXN6 s nclk net53 VSS nm1p2_svt_lp L=6e-08 W=1.5e-07
MXN5 net53 ns VSS VSS nm1p2_svt_lp L=6e-08 W=1.5e-07
MXN7 s R VSS VSS nm1p2_svt_lp L=6e-08 W=1.5e-07
MI78_MXNA1 ns s VSS VSS nm1p2_svt_lp L=6e-08 W=1.2e-07
MI8_MXNA1 QN s VSS VSS nm1p2_svt_lp L=6e-08 W=4.2e-07
MI8_MXNA1_2 QN s VSS VSS nm1p2_svt_lp L=6e-08 W=4.2e-07
MI23_MXNA1 bclk nclk VSS VSS nm1p2_svt_lp L=6e-08 W=1.7e-07
MI22_MXNA1 nclk CK VSS VSS nm1p2_svt_lp L=6e-08 W=2.1e-07
MI57_MXPA1 nse SE VDD VDD pm1p2_svt_lp L=6e-08 W=2e-07
MI14_MXPOEN nmux nse XI14_p1 VDD pm1p2_svt_lp L=6e-08 W=2e-07
MI14_MXPA1 XI14_p1 SI VDD VDD pm1p2_svt_lp L=6e-08 W=2e-07
MXP2 p1 SE VDD VDD pm1p2_svt_lp L=6e-08 W=5.25e-07
MXP3 nmux D p1 VDD pm1p2_svt_lp L=6e-08 W=5.25e-07
MI33_MXPOEN nm bclk nmux VDD pm1p2_svt_lp L=6e-08 W=3.2e-07
MI31_MXPOEN nm nclk XI31_p1 VDD pm1p2_svt_lp L=6e-08 W=1.5e-07
MI31_MXPA1 XI31_p1 m VDD VDD pm1p2_svt_lp L=6e-08 W=1.5e-07
MI0_MXPA2 XI0_p1 nm VDD VDD pm1p2_svt_lp L=6e-08 W=5.7e-07
MI0_MXPA1 m R XI0_p1 VDD pm1p2_svt_lp L=6e-08 W=5.7e-07
MI20_MXPOEN s nclk m VDD pm1p2_svt_lp L=6e-08 W=3.2e-07
MXP7 s bclk net74 VDD pm1p2_svt_lp L=6e-08 W=2e-07
MXP4 net74 ns net78 VDD pm1p2_svt_lp L=6e-08 W=2e-07
MXP6 net78 R VDD VDD pm1p2_svt_lp L=6e-08 W=2e-07
MI78_MXPA1 ns s VDD VDD pm1p2_svt_lp L=6e-08 W=1.2e-07
MI8_MXPA1 QN s VDD VDD pm1p2_svt_lp L=6e-08 W=5.85e-07
MI8_MXPA1_2 QN s VDD VDD pm1p2_svt_lp L=6e-08 W=5.85e-07
MI23_MXPA1 bclk nclk VDD VDD pm1p2_svt_lp L=6e-08 W=3.3e-07
MI22_MXPA1 nclk CK VDD VDD pm1p2_svt_lp L=6e-08 W=2.3e-07
.ENDS

.SUBCKT SDFFRPQNX3H9R QN VDD VSS CK D R SE SI
MI57_MXNA1 nse SE VSS VSS nm1p2_svt_lp L=6e-08 W=1.5e-07
MI14_MXNOE nmux SE XI14_n1 VSS nm1p2_svt_lp L=6e-08 W=1.5e-07
MI14_MXNA1 XI14_n1 SI VSS VSS nm1p2_svt_lp L=6e-08 W=1.5e-07
MXN3 n1 nse VSS VSS nm1p2_svt_lp L=6e-08 W=3e-07
MXN2 nmux D n1 VSS nm1p2_svt_lp L=6e-08 W=3e-07
MI33_MXNOE nm nclk nmux VSS nm1p2_svt_lp L=6e-08 W=3.9e-07
MI31_MXNOE nm bclk XI31_n1 VSS nm1p2_svt_lp L=6e-08 W=1.5e-07
MI31_MXNA1 XI31_n1 m VSS VSS nm1p2_svt_lp L=6e-08 W=1.5e-07
MI0_MXNA2 m nm VSS VSS nm1p2_svt_lp L=6e-08 W=1.6e-07
MI0_MXNA1 m R VSS VSS nm1p2_svt_lp L=6e-08 W=1.6e-07
MI20_MXNOE s bclk m VSS nm1p2_svt_lp L=6e-08 W=3.9e-07
MXN6 s nclk net53 VSS nm1p2_svt_lp L=6e-08 W=1.5e-07
MXN5 net53 ns VSS VSS nm1p2_svt_lp L=6e-08 W=1.5e-07
MXN7 s R VSS VSS nm1p2_svt_lp L=6e-08 W=1.5e-07
MI78_MXNA1 ns s VSS VSS nm1p2_svt_lp L=6e-08 W=1.2e-07
MI8_MXNA1 QN s VSS VSS nm1p2_svt_lp L=6e-08 W=4.2e-07
MI8_MXNA1_2 QN s VSS VSS nm1p2_svt_lp L=6e-08 W=4.2e-07
MI8_MXNA1_3 QN s VSS VSS nm1p2_svt_lp L=6e-08 W=4.2e-07
MI23_MXNA1 bclk nclk VSS VSS nm1p2_svt_lp L=6e-08 W=1.8e-07
MI22_MXNA1 nclk CK VSS VSS nm1p2_svt_lp L=6e-08 W=2.2e-07
MI57_MXPA1 nse SE VDD VDD pm1p2_svt_lp L=6e-08 W=2e-07
MI14_MXPOEN nmux nse XI14_p1 VDD pm1p2_svt_lp L=6e-08 W=2e-07
MI14_MXPA1 XI14_p1 SI VDD VDD pm1p2_svt_lp L=6e-08 W=2e-07
MXP2 p1 SE VDD VDD pm1p2_svt_lp L=6e-08 W=5.6e-07
MXP3 nmux D p1 VDD pm1p2_svt_lp L=6e-08 W=5.6e-07
MI33_MXPOEN nm bclk nmux VDD pm1p2_svt_lp L=6e-08 W=3.9e-07
MI31_MXPOEN nm nclk XI31_p1 VDD pm1p2_svt_lp L=6e-08 W=1.5e-07
MI31_MXPA1 XI31_p1 m VDD VDD pm1p2_svt_lp L=6e-08 W=1.5e-07
MI0_MXPA2 XI0_p1 nm VDD VDD pm1p2_svt_lp L=6e-08 W=5.85e-07
MI0_MXPA1 m R XI0_p1 VDD pm1p2_svt_lp L=6e-08 W=5.85e-07
MI20_MXPOEN s nclk m VDD pm1p2_svt_lp L=6e-08 W=3.9e-07
MXP7 s bclk net74 VDD pm1p2_svt_lp L=6e-08 W=2e-07
MXP4 net74 ns net78 VDD pm1p2_svt_lp L=6e-08 W=2e-07
MXP6 net78 R VDD VDD pm1p2_svt_lp L=6e-08 W=2e-07
MI78_MXPA1 ns s VDD VDD pm1p2_svt_lp L=6e-08 W=1.2e-07
MI8_MXPA1 QN s VDD VDD pm1p2_svt_lp L=6e-08 W=5.85e-07
MI8_MXPA1_2 QN s VDD VDD pm1p2_svt_lp L=6e-08 W=5.85e-07
MI8_MXPA1_3 QN s VDD VDD pm1p2_svt_lp L=6e-08 W=5.85e-07
MI23_MXPA1 bclk nclk VDD VDD pm1p2_svt_lp L=6e-08 W=3.6e-07
MI22_MXPA1 nclk CK VDD VDD pm1p2_svt_lp L=6e-08 W=2.4e-07
.ENDS

.SUBCKT SDFFNRPQX1H9R Q VDD VSS CKN D R SE SI
MI57_MXNA1 nse SE VSS VSS nm1p2_svt_lp L=6e-08 W=1.5e-07
MI14_MXNOE nmux SE XI14_n1 VSS nm1p2_svt_lp L=6e-08 W=1.5e-07
MI14_MXNA1 XI14_n1 SI VSS VSS nm1p2_svt_lp L=6e-08 W=1.5e-07
MXN3 n1 nse VSS VSS nm1p2_svt_lp L=6e-08 W=1.6e-07
MXN2 nmux D n1 VSS nm1p2_svt_lp L=6e-08 W=1.6e-07
MI33_MXNOE nm bclk_ nmux VSS nm1p2_svt_lp L=6e-08 W=1.5e-07
MI31_MXNOE nm nclk_ XI31_n1 VSS nm1p2_svt_lp L=6e-08 W=1.5e-07
MI31_MXNA1 XI31_n1 m VSS VSS nm1p2_svt_lp L=6e-08 W=1.5e-07
MI0_MXNA2 m nm VSS VSS nm1p2_svt_lp L=6e-08 W=1.6e-07
MI0_MXNA1 m R VSS VSS nm1p2_svt_lp L=6e-08 W=1.6e-07
MI20_MXNOE s nclk_ m VSS nm1p2_svt_lp L=6e-08 W=1.5e-07
MXN4 s bclk_ net62 VSS nm1p2_svt_lp L=6e-08 W=1.5e-07
MXN0 net62 ns VSS VSS nm1p2_svt_lp L=6e-08 W=1.5e-07
MXN1 s R VSS VSS nm1p2_svt_lp L=6e-08 W=1.5e-07
MI28_MXNA1 ns s VSS VSS nm1p2_svt_lp L=6e-08 W=2.25e-07
MI8_MXNA1 Q ns VSS VSS nm1p2_svt_lp L=6e-08 W=4.2e-07
MI23_MXNA1 bclk_ nclk_ VSS VSS nm1p2_svt_lp L=6e-08 W=1.7e-07
MI22_MXNA1 nclk_ CKN VSS VSS nm1p2_svt_lp L=6e-08 W=1.5e-07
MI57_MXPA1 nse SE VDD VDD pm1p2_svt_lp L=6e-08 W=2e-07
MI14_MXPOEN nmux nse XI14_p1 VDD pm1p2_svt_lp L=6e-08 W=2e-07
MI14_MXPA1 XI14_p1 SI VDD VDD pm1p2_svt_lp L=6e-08 W=2e-07
MXP2 p1 SE VDD VDD pm1p2_svt_lp L=6e-08 W=4e-07
MXP3 nmux D p1 VDD pm1p2_svt_lp L=6e-08 W=4e-07
MI33_MXPOEN nm nclk_ nmux VDD pm1p2_svt_lp L=6e-08 W=3.6e-07
MI31_MXPOEN nm bclk_ XI31_p1 VDD pm1p2_svt_lp L=6e-08 W=1.5e-07
MI31_MXPA1 XI31_p1 m VDD VDD pm1p2_svt_lp L=6e-08 W=1.5e-07
MI0_MXPA2 XI0_p1 nm VDD VDD pm1p2_svt_lp L=6e-08 W=4.3e-07
MI0_MXPA1 m R XI0_p1 VDD pm1p2_svt_lp L=6e-08 W=4.3e-07
MI20_MXPOEN s bclk_ m VDD pm1p2_svt_lp L=6e-08 W=3.6e-07
MXP1 s nclk_ net85 VDD pm1p2_svt_lp L=6e-08 W=2e-07
MXP0 net85 ns net77 VDD pm1p2_svt_lp L=6e-08 W=2e-07
MXP5 net77 R VDD VDD pm1p2_svt_lp L=6e-08 W=2e-07
MI28_MXPA1 ns s VDD VDD pm1p2_svt_lp L=6e-08 W=1.5e-07
MI8_MXPA1 Q ns VDD VDD pm1p2_svt_lp L=6e-08 W=5.85e-07
MI23_MXPA1 bclk_ nclk_ VDD VDD pm1p2_svt_lp L=6e-08 W=1.9e-07
MI22_MXPA1 nclk_ CKN VDD VDD pm1p2_svt_lp L=6e-08 W=3e-07
.ENDS

.SUBCKT SDFFNRPQX2H9R Q VDD VSS CKN D R SE SI
MI57_MXNA1 nse SE VSS VSS nm1p2_svt_lp L=6e-08 W=1.5e-07
MI14_MXNOE nmux SE XI14_n1 VSS nm1p2_svt_lp L=6e-08 W=1.5e-07
MI14_MXNA1 XI14_n1 SI VSS VSS nm1p2_svt_lp L=6e-08 W=1.5e-07
MXN3 n1 nse VSS VSS nm1p2_svt_lp L=6e-08 W=1.8e-07
MXN2 nmux D n1 VSS nm1p2_svt_lp L=6e-08 W=1.8e-07
MI33_MXNOE nm bclk_ nmux VSS nm1p2_svt_lp L=6e-08 W=1.8e-07
MI31_MXNOE nm nclk_ XI31_n1 VSS nm1p2_svt_lp L=6e-08 W=1.5e-07
MI31_MXNA1 XI31_n1 m VSS VSS nm1p2_svt_lp L=6e-08 W=1.5e-07
MI0_MXNA2 m nm VSS VSS nm1p2_svt_lp L=6e-08 W=2e-07
MI0_MXNA1 m R VSS VSS nm1p2_svt_lp L=6e-08 W=2e-07
MI20_MXNOE s nclk_ m VSS nm1p2_svt_lp L=6e-08 W=1.8e-07
MXN4 s bclk_ net62 VSS nm1p2_svt_lp L=6e-08 W=1.5e-07
MXN0 net62 ns VSS VSS nm1p2_svt_lp L=6e-08 W=1.5e-07
MXN1 s R VSS VSS nm1p2_svt_lp L=6e-08 W=1.5e-07
MI28_MXNA1 ns s VSS VSS nm1p2_svt_lp L=6e-08 W=2e-07
MI8_MXNA1 Q ns VSS VSS nm1p2_svt_lp L=6e-08 W=4.2e-07
MI8_MXNA1_2 Q ns VSS VSS nm1p2_svt_lp L=6e-08 W=4.2e-07
MI23_MXNA1 bclk_ nclk_ VSS VSS nm1p2_svt_lp L=6e-08 W=2.1e-07
MI22_MXNA1 nclk_ CKN VSS VSS nm1p2_svt_lp L=6e-08 W=1.7e-07
MI57_MXPA1 nse SE VDD VDD pm1p2_svt_lp L=6e-08 W=2e-07
MI14_MXPOEN nmux nse XI14_p1 VDD pm1p2_svt_lp L=6e-08 W=2e-07
MI14_MXPA1 XI14_p1 SI VDD VDD pm1p2_svt_lp L=6e-08 W=2e-07
MXP2 p1 SE VDD VDD pm1p2_svt_lp L=6e-08 W=4.3e-07
MXP3 nmux D p1 VDD pm1p2_svt_lp L=6e-08 W=4.3e-07
MI33_MXPOEN nm nclk_ nmux VDD pm1p2_svt_lp L=6e-08 W=4.5e-07
MI31_MXPOEN nm bclk_ XI31_p1 VDD pm1p2_svt_lp L=6e-08 W=1.5e-07
MI31_MXPA1 XI31_p1 m VDD VDD pm1p2_svt_lp L=6e-08 W=1.5e-07
MI0_MXPA2 XI0_p1 nm VDD VDD pm1p2_svt_lp L=6e-08 W=5e-07
MI0_MXPA1 m R XI0_p1 VDD pm1p2_svt_lp L=6e-08 W=5e-07
MI20_MXPOEN s bclk_ m VDD pm1p2_svt_lp L=6e-08 W=4.5e-07
MXP1 s nclk_ net85 VDD pm1p2_svt_lp L=6e-08 W=2e-07
MXP0 net85 ns net77 VDD pm1p2_svt_lp L=6e-08 W=2e-07
MXP5 net77 R VDD VDD pm1p2_svt_lp L=6e-08 W=2e-07
MI28_MXPA1 ns s VDD VDD pm1p2_svt_lp L=6e-08 W=1.7e-07
MI8_MXPA1 Q ns VDD VDD pm1p2_svt_lp L=6e-08 W=5.85e-07
MI8_MXPA1_2 Q ns VDD VDD pm1p2_svt_lp L=6e-08 W=5.85e-07
MI23_MXPA1 bclk_ nclk_ VDD VDD pm1p2_svt_lp L=6e-08 W=2.3e-07
MI22_MXPA1 nclk_ CKN VDD VDD pm1p2_svt_lp L=6e-08 W=3.3e-07
.ENDS

.SUBCKT SDFFNRPQX3H9R Q VDD VSS CKN D R SE SI
MI57_MXNA1 nse SE VSS VSS nm1p2_svt_lp L=6e-08 W=1.5e-07
MI14_MXNOE nmux SE XI14_n1 VSS nm1p2_svt_lp L=6e-08 W=1.5e-07
MI14_MXNA1 XI14_n1 SI VSS VSS nm1p2_svt_lp L=6e-08 W=1.5e-07
MXN3 n1 nse VSS VSS nm1p2_svt_lp L=6e-08 W=2e-07
MXN2 nmux D n1 VSS nm1p2_svt_lp L=6e-08 W=2e-07
MI33_MXNOE nm bclk_ nmux VSS nm1p2_svt_lp L=6e-08 W=1.8e-07
MI31_MXNOE nm nclk_ XI31_n1 VSS nm1p2_svt_lp L=6e-08 W=1.5e-07
MI31_MXNA1 XI31_n1 m VSS VSS nm1p2_svt_lp L=6e-08 W=1.5e-07
MI0_MXNA2 m nm VSS VSS nm1p2_svt_lp L=6e-08 W=1.7e-07
MI0_MXNA1 m R VSS VSS nm1p2_svt_lp L=6e-08 W=1.7e-07
MI20_MXNOE s nclk_ m VSS nm1p2_svt_lp L=6e-08 W=1.8e-07
MXN4 s bclk_ net62 VSS nm1p2_svt_lp L=6e-08 W=1.5e-07
MXN0 net62 ns VSS VSS nm1p2_svt_lp L=6e-08 W=1.5e-07
MXN1 s R VSS VSS nm1p2_svt_lp L=6e-08 W=1.5e-07
MI28_MXNA1 ns s VSS VSS nm1p2_svt_lp L=6e-08 W=3.4e-07
MI8_MXNA1 Q ns VSS VSS nm1p2_svt_lp L=6e-08 W=4.2e-07
MI8_MXNA1_2 Q ns VSS VSS nm1p2_svt_lp L=6e-08 W=4.2e-07
MI8_MXNA1_3 Q ns VSS VSS nm1p2_svt_lp L=6e-08 W=4.2e-07
MI23_MXNA1 bclk_ nclk_ VSS VSS nm1p2_svt_lp L=6e-08 W=2.2e-07
MI22_MXNA1 nclk_ CKN VSS VSS nm1p2_svt_lp L=6e-08 W=1.8e-07
MI57_MXPA1 nse SE VDD VDD pm1p2_svt_lp L=6e-08 W=2e-07
MI14_MXPOEN nmux nse XI14_p1 VDD pm1p2_svt_lp L=6e-08 W=2e-07
MI14_MXPA1 XI14_p1 SI VDD VDD pm1p2_svt_lp L=6e-08 W=2e-07
MXP2 p1 SE VDD VDD pm1p2_svt_lp L=6e-08 W=5e-07
MXP3 nmux D p1 VDD pm1p2_svt_lp L=6e-08 W=5e-07
MI33_MXPOEN nm nclk_ nmux VDD pm1p2_svt_lp L=6e-08 W=5.85e-07
MI31_MXPOEN nm bclk_ XI31_p1 VDD pm1p2_svt_lp L=6e-08 W=1.5e-07
MI31_MXPA1 XI31_p1 m VDD VDD pm1p2_svt_lp L=6e-08 W=1.5e-07
MI0_MXPA2 XI0_p1 nm VDD VDD pm1p2_svt_lp L=6e-08 W=5.5e-07
MI0_MXPA1 m R XI0_p1 VDD pm1p2_svt_lp L=6e-08 W=5.5e-07
MI20_MXPOEN s bclk_ m VDD pm1p2_svt_lp L=6e-08 W=5.85e-07
MXP1 s nclk_ net85 VDD pm1p2_svt_lp L=6e-08 W=2e-07
MXP0 net85 ns net77 VDD pm1p2_svt_lp L=6e-08 W=2e-07
MXP5 net77 R VDD VDD pm1p2_svt_lp L=6e-08 W=2e-07
MI28_MXPA1 ns s VDD VDD pm1p2_svt_lp L=6e-08 W=3e-07
MI8_MXPA1 Q ns VDD VDD pm1p2_svt_lp L=6e-08 W=5.85e-07
MI8_MXPA1_2 Q ns VDD VDD pm1p2_svt_lp L=6e-08 W=5.85e-07
MI8_MXPA1_3 Q ns VDD VDD pm1p2_svt_lp L=6e-08 W=5.85e-07
MI23_MXPA1 bclk_ nclk_ VDD VDD pm1p2_svt_lp L=6e-08 W=2.4e-07
MI22_MXPA1 nclk_ CKN VDD VDD pm1p2_svt_lp L=6e-08 W=3.6e-07
.ENDS

.SUBCKT SDFFSQX0P5H9R Q VDD VSS CK D SE SI SN
MI57_MXNA1 nse SE VSS VSS nm1p2_svt_lp L=6e-08 W=1.5e-07
MI14_MXNOE nmux SE XI14_n1 VSS nm1p2_svt_lp L=6e-08 W=1.5e-07
MI14_MXNA1 XI14_n1 SI VSS VSS nm1p2_svt_lp L=6e-08 W=1.5e-07
MXN3 n1 nse VSS VSS nm1p2_svt_lp L=6e-08 W=1.6e-07
MXN2 nmux D n1 VSS nm1p2_svt_lp L=6e-08 W=1.6e-07
MI33_MXNOE nm nclk nmux VSS nm1p2_svt_lp L=6e-08 W=1.5e-07
MI31_MXNOE nm bclk XI31_n1 VSS nm1p2_svt_lp L=6e-08 W=1.5e-07
MI31_MXNA1 XI31_n1 m VSS VSS nm1p2_svt_lp L=6e-08 W=1.5e-07
MI0_MXNA2 XI0_n1 nm VSS VSS nm1p2_svt_lp L=6e-08 W=2e-07
MI0_MXNA1 m SN XI0_n1 VSS nm1p2_svt_lp L=6e-08 W=2e-07
MI20_MXNOE s bclk m VSS nm1p2_svt_lp L=6e-08 W=1.5e-07
MXN4 s nclk net54 VSS nm1p2_svt_lp L=6e-08 W=2e-07
MXN0 net54 ns net50 VSS nm1p2_svt_lp L=6e-08 W=2e-07
MXN1 net50 SN VSS VSS nm1p2_svt_lp L=6e-08 W=2e-07
MI28_MXNA1 ns s VSS VSS nm1p2_svt_lp L=6e-08 W=2.4e-07
MI8_MXNA1 Q ns VSS VSS nm1p2_svt_lp L=6e-08 W=2.1e-07
MI23_MXNA1 bclk nclk VSS VSS nm1p2_svt_lp L=6e-08 W=1.5e-07
MI22_MXNA1 nclk CK VSS VSS nm1p2_svt_lp L=6e-08 W=1.5e-07
MI57_MXPA1 nse SE VDD VDD pm1p2_svt_lp L=6e-08 W=2e-07
MI14_MXPOEN nmux nse XI14_p1 VDD pm1p2_svt_lp L=6e-08 W=1.5e-07
MI14_MXPA1 XI14_p1 SI VDD VDD pm1p2_svt_lp L=6e-08 W=1.5e-07
MXP2 p1 SE VDD VDD pm1p2_svt_lp L=6e-08 W=2e-07
MXP3 nmux D p1 VDD pm1p2_svt_lp L=6e-08 W=2e-07
MI33_MXPOEN nm bclk nmux VDD pm1p2_svt_lp L=6e-08 W=1.5e-07
MI31_MXPOEN nm nclk XI31_p1 VDD pm1p2_svt_lp L=6e-08 W=1.5e-07
MI31_MXPA1 XI31_p1 m VDD VDD pm1p2_svt_lp L=6e-08 W=1.5e-07
MI0_MXPA2 m nm VDD VDD pm1p2_svt_lp L=6e-08 W=1.5e-07
MI0_MXPA1 m SN VDD VDD pm1p2_svt_lp L=6e-08 W=1.5e-07
MI20_MXPOEN s nclk m VDD pm1p2_svt_lp L=6e-08 W=1.5e-07
MXP0 s bclk net73 VDD pm1p2_svt_lp L=6e-08 W=1.5e-07
MXP1 net73 ns VDD VDD pm1p2_svt_lp L=6e-08 W=1.5e-07
MXP4 s SN VDD VDD pm1p2_svt_lp L=6e-08 W=1.5e-07
MI28_MXPA1 ns s VDD VDD pm1p2_svt_lp L=6e-08 W=2.2e-07
MI8_MXPA1 Q ns VDD VDD pm1p2_svt_lp L=6e-08 W=2.95e-07
MI23_MXPA1 bclk nclk VDD VDD pm1p2_svt_lp L=6e-08 W=1.9e-07
MI22_MXPA1 nclk CK VDD VDD pm1p2_svt_lp L=6e-08 W=1.7e-07
.ENDS

.SUBCKT SDFFSQX1H9R Q VDD VSS CK D SE SI SN
MI57_MXNA1 nse SE VSS VSS nm1p2_svt_lp L=6e-08 W=1.5e-07
MI14_MXNOE nmux SE XI14_n1 VSS nm1p2_svt_lp L=6e-08 W=1.5e-07
MI14_MXNA1 XI14_n1 SI VSS VSS nm1p2_svt_lp L=6e-08 W=1.5e-07
MXN3 n1 nse VSS VSS nm1p2_svt_lp L=6e-08 W=2.5e-07
MXN2 nmux D n1 VSS nm1p2_svt_lp L=6e-08 W=2.5e-07
MI33_MXNOE nm nclk nmux VSS nm1p2_svt_lp L=6e-08 W=2.6e-07
MI31_MXNOE nm bclk XI31_n1 VSS nm1p2_svt_lp L=6e-08 W=1.5e-07
MI31_MXNA1 XI31_n1 m VSS VSS nm1p2_svt_lp L=6e-08 W=1.5e-07
MI0_MXNA2 XI0_n1 nm VSS VSS nm1p2_svt_lp L=6e-08 W=2.8e-07
MI0_MXNA1 m SN XI0_n1 VSS nm1p2_svt_lp L=6e-08 W=2.8e-07
MI20_MXNOE s bclk m VSS nm1p2_svt_lp L=6e-08 W=2.6e-07
MXN4 s nclk net63 VSS nm1p2_svt_lp L=6e-08 W=2e-07
MXN0 net63 ns net51 VSS nm1p2_svt_lp L=6e-08 W=2e-07
MXN1 net51 SN VSS VSS nm1p2_svt_lp L=6e-08 W=2e-07
MI28_MXNA1 ns s VSS VSS nm1p2_svt_lp L=6e-08 W=2.1e-07
MI8_MXNA1 Q ns VSS VSS nm1p2_svt_lp L=6e-08 W=4.2e-07
MI23_MXNA1 bclk nclk VSS VSS nm1p2_svt_lp L=6e-08 W=1.5e-07
MI22_MXNA1 nclk CK VSS VSS nm1p2_svt_lp L=6e-08 W=1.7e-07
MI57_MXPA1 nse SE VDD VDD pm1p2_svt_lp L=6e-08 W=2e-07
MI14_MXPOEN nmux nse XI14_p1 VDD pm1p2_svt_lp L=6e-08 W=2e-07
MI14_MXPA1 XI14_p1 SI VDD VDD pm1p2_svt_lp L=6e-08 W=2e-07
MXP2 p1 SE VDD VDD pm1p2_svt_lp L=6e-08 W=3.2e-07
MXP3 nmux D p1 VDD pm1p2_svt_lp L=6e-08 W=3.2e-07
MI33_MXPOEN nm bclk nmux VDD pm1p2_svt_lp L=6e-08 W=2.6e-07
MI31_MXPOEN nm nclk XI31_p1 VDD pm1p2_svt_lp L=6e-08 W=1.5e-07
MI31_MXPA1 XI31_p1 m VDD VDD pm1p2_svt_lp L=6e-08 W=1.5e-07
MI0_MXPA2 m nm VDD VDD pm1p2_svt_lp L=6e-08 W=2.4e-07
MI0_MXPA1 m SN VDD VDD pm1p2_svt_lp L=6e-08 W=2.4e-07
MI20_MXPOEN s nclk m VDD pm1p2_svt_lp L=6e-08 W=2.6e-07
MXP0 s bclk net70 VDD pm1p2_svt_lp L=6e-08 W=1.5e-07
MXP1 net70 ns VDD VDD pm1p2_svt_lp L=6e-08 W=1.5e-07
MXP4 s SN VDD VDD pm1p2_svt_lp L=6e-08 W=1.5e-07
MI28_MXPA1 ns s VDD VDD pm1p2_svt_lp L=6e-08 W=3.5e-07
MI8_MXPA1 Q ns VDD VDD pm1p2_svt_lp L=6e-08 W=5.85e-07
MI23_MXPA1 bclk nclk VDD VDD pm1p2_svt_lp L=6e-08 W=3e-07
MI22_MXPA1 nclk CK VDD VDD pm1p2_svt_lp L=6e-08 W=1.9e-07
.ENDS

.SUBCKT SDFFSQX2H9R Q VDD VSS CK D SE SI SN
MI57_MXNA1 nse SE VSS VSS nm1p2_svt_lp L=6e-08 W=1.5e-07
MI14_MXNOE nmux SE XI14_n1 VSS nm1p2_svt_lp L=6e-08 W=1.5e-07
MI14_MXNA1 XI14_n1 SI VSS VSS nm1p2_svt_lp L=6e-08 W=1.5e-07
MXN3 n1 nse VSS VSS nm1p2_svt_lp L=6e-08 W=4e-07
MXN2 nmux D n1 VSS nm1p2_svt_lp L=6e-08 W=4e-07
MI33_MXNOE nm nclk nmux VSS nm1p2_svt_lp L=6e-08 W=3.2e-07
MI31_MXNOE nm bclk XI31_n1 VSS nm1p2_svt_lp L=6e-08 W=1.5e-07
MI31_MXNA1 XI31_n1 m VSS VSS nm1p2_svt_lp L=6e-08 W=1.5e-07
MI0_MXNA2 XI0_n1 nm VSS VSS nm1p2_svt_lp L=6e-08 W=4e-07
MI0_MXNA1 m SN XI0_n1 VSS nm1p2_svt_lp L=6e-08 W=4e-07
MI20_MXNOE s bclk m VSS nm1p2_svt_lp L=6e-08 W=3.2e-07
MXN4 s nclk net54 VSS nm1p2_svt_lp L=6e-08 W=2e-07
MXN0 net54 ns net50 VSS nm1p2_svt_lp L=6e-08 W=2e-07
MXN1 net50 SN VSS VSS nm1p2_svt_lp L=6e-08 W=2e-07
MI28_MXNA1 ns s VSS VSS nm1p2_svt_lp L=6e-08 W=3.2e-07
MI8_MXNA1 Q ns VSS VSS nm1p2_svt_lp L=6e-08 W=4.2e-07
MI8_MXNA1_2 Q ns VSS VSS nm1p2_svt_lp L=6e-08 W=4.2e-07
MI23_MXNA1 bclk nclk VSS VSS nm1p2_svt_lp L=6e-08 W=1.7e-07
MI22_MXNA1 nclk CK VSS VSS nm1p2_svt_lp L=6e-08 W=2.1e-07
MI57_MXPA1 nse SE VDD VDD pm1p2_svt_lp L=6e-08 W=2e-07
MI14_MXPOEN nmux nse XI14_p1 VDD pm1p2_svt_lp L=6e-08 W=2e-07
MI14_MXPA1 XI14_p1 SI VDD VDD pm1p2_svt_lp L=6e-08 W=2e-07
MXP2 p1 SE VDD VDD pm1p2_svt_lp L=6e-08 W=4.3e-07
MXP3 nmux D p1 VDD pm1p2_svt_lp L=6e-08 W=4.3e-07
MI33_MXPOEN nm bclk nmux VDD pm1p2_svt_lp L=6e-08 W=3.2e-07
MI31_MXPOEN nm nclk XI31_p1 VDD pm1p2_svt_lp L=6e-08 W=1.5e-07
MI31_MXPA1 XI31_p1 m VDD VDD pm1p2_svt_lp L=6e-08 W=1.5e-07
MI0_MXPA2 m nm VDD VDD pm1p2_svt_lp L=6e-08 W=3e-07
MI0_MXPA1 m SN VDD VDD pm1p2_svt_lp L=6e-08 W=3e-07
MI20_MXPOEN s nclk m VDD pm1p2_svt_lp L=6e-08 W=3.2e-07
MXP0 s bclk net73 VDD pm1p2_svt_lp L=6e-08 W=1.5e-07
MXP1 net73 ns VDD VDD pm1p2_svt_lp L=6e-08 W=1.5e-07
MXP4 s SN VDD VDD pm1p2_svt_lp L=6e-08 W=1.5e-07
MI28_MXPA1 ns s VDD VDD pm1p2_svt_lp L=6e-08 W=5e-07
MI8_MXPA1 Q ns VDD VDD pm1p2_svt_lp L=6e-08 W=5.85e-07
MI8_MXPA1_2 Q ns VDD VDD pm1p2_svt_lp L=6e-08 W=5.85e-07
MI23_MXPA1 bclk nclk VDD VDD pm1p2_svt_lp L=6e-08 W=3.3e-07
MI22_MXPA1 nclk CK VDD VDD pm1p2_svt_lp L=6e-08 W=2.3e-07
.ENDS

.SUBCKT SDFFSQX3H9R Q VDD VSS CK D SE SI SN
MI57_MXNA1 nse SE VSS VSS nm1p2_svt_lp L=6e-08 W=1.5e-07
MI14_MXNOE nmux SE XI14_n1 VSS nm1p2_svt_lp L=6e-08 W=1.5e-07
MI14_MXNA1 XI14_n1 SI VSS VSS nm1p2_svt_lp L=6e-08 W=1.5e-07
MXN3 n1 nse VSS VSS nm1p2_svt_lp L=6e-08 W=4.4e-07
MXN2 nmux D n1 VSS nm1p2_svt_lp L=6e-08 W=4.4e-07
MI33_MXNOE nm nclk nmux VSS nm1p2_svt_lp L=6e-08 W=3.9e-07
MI31_MXNOE nm bclk XI31_n1 VSS nm1p2_svt_lp L=6e-08 W=1.5e-07
MI31_MXNA1 XI31_n1 m VSS VSS nm1p2_svt_lp L=6e-08 W=1.5e-07
MI0_MXNA2 XI0_n1 nm VSS VSS nm1p2_svt_lp L=6e-08 W=4.95e-07
MI0_MXNA1 m SN XI0_n1 VSS nm1p2_svt_lp L=6e-08 W=4.95e-07
MI20_MXNOE s bclk m VSS nm1p2_svt_lp L=6e-08 W=3.9e-07
MXN4 s nclk net54 VSS nm1p2_svt_lp L=6e-08 W=2e-07
MXN0 net54 ns net50 VSS nm1p2_svt_lp L=6e-08 W=2e-07
MXN1 net50 SN VSS VSS nm1p2_svt_lp L=6e-08 W=2e-07
MI28_MXNA1 ns s VSS VSS nm1p2_svt_lp L=6e-08 W=3.2e-07
MI8_MXNA1 Q ns VSS VSS nm1p2_svt_lp L=6e-08 W=4.2e-07
MI8_MXNA1_2 Q ns VSS VSS nm1p2_svt_lp L=6e-08 W=4.2e-07
MI8_MXNA1_3 Q ns VSS VSS nm1p2_svt_lp L=6e-08 W=4.2e-07
MI23_MXNA1 bclk nclk VSS VSS nm1p2_svt_lp L=6e-08 W=1.8e-07
MI22_MXNA1 nclk CK VSS VSS nm1p2_svt_lp L=6e-08 W=2.2e-07
MI57_MXPA1 nse SE VDD VDD pm1p2_svt_lp L=6e-08 W=2e-07
MI14_MXPOEN nmux nse XI14_p1 VDD pm1p2_svt_lp L=6e-08 W=2e-07
MI14_MXPA1 XI14_p1 SI VDD VDD pm1p2_svt_lp L=6e-08 W=2e-07
MXP2 p1 SE VDD VDD pm1p2_svt_lp L=6e-08 W=5e-07
MXP3 nmux D p1 VDD pm1p2_svt_lp L=6e-08 W=5e-07
MI33_MXPOEN nm bclk nmux VDD pm1p2_svt_lp L=6e-08 W=3.9e-07
MI31_MXPOEN nm nclk XI31_p1 VDD pm1p2_svt_lp L=6e-08 W=1.5e-07
MI31_MXPA1 XI31_p1 m VDD VDD pm1p2_svt_lp L=6e-08 W=1.5e-07
MI0_MXPA2 m nm VDD VDD pm1p2_svt_lp L=6e-08 W=4.2e-07
MI0_MXPA1 m SN VDD VDD pm1p2_svt_lp L=6e-08 W=4.2e-07
MI20_MXPOEN s nclk m VDD pm1p2_svt_lp L=6e-08 W=3.9e-07
MXP0 s bclk net73 VDD pm1p2_svt_lp L=6e-08 W=1.5e-07
MXP1 net73 ns VDD VDD pm1p2_svt_lp L=6e-08 W=1.5e-07
MXP4 s SN VDD VDD pm1p2_svt_lp L=6e-08 W=1.5e-07
MI28_MXPA1 ns s VDD VDD pm1p2_svt_lp L=6e-08 W=5.8e-07
MI8_MXPA1 Q ns VDD VDD pm1p2_svt_lp L=6e-08 W=5.85e-07
MI8_MXPA1_2 Q ns VDD VDD pm1p2_svt_lp L=6e-08 W=5.85e-07
MI8_MXPA1_3 Q ns VDD VDD pm1p2_svt_lp L=6e-08 W=5.85e-07
MI23_MXPA1 bclk nclk VDD VDD pm1p2_svt_lp L=6e-08 W=3.6e-07
MI22_MXPA1 nclk CK VDD VDD pm1p2_svt_lp L=6e-08 W=2.4e-07
.ENDS

.SUBCKT SDFFSQX4H9R Q VDD VSS CK D SE SI SN
MI57_MXNA1 nse SE VSS VSS nm1p2_svt_lp L=6e-08 W=1.5e-07
MI14_MXNOE nmux SE XI14_n1 VSS nm1p2_svt_lp L=6e-08 W=1.5e-07
MI14_MXNA1 XI14_n1 SI VSS VSS nm1p2_svt_lp L=6e-08 W=1.5e-07
MXN3 n1 nse VSS VSS nm1p2_svt_lp L=6e-08 W=4.1e-07
MXN2 nmux D n1 VSS nm1p2_svt_lp L=6e-08 W=4.1e-07
MI33_MXNOE nm nclk nmux VSS nm1p2_svt_lp L=6e-08 W=4.5e-07
MI31_MXNOE nm bclk XI31_n1 VSS nm1p2_svt_lp L=6e-08 W=1.5e-07
MI31_MXNA1 XI31_n1 m VSS VSS nm1p2_svt_lp L=6e-08 W=1.5e-07
MI0_MXNA2 XI0_n1 nm VSS VSS nm1p2_svt_lp L=6e-08 W=4.95e-07
MI0_MXNA1 m SN XI0_n1 VSS nm1p2_svt_lp L=6e-08 W=4.95e-07
MI20_MXNOE s bclk m VSS nm1p2_svt_lp L=6e-08 W=4.5e-07
MXN4 s nclk net54 VSS nm1p2_svt_lp L=6e-08 W=2e-07
MXN0 net54 ns net50 VSS nm1p2_svt_lp L=6e-08 W=2e-07
MXN1 net50 SN VSS VSS nm1p2_svt_lp L=6e-08 W=2e-07
MI28_MXNA1 ns s VSS VSS nm1p2_svt_lp L=6e-08 W=2.5e-07
MI28_MXNA1_2 ns s VSS VSS nm1p2_svt_lp L=6e-08 W=2.5e-07
MI8_MXNA1 Q ns VSS VSS nm1p2_svt_lp L=6e-08 W=4.2e-07
MI8_MXNA1_2 Q ns VSS VSS nm1p2_svt_lp L=6e-08 W=4.2e-07
MI8_MXNA1_3 Q ns VSS VSS nm1p2_svt_lp L=6e-08 W=4.2e-07
MI8_MXNA1_4 Q ns VSS VSS nm1p2_svt_lp L=6e-08 W=4.2e-07
MI23_MXNA1 bclk nclk VSS VSS nm1p2_svt_lp L=6e-08 W=2.1e-07
MI22_MXNA1 nclk CK VSS VSS nm1p2_svt_lp L=6e-08 W=2.5e-07
MI57_MXPA1 nse SE VDD VDD pm1p2_svt_lp L=6e-08 W=2e-07
MI14_MXPOEN nmux nse XI14_p1 VDD pm1p2_svt_lp L=6e-08 W=2e-07
MI14_MXPA1 XI14_p1 SI VDD VDD pm1p2_svt_lp L=6e-08 W=2e-07
MXP2 p1 SE VDD VDD pm1p2_svt_lp L=6e-08 W=5e-07
MXP3 nmux D p1 VDD pm1p2_svt_lp L=6e-08 W=5e-07
MI33_MXPOEN nm bclk nmux VDD pm1p2_svt_lp L=6e-08 W=4.5e-07
MI31_MXPOEN nm nclk XI31_p1 VDD pm1p2_svt_lp L=6e-08 W=1.5e-07
MI31_MXPA1 XI31_p1 m VDD VDD pm1p2_svt_lp L=6e-08 W=1.5e-07
MI0_MXPA2 m nm VDD VDD pm1p2_svt_lp L=6e-08 W=4.35e-07
MI0_MXPA1 m SN VDD VDD pm1p2_svt_lp L=6e-08 W=4.35e-07
MI20_MXPOEN s nclk m VDD pm1p2_svt_lp L=6e-08 W=4.5e-07
MXP0 s bclk net73 VDD pm1p2_svt_lp L=6e-08 W=1.5e-07
MXP1 net73 ns VDD VDD pm1p2_svt_lp L=6e-08 W=1.5e-07
MXP4 s SN VDD VDD pm1p2_svt_lp L=6e-08 W=1.5e-07
MI28_MXPA1 ns s VDD VDD pm1p2_svt_lp L=6e-08 W=4.45e-07
MI28_MXPA1_2 ns s VDD VDD pm1p2_svt_lp L=6e-08 W=4.45e-07
MI8_MXPA1 Q ns VDD VDD pm1p2_svt_lp L=6e-08 W=5.85e-07
MI8_MXPA1_2 Q ns VDD VDD pm1p2_svt_lp L=6e-08 W=5.85e-07
MI8_MXPA1_3 Q ns VDD VDD pm1p2_svt_lp L=6e-08 W=5.85e-07
MI8_MXPA1_4 Q ns VDD VDD pm1p2_svt_lp L=6e-08 W=5.85e-07
MI23_MXPA1 bclk nclk VDD VDD pm1p2_svt_lp L=6e-08 W=4.2e-07
MI22_MXPA1 nclk CK VDD VDD pm1p2_svt_lp L=6e-08 W=2.8e-07
.ENDS

.SUBCKT SDFFSQNX0P5H9R QN VDD VSS CK D SE SI SN
MI57_MXNA1 nse SE VSS VSS nm1p2_svt_lp L=6e-08 W=1.5e-07
MI14_MXNOE nmux SE XI14_n1 VSS nm1p2_svt_lp L=6e-08 W=1.5e-07
MI14_MXNA1 XI14_n1 SI VSS VSS nm1p2_svt_lp L=6e-08 W=1.5e-07
MXN3 n1 nse VSS VSS nm1p2_svt_lp L=6e-08 W=1.5e-07
MXN2 nmux D n1 VSS nm1p2_svt_lp L=6e-08 W=1.5e-07
MI33_MXNOE nm nclk nmux VSS nm1p2_svt_lp L=6e-08 W=1.5e-07
MI31_MXNOE nm bclk XI31_n1 VSS nm1p2_svt_lp L=6e-08 W=1.5e-07
MI31_MXNA1 XI31_n1 m VSS VSS nm1p2_svt_lp L=6e-08 W=1.5e-07
MI0_MXNA2 XI0_n1 nm VSS VSS nm1p2_svt_lp L=6e-08 W=2e-07
MI0_MXNA1 m SN XI0_n1 VSS nm1p2_svt_lp L=6e-08 W=2e-07
MI20_MXNOE s bclk m VSS nm1p2_svt_lp L=6e-08 W=1.5e-07
MXN4 s nclk net58 VSS nm1p2_svt_lp L=6e-08 W=2e-07
MXN0 net58 ns net54 VSS nm1p2_svt_lp L=6e-08 W=2e-07
MXN1 net54 SN VSS VSS nm1p2_svt_lp L=6e-08 W=2e-07
MI28_MXNA1 ns s VSS VSS nm1p2_svt_lp L=6e-08 W=1.2e-07
MI8_MXNA1 QN s VSS VSS nm1p2_svt_lp L=6e-08 W=2.1e-07
MI23_MXNA1 bclk nclk VSS VSS nm1p2_svt_lp L=6e-08 W=1.5e-07
MI22_MXNA1 nclk CK VSS VSS nm1p2_svt_lp L=6e-08 W=1.5e-07
MI57_MXPA1 nse SE VDD VDD pm1p2_svt_lp L=6e-08 W=2e-07
MI14_MXPOEN nmux nse XI14_p1 VDD pm1p2_svt_lp L=6e-08 W=1.5e-07
MI14_MXPA1 XI14_p1 SI VDD VDD pm1p2_svt_lp L=6e-08 W=1.5e-07
MXP2 p1 SE VDD VDD pm1p2_svt_lp L=6e-08 W=2.3e-07
MXP3 nmux D p1 VDD pm1p2_svt_lp L=6e-08 W=2.3e-07
MI33_MXPOEN nm bclk nmux VDD pm1p2_svt_lp L=6e-08 W=1.5e-07
MI31_MXPOEN nm nclk XI31_p1 VDD pm1p2_svt_lp L=6e-08 W=1.5e-07
MI31_MXPA1 XI31_p1 m VDD VDD pm1p2_svt_lp L=6e-08 W=1.5e-07
MI0_MXPA2 m nm VDD VDD pm1p2_svt_lp L=6e-08 W=2.8e-07
MI0_MXPA1 m SN VDD VDD pm1p2_svt_lp L=6e-08 W=2.8e-07
MI20_MXPOEN s nclk m VDD pm1p2_svt_lp L=6e-08 W=1.5e-07
MXP1 s bclk net79 VDD pm1p2_svt_lp L=6e-08 W=1.5e-07
MXP0 net79 ns VDD VDD pm1p2_svt_lp L=6e-08 W=1.5e-07
MXP4 s SN VDD VDD pm1p2_svt_lp L=6e-08 W=1.5e-07
MI28_MXPA1 ns s VDD VDD pm1p2_svt_lp L=6e-08 W=1.2e-07
MI8_MXPA1 QN s VDD VDD pm1p2_svt_lp L=6e-08 W=2.95e-07
MI23_MXPA1 bclk nclk VDD VDD pm1p2_svt_lp L=6e-08 W=1.9e-07
MI22_MXPA1 nclk CK VDD VDD pm1p2_svt_lp L=6e-08 W=1.7e-07
.ENDS

.SUBCKT SDFFSQNX1H9R QN VDD VSS CK D SE SI SN
MI57_MXNA1 nse SE VSS VSS nm1p2_svt_lp L=6e-08 W=1.5e-07
MI14_MXNOE nmux SE XI14_n1 VSS nm1p2_svt_lp L=6e-08 W=1.5e-07
MI14_MXNA1 XI14_n1 SI VSS VSS nm1p2_svt_lp L=6e-08 W=1.5e-07
MXN3 n1 nse VSS VSS nm1p2_svt_lp L=6e-08 W=2.8e-07
MXN2 nmux D n1 VSS nm1p2_svt_lp L=6e-08 W=2.8e-07
MI33_MXNOE nm nclk nmux VSS nm1p2_svt_lp L=6e-08 W=2.6e-07
MI31_MXNOE nm bclk XI31_n1 VSS nm1p2_svt_lp L=6e-08 W=1.5e-07
MI31_MXNA1 XI31_n1 m VSS VSS nm1p2_svt_lp L=6e-08 W=1.5e-07
MI0_MXNA2 XI0_n1 nm VSS VSS nm1p2_svt_lp L=6e-08 W=3.2e-07
MI0_MXNA1 m SN XI0_n1 VSS nm1p2_svt_lp L=6e-08 W=3.2e-07
MI20_MXNOE s bclk m VSS nm1p2_svt_lp L=6e-08 W=2.6e-07
MXN4 s nclk net58 VSS nm1p2_svt_lp L=6e-08 W=2e-07
MXN0 net58 ns net54 VSS nm1p2_svt_lp L=6e-08 W=2e-07
MXN1 net54 SN VSS VSS nm1p2_svt_lp L=6e-08 W=2e-07
MI28_MXNA1 ns s VSS VSS nm1p2_svt_lp L=6e-08 W=1.2e-07
MI8_MXNA1 QN s VSS VSS nm1p2_svt_lp L=6e-08 W=4.2e-07
MI23_MXNA1 bclk nclk VSS VSS nm1p2_svt_lp L=6e-08 W=1.5e-07
MI22_MXNA1 nclk CK VSS VSS nm1p2_svt_lp L=6e-08 W=1.7e-07
MI57_MXPA1 nse SE VDD VDD pm1p2_svt_lp L=6e-08 W=2e-07
MI14_MXPOEN nmux nse XI14_p1 VDD pm1p2_svt_lp L=6e-08 W=2e-07
MI14_MXPA1 XI14_p1 SI VDD VDD pm1p2_svt_lp L=6e-08 W=2e-07
MXP2 p1 SE VDD VDD pm1p2_svt_lp L=6e-08 W=3.2e-07
MXP3 nmux D p1 VDD pm1p2_svt_lp L=6e-08 W=3.2e-07
MI33_MXPOEN nm bclk nmux VDD pm1p2_svt_lp L=6e-08 W=2.6e-07
MI31_MXPOEN nm nclk XI31_p1 VDD pm1p2_svt_lp L=6e-08 W=1.5e-07
MI31_MXPA1 XI31_p1 m VDD VDD pm1p2_svt_lp L=6e-08 W=1.5e-07
MI0_MXPA2 m nm VDD VDD pm1p2_svt_lp L=6e-08 W=2.4e-07
MI0_MXPA1 m SN VDD VDD pm1p2_svt_lp L=6e-08 W=2.4e-07
MI20_MXPOEN s nclk m VDD pm1p2_svt_lp L=6e-08 W=2.6e-07
MXP1 s bclk net79 VDD pm1p2_svt_lp L=6e-08 W=1.5e-07
MXP0 net79 ns VDD VDD pm1p2_svt_lp L=6e-08 W=1.5e-07
MXP4 s SN VDD VDD pm1p2_svt_lp L=6e-08 W=1.5e-07
MI28_MXPA1 ns s VDD VDD pm1p2_svt_lp L=6e-08 W=1.2e-07
MI8_MXPA1 QN s VDD VDD pm1p2_svt_lp L=6e-08 W=5.85e-07
MI23_MXPA1 bclk nclk VDD VDD pm1p2_svt_lp L=6e-08 W=3e-07
MI22_MXPA1 nclk CK VDD VDD pm1p2_svt_lp L=6e-08 W=1.9e-07
.ENDS

.SUBCKT SDFFSQNX2H9R QN VDD VSS CK D SE SI SN
MI57_MXNA1 nse SE VSS VSS nm1p2_svt_lp L=6e-08 W=1.5e-07
MI14_MXNOE nmux SE XI14_n1 VSS nm1p2_svt_lp L=6e-08 W=1.5e-07
MI14_MXNA1 XI14_n1 SI VSS VSS nm1p2_svt_lp L=6e-08 W=1.5e-07
MXN3 n1 nse VSS VSS nm1p2_svt_lp L=6e-08 W=4.5e-07
MXN2 nmux D n1 VSS nm1p2_svt_lp L=6e-08 W=4.5e-07
MI33_MXNOE nm nclk nmux VSS nm1p2_svt_lp L=6e-08 W=3.2e-07
MI31_MXNOE nm bclk XI31_n1 VSS nm1p2_svt_lp L=6e-08 W=1.5e-07
MI31_MXNA1 XI31_n1 m VSS VSS nm1p2_svt_lp L=6e-08 W=1.5e-07
MI0_MXNA2 XI0_n1 nm VSS VSS nm1p2_svt_lp L=6e-08 W=4.95e-07
MI0_MXNA1 m SN XI0_n1 VSS nm1p2_svt_lp L=6e-08 W=4.95e-07
MI20_MXNOE s bclk m VSS nm1p2_svt_lp L=6e-08 W=3.2e-07
MXN4 s nclk net58 VSS nm1p2_svt_lp L=6e-08 W=2e-07
MXN0 net58 ns net54 VSS nm1p2_svt_lp L=6e-08 W=2e-07
MXN1 net54 SN VSS VSS nm1p2_svt_lp L=6e-08 W=2e-07
MI28_MXNA1 ns s VSS VSS nm1p2_svt_lp L=6e-08 W=1.2e-07
MI8_MXNA1 QN s VSS VSS nm1p2_svt_lp L=6e-08 W=4.2e-07
MI8_MXNA1_2 QN s VSS VSS nm1p2_svt_lp L=6e-08 W=4.2e-07
MI23_MXNA1 bclk nclk VSS VSS nm1p2_svt_lp L=6e-08 W=1.7e-07
MI22_MXNA1 nclk CK VSS VSS nm1p2_svt_lp L=6e-08 W=2.1e-07
MI57_MXPA1 nse SE VDD VDD pm1p2_svt_lp L=6e-08 W=2e-07
MI14_MXPOEN nmux nse XI14_p1 VDD pm1p2_svt_lp L=6e-08 W=2e-07
MI14_MXPA1 XI14_p1 SI VDD VDD pm1p2_svt_lp L=6e-08 W=2e-07
MXP2 p1 SE VDD VDD pm1p2_svt_lp L=6e-08 W=5e-07
MXP3 nmux D p1 VDD pm1p2_svt_lp L=6e-08 W=5e-07
MI33_MXPOEN nm bclk nmux VDD pm1p2_svt_lp L=6e-08 W=3.2e-07
MI31_MXPOEN nm nclk XI31_p1 VDD pm1p2_svt_lp L=6e-08 W=1.5e-07
MI31_MXPA1 XI31_p1 m VDD VDD pm1p2_svt_lp L=6e-08 W=1.5e-07
MI0_MXPA2 m nm VDD VDD pm1p2_svt_lp L=6e-08 W=4.15e-07
MI0_MXPA1 m SN VDD VDD pm1p2_svt_lp L=6e-08 W=4.15e-07
MI20_MXPOEN s nclk m VDD pm1p2_svt_lp L=6e-08 W=3.2e-07
MXP1 s bclk net79 VDD pm1p2_svt_lp L=6e-08 W=1.5e-07
MXP0 net79 ns VDD VDD pm1p2_svt_lp L=6e-08 W=1.5e-07
MXP4 s SN VDD VDD pm1p2_svt_lp L=6e-08 W=1.5e-07
MI28_MXPA1 ns s VDD VDD pm1p2_svt_lp L=6e-08 W=1.2e-07
MI8_MXPA1 QN s VDD VDD pm1p2_svt_lp L=6e-08 W=5.85e-07
MI8_MXPA1_2 QN s VDD VDD pm1p2_svt_lp L=6e-08 W=5.85e-07
MI23_MXPA1 bclk nclk VDD VDD pm1p2_svt_lp L=6e-08 W=3.3e-07
MI22_MXPA1 nclk CK VDD VDD pm1p2_svt_lp L=6e-08 W=2.3e-07
.ENDS

.SUBCKT SDFFSQNX3H9R QN VDD VSS CK D SE SI SN
MI57_MXNA1 nse SE VSS VSS nm1p2_svt_lp L=6e-08 W=1.5e-07
MI14_MXNOE nmux SE XI14_n1 VSS nm1p2_svt_lp L=6e-08 W=1.5e-07
MI14_MXNA1 XI14_n1 SI VSS VSS nm1p2_svt_lp L=6e-08 W=1.5e-07
MXN3 n1 nse VSS VSS nm1p2_svt_lp L=6e-08 W=4.25e-07
MXN2 nmux D n1 VSS nm1p2_svt_lp L=6e-08 W=4.25e-07
MI33_MXNOE nm nclk nmux VSS nm1p2_svt_lp L=6e-08 W=3.9e-07
MI31_MXNOE nm bclk XI31_n1 VSS nm1p2_svt_lp L=6e-08 W=1.5e-07
MI31_MXNA1 XI31_n1 m VSS VSS nm1p2_svt_lp L=6e-08 W=1.5e-07
MI0_MXNA2 XI0_n1 nm VSS VSS nm1p2_svt_lp L=6e-08 W=4.4e-07
MI0_MXNA1 m SN XI0_n1 VSS nm1p2_svt_lp L=6e-08 W=4.4e-07
MI20_MXNOE s bclk m VSS nm1p2_svt_lp L=6e-08 W=3.9e-07
MXN4 s nclk net58 VSS nm1p2_svt_lp L=6e-08 W=2e-07
MXN0 net58 ns net54 VSS nm1p2_svt_lp L=6e-08 W=2e-07
MXN1 net54 SN VSS VSS nm1p2_svt_lp L=6e-08 W=2e-07
MI28_MXNA1 ns s VSS VSS nm1p2_svt_lp L=6e-08 W=1.2e-07
MI8_MXNA1 QN s VSS VSS nm1p2_svt_lp L=6e-08 W=4.2e-07
MI8_MXNA1_2 QN s VSS VSS nm1p2_svt_lp L=6e-08 W=4.2e-07
MI8_MXNA1_3 QN s VSS VSS nm1p2_svt_lp L=6e-08 W=4.2e-07
MI23_MXNA1 bclk nclk VSS VSS nm1p2_svt_lp L=6e-08 W=1.8e-07
MI22_MXNA1 nclk CK VSS VSS nm1p2_svt_lp L=6e-08 W=2.2e-07
MI57_MXPA1 nse SE VDD VDD pm1p2_svt_lp L=6e-08 W=2e-07
MI14_MXPOEN nmux nse XI14_p1 VDD pm1p2_svt_lp L=6e-08 W=2e-07
MI14_MXPA1 XI14_p1 SI VDD VDD pm1p2_svt_lp L=6e-08 W=2e-07
MXP2 p1 SE VDD VDD pm1p2_svt_lp L=6e-08 W=5.2e-07
MXP3 nmux D p1 VDD pm1p2_svt_lp L=6e-08 W=5.2e-07
MI33_MXPOEN nm bclk nmux VDD pm1p2_svt_lp L=6e-08 W=3.9e-07
MI31_MXPOEN nm nclk XI31_p1 VDD pm1p2_svt_lp L=6e-08 W=1.5e-07
MI31_MXPA1 XI31_p1 m VDD VDD pm1p2_svt_lp L=6e-08 W=1.5e-07
MI0_MXPA2 m nm VDD VDD pm1p2_svt_lp L=6e-08 W=4.15e-07
MI0_MXPA1 m SN VDD VDD pm1p2_svt_lp L=6e-08 W=4.15e-07
MI20_MXPOEN s nclk m VDD pm1p2_svt_lp L=6e-08 W=3.9e-07
MXP1 s bclk net79 VDD pm1p2_svt_lp L=6e-08 W=1.5e-07
MXP0 net79 ns VDD VDD pm1p2_svt_lp L=6e-08 W=1.5e-07
MXP4 s SN VDD VDD pm1p2_svt_lp L=6e-08 W=1.5e-07
MI28_MXPA1 ns s VDD VDD pm1p2_svt_lp L=6e-08 W=1.2e-07
MI8_MXPA1 QN s VDD VDD pm1p2_svt_lp L=6e-08 W=5.85e-07
MI8_MXPA1_2 QN s VDD VDD pm1p2_svt_lp L=6e-08 W=5.85e-07
MI8_MXPA1_3 QN s VDD VDD pm1p2_svt_lp L=6e-08 W=5.85e-07
MI23_MXPA1 bclk nclk VDD VDD pm1p2_svt_lp L=6e-08 W=3.6e-07
MI22_MXPA1 nclk CK VDD VDD pm1p2_svt_lp L=6e-08 W=2.4e-07
.ENDS

.SUBCKT SDFFNSQX1H9R Q VDD VSS CKN D SE SI SN
MI57_MXNA1 nse SE VSS VSS nm1p2_svt_lp L=6e-08 W=1.5e-07
MXN3 n1 nse VSS VSS nm1p2_svt_lp L=6e-08 W=1.7e-07
MXN2 nmux D n1 VSS nm1p2_svt_lp L=6e-08 W=1.7e-07
MI14_MXNOE nmux SE XI14_n1 VSS nm1p2_svt_lp L=6e-08 W=1.5e-07
MI14_MXNA1 XI14_n1 SI VSS VSS nm1p2_svt_lp L=6e-08 W=1.5e-07
MI22_MXNA1 nclk_ CKN VSS VSS nm1p2_svt_lp L=6e-08 W=1.5e-07
MI23_MXNA1 bclk_ nclk_ VSS VSS nm1p2_svt_lp L=6e-08 W=1.7e-07
MI33_MXNOE nm bclk_ nmux VSS nm1p2_svt_lp L=6e-08 W=1.5e-07
MI31_MXNOE nm nclk_ XI31_n1 VSS nm1p2_svt_lp L=6e-08 W=1.5e-07
MI31_MXNA1 XI31_n1 m VSS VSS nm1p2_svt_lp L=6e-08 W=1.5e-07
MI0_MXNA2 XI0_n1 nm VSS VSS nm1p2_svt_lp L=6e-08 W=2.5e-07
MI0_MXNA1 m SN XI0_n1 VSS nm1p2_svt_lp L=6e-08 W=2.5e-07
MI20_MXNOE s nclk_ m VSS nm1p2_svt_lp L=6e-08 W=1.5e-07
MXN4 s bclk_ net63 VSS nm1p2_svt_lp L=6e-08 W=2e-07
MXN0 net63 ns net51 VSS nm1p2_svt_lp L=6e-08 W=2e-07
MXN1 net51 SN VSS VSS nm1p2_svt_lp L=6e-08 W=2e-07
MI28_MXNA1 ns s VSS VSS nm1p2_svt_lp L=6e-08 W=2.2e-07
MI8_MXNA1 Q ns VSS VSS nm1p2_svt_lp L=6e-08 W=4.2e-07
MI57_MXPA1 nse SE VDD VDD pm1p2_svt_lp L=6e-08 W=2e-07
MXP2 p1 SE VDD VDD pm1p2_svt_lp L=6e-08 W=4.2e-07
MXP3 nmux D p1 VDD pm1p2_svt_lp L=6e-08 W=4.2e-07
MI14_MXPOEN nmux nse XI14_p1 VDD pm1p2_svt_lp L=6e-08 W=2e-07
MI14_MXPA1 XI14_p1 SI VDD VDD pm1p2_svt_lp L=6e-08 W=2e-07
MI22_MXPA1 nclk_ CKN VDD VDD pm1p2_svt_lp L=6e-08 W=3e-07
MI23_MXPA1 bclk_ nclk_ VDD VDD pm1p2_svt_lp L=6e-08 W=1.9e-07
MI33_MXPOEN nm nclk_ nmux VDD pm1p2_svt_lp L=6e-08 W=3.6e-07
MI31_MXPOEN nm bclk_ XI31_p1 VDD pm1p2_svt_lp L=6e-08 W=1.5e-07
MI31_MXPA1 XI31_p1 m VDD VDD pm1p2_svt_lp L=6e-08 W=1.5e-07
MI0_MXPA2 m nm VDD VDD pm1p2_svt_lp L=6e-08 W=3e-07
MI0_MXPA1 m SN VDD VDD pm1p2_svt_lp L=6e-08 W=3e-07
MI20_MXPOEN s bclk_ m VDD pm1p2_svt_lp L=6e-08 W=3.6e-07
MXP0 s nclk_ net70 VDD pm1p2_svt_lp L=6e-08 W=1.5e-07
MXP1 net70 ns VDD VDD pm1p2_svt_lp L=6e-08 W=1.5e-07
MXP4 s SN VDD VDD pm1p2_svt_lp L=6e-08 W=1.5e-07
MI28_MXPA1 ns s VDD VDD pm1p2_svt_lp L=6e-08 W=1.75e-07
MI8_MXPA1 Q ns VDD VDD pm1p2_svt_lp L=6e-08 W=5.85e-07
.ENDS

.SUBCKT SDFFNSQX2H9R Q VDD VSS CKN D SE SI SN
MI57_MXNA1 nse SE VSS VSS nm1p2_svt_lp L=6e-08 W=1.5e-07
MXN3 n1 nse VSS VSS nm1p2_svt_lp L=6e-08 W=1.7e-07
MXN2 nmux D n1 VSS nm1p2_svt_lp L=6e-08 W=1.7e-07
MI14_MXNOE nmux SE XI14_n1 VSS nm1p2_svt_lp L=6e-08 W=1.5e-07
MI14_MXNA1 XI14_n1 SI VSS VSS nm1p2_svt_lp L=6e-08 W=1.5e-07
MI23_MXNA1 bclk_ nclk_ VSS VSS nm1p2_svt_lp L=6e-08 W=2.1e-07
MI33_MXNOE nm bclk_ nmux VSS nm1p2_svt_lp L=6e-08 W=1.8e-07
MI31_MXNOE nm nclk_ XI31_n1 VSS nm1p2_svt_lp L=6e-08 W=1.5e-07
MI31_MXNA1 XI31_n1 m VSS VSS nm1p2_svt_lp L=6e-08 W=1.5e-07
MI0_MXNA2 XI0_n1 nm VSS VSS nm1p2_svt_lp L=6e-08 W=2.5e-07
MI0_MXNA1 m SN XI0_n1 VSS nm1p2_svt_lp L=6e-08 W=2.5e-07
MI20_MXNOE s nclk_ m VSS nm1p2_svt_lp L=6e-08 W=1.8e-07
MXN4 s bclk_ net63 VSS nm1p2_svt_lp L=6e-08 W=2e-07
MXN0 net63 ns net51 VSS nm1p2_svt_lp L=6e-08 W=2e-07
MXN1 net51 SN VSS VSS nm1p2_svt_lp L=6e-08 W=2e-07
MI28_MXNA1 ns s VSS VSS nm1p2_svt_lp L=6e-08 W=3.2e-07
MI8_MXNA1 Q ns VSS VSS nm1p2_svt_lp L=6e-08 W=4.2e-07
MI8_MXNA1_2 Q ns VSS VSS nm1p2_svt_lp L=6e-08 W=4.2e-07
MI22_MXNA1 nclk_ CKN VSS VSS nm1p2_svt_lp L=6e-08 W=1.7e-07
MI57_MXPA1 nse SE VDD VDD pm1p2_svt_lp L=6e-08 W=2e-07
MXP2 p1 SE VDD VDD pm1p2_svt_lp L=6e-08 W=4.3e-07
MXP3 nmux D p1 VDD pm1p2_svt_lp L=6e-08 W=4.3e-07
MI14_MXPOEN nmux nse XI14_p1 VDD pm1p2_svt_lp L=6e-08 W=2e-07
MI14_MXPA1 XI14_p1 SI VDD VDD pm1p2_svt_lp L=6e-08 W=2e-07
MI23_MXPA1 bclk_ nclk_ VDD VDD pm1p2_svt_lp L=6e-08 W=2.3e-07
MI33_MXPOEN nm nclk_ nmux VDD pm1p2_svt_lp L=6e-08 W=4.5e-07
MI31_MXPOEN nm bclk_ XI31_p1 VDD pm1p2_svt_lp L=6e-08 W=1.5e-07
MI31_MXPA1 XI31_p1 m VDD VDD pm1p2_svt_lp L=6e-08 W=1.5e-07
MI0_MXPA2 m nm VDD VDD pm1p2_svt_lp L=6e-08 W=3.3e-07
MI0_MXPA1 m SN VDD VDD pm1p2_svt_lp L=6e-08 W=3.3e-07
MI20_MXPOEN s bclk_ m VDD pm1p2_svt_lp L=6e-08 W=4.5e-07
MXP0 s nclk_ net70 VDD pm1p2_svt_lp L=6e-08 W=1.5e-07
MXP1 net70 ns VDD VDD pm1p2_svt_lp L=6e-08 W=1.5e-07
MXP4 s SN VDD VDD pm1p2_svt_lp L=6e-08 W=1.5e-07
MI28_MXPA1 ns s VDD VDD pm1p2_svt_lp L=6e-08 W=3.2e-07
MI8_MXPA1 Q ns VDD VDD pm1p2_svt_lp L=6e-08 W=5.85e-07
MI8_MXPA1_2 Q ns VDD VDD pm1p2_svt_lp L=6e-08 W=5.85e-07
MI22_MXPA1 nclk_ CKN VDD VDD pm1p2_svt_lp L=6e-08 W=3.3e-07
.ENDS

.SUBCKT SDFFNSQX3H9R Q VDD VSS CKN D SE SI SN
MI57_MXNA1 nse SE VSS VSS nm1p2_svt_lp L=6e-08 W=1.5e-07
MXN3 n1 nse VSS VSS nm1p2_svt_lp L=6e-08 W=2.05e-07
MXN2 nmux D n1 VSS nm1p2_svt_lp L=6e-08 W=2.05e-07
MI14_MXNOE nmux SE XI14_n1 VSS nm1p2_svt_lp L=6e-08 W=1.5e-07
MI14_MXNA1 XI14_n1 SI VSS VSS nm1p2_svt_lp L=6e-08 W=1.5e-07
MI22_MXNA1 nclk_ CKN VSS VSS nm1p2_svt_lp L=6e-08 W=1.8e-07
MI23_MXNA1 bclk_ nclk_ VSS VSS nm1p2_svt_lp L=6e-08 W=2.2e-07
MI33_MXNOE nm bclk_ nmux VSS nm1p2_svt_lp L=6e-08 W=1.8e-07
MI31_MXNOE nm nclk_ XI31_n1 VSS nm1p2_svt_lp L=6e-08 W=1.5e-07
MI31_MXNA1 XI31_n1 m VSS VSS nm1p2_svt_lp L=6e-08 W=1.5e-07
MI0_MXNA2 XI0_n1 nm VSS VSS nm1p2_svt_lp L=6e-08 W=3.9e-07
MI0_MXNA1 m SN XI0_n1 VSS nm1p2_svt_lp L=6e-08 W=3.9e-07
MI20_MXNOE s nclk_ m VSS nm1p2_svt_lp L=6e-08 W=1.8e-07
MXN4 s bclk_ net63 VSS nm1p2_svt_lp L=6e-08 W=2e-07
MXN0 net63 ns net51 VSS nm1p2_svt_lp L=6e-08 W=2e-07
MXN1 net51 SN VSS VSS nm1p2_svt_lp L=6e-08 W=2e-07
MI28_MXNA1 ns s VSS VSS nm1p2_svt_lp L=6e-08 W=3.3e-07
MI8_MXNA1 Q ns VSS VSS nm1p2_svt_lp L=6e-08 W=4.2e-07
MI8_MXNA1_2 Q ns VSS VSS nm1p2_svt_lp L=6e-08 W=4.2e-07
MI8_MXNA1_3 Q ns VSS VSS nm1p2_svt_lp L=6e-08 W=4.2e-07
MI57_MXPA1 nse SE VDD VDD pm1p2_svt_lp L=6e-08 W=2e-07
MXP2 p1 SE VDD VDD pm1p2_svt_lp L=6e-08 W=5e-07
MXP3 nmux D p1 VDD pm1p2_svt_lp L=6e-08 W=5e-07
MI14_MXPOEN nmux nse XI14_p1 VDD pm1p2_svt_lp L=6e-08 W=2e-07
MI14_MXPA1 XI14_p1 SI VDD VDD pm1p2_svt_lp L=6e-08 W=2e-07
MI22_MXPA1 nclk_ CKN VDD VDD pm1p2_svt_lp L=6e-08 W=3.6e-07
MI23_MXPA1 bclk_ nclk_ VDD VDD pm1p2_svt_lp L=6e-08 W=2.4e-07
MI33_MXPOEN nm nclk_ nmux VDD pm1p2_svt_lp L=6e-08 W=5.85e-07
MI31_MXPOEN nm bclk_ XI31_p1 VDD pm1p2_svt_lp L=6e-08 W=1.5e-07
MI31_MXPA1 XI31_p1 m VDD VDD pm1p2_svt_lp L=6e-08 W=1.5e-07
MI0_MXPA2 m nm VDD VDD pm1p2_svt_lp L=6e-08 W=5.05e-07
MI0_MXPA1 m SN VDD VDD pm1p2_svt_lp L=6e-08 W=5.05e-07
MI20_MXPOEN s bclk_ m VDD pm1p2_svt_lp L=6e-08 W=5.85e-07
MXP0 s nclk_ net70 VDD pm1p2_svt_lp L=6e-08 W=1.5e-07
MXP1 net70 ns VDD VDD pm1p2_svt_lp L=6e-08 W=1.5e-07
MXP4 s SN VDD VDD pm1p2_svt_lp L=6e-08 W=1.5e-07
MI28_MXPA1 ns s VDD VDD pm1p2_svt_lp L=6e-08 W=3.4e-07
MI8_MXPA1 Q ns VDD VDD pm1p2_svt_lp L=6e-08 W=5.85e-07
MI8_MXPA1_2 Q ns VDD VDD pm1p2_svt_lp L=6e-08 W=5.85e-07
MI8_MXPA1_3 Q ns VDD VDD pm1p2_svt_lp L=6e-08 W=5.85e-07
.ENDS

.SUBCKT SDFFSRPQX0P5H9R Q VDD VSS CK D R SE SI SN
MI57_MXNA1 nse SE VSS VSS nm1p2_svt_lp L=6e-08 W=1.5e-07
MI14_MXNOE nmux SE XI14_n1 VSS nm1p2_svt_lp L=6e-08 W=1.5e-07
MI14_MXNA1 XI14_n1 SI VSS VSS nm1p2_svt_lp L=6e-08 W=1.5e-07
MXN3 n1 nse VSS VSS nm1p2_svt_lp L=6e-08 W=1.5e-07
MXN2 nmux D n1 VSS nm1p2_svt_lp L=6e-08 W=1.5e-07
MI33_MXNOE nm nclk nmux VSS nm1p2_svt_lp L=6e-08 W=1.5e-07
MI31_MXNOE nm bclk XI31_n1 VSS nm1p2_svt_lp L=6e-08 W=1.5e-07
MI31_MXNA1 XI31_n1 m VSS VSS nm1p2_svt_lp L=6e-08 W=1.5e-07
MXN8 net64 SN VSS VSS nm1p2_svt_lp L=6e-08 W=1.5e-07
MXN7 m nm net64 VSS nm1p2_svt_lp L=6e-08 W=1.5e-07
MXN9 m R net64 VSS nm1p2_svt_lp L=6e-08 W=1.5e-07
MI20_MXNOE s bclk m VSS nm1p2_svt_lp L=6e-08 W=1.5e-07
MXN6 net56 R VSS VSS nm1p2_svt_lp L=6e-08 W=2e-07
MXN0 s SN net56 VSS nm1p2_svt_lp L=6e-08 W=2e-07
MXN4 s nclk net48 VSS nm1p2_svt_lp L=6e-08 W=2e-07
MXN1 net48 ns net44 VSS nm1p2_svt_lp L=6e-08 W=2e-07
MXN5 net44 SN VSS VSS nm1p2_svt_lp L=6e-08 W=2e-07
MI28_MXNA1 ns s VSS VSS nm1p2_svt_lp L=6e-08 W=2e-07
MI8_MXNA1 Q ns VSS VSS nm1p2_svt_lp L=6e-08 W=2.1e-07
MI23_MXNA1 bclk nclk VSS VSS nm1p2_svt_lp L=6e-08 W=1.5e-07
MI22_MXNA1 nclk CK VSS VSS nm1p2_svt_lp L=6e-08 W=1.5e-07
MI57_MXPA1 nse SE VDD VDD pm1p2_svt_lp L=6e-08 W=2e-07
MI14_MXPOEN nmux nse XI14_p1 VDD pm1p2_svt_lp L=6e-08 W=1.5e-07
MI14_MXPA1 XI14_p1 SI VDD VDD pm1p2_svt_lp L=6e-08 W=1.5e-07
MXP2 p1 SE VDD VDD pm1p2_svt_lp L=6e-08 W=2.2e-07
MXP3 nmux D p1 VDD pm1p2_svt_lp L=6e-08 W=2.2e-07
MI33_MXPOEN nm bclk nmux VDD pm1p2_svt_lp L=6e-08 W=1.5e-07
MI31_MXPOEN nm nclk XI31_p1 VDD pm1p2_svt_lp L=6e-08 W=1.5e-07
MI31_MXPA1 XI31_p1 m VDD VDD pm1p2_svt_lp L=6e-08 W=1.5e-07
MXP9 m SN VDD VDD pm1p2_svt_lp L=6e-08 W=2.5e-07
MXP8 net103 nm VDD VDD pm1p2_svt_lp L=6e-08 W=2.5e-07
MXP7 m R net103 VDD pm1p2_svt_lp L=6e-08 W=2.5e-07
MI20_MXPOEN s nclk m VDD pm1p2_svt_lp L=6e-08 W=1.5e-07
MXP5 net91 R VDD VDD pm1p2_svt_lp L=6e-08 W=2e-07
MXP1 net87 ns net91 VDD pm1p2_svt_lp L=6e-08 W=2e-07
MXP0 s bclk net87 VDD pm1p2_svt_lp L=6e-08 W=2e-07
MXP6 s SN VDD VDD pm1p2_svt_lp L=6e-08 W=2e-07
MI28_MXPA1 ns s VDD VDD pm1p2_svt_lp L=6e-08 W=2e-07
MI8_MXPA1 Q ns VDD VDD pm1p2_svt_lp L=6e-08 W=2.95e-07
MI23_MXPA1 bclk nclk VDD VDD pm1p2_svt_lp L=6e-08 W=1.9e-07
MI22_MXPA1 nclk CK VDD VDD pm1p2_svt_lp L=6e-08 W=1.7e-07
.ENDS

.SUBCKT SDFFSRPQX1H9R Q VDD VSS CK D R SE SI SN
MI57_MXNA1 nse SE VSS VSS nm1p2_svt_lp L=6e-08 W=1.5e-07
MI14_MXNOE nmux SE XI14_n1 VSS nm1p2_svt_lp L=6e-08 W=1.5e-07
MI14_MXNA1 XI14_n1 SI VSS VSS nm1p2_svt_lp L=6e-08 W=1.5e-07
MXN3 n1 nse VSS VSS nm1p2_svt_lp L=6e-08 W=2e-07
MXN2 nmux D n1 VSS nm1p2_svt_lp L=6e-08 W=2e-07
MI33_MXNOE nm nclk nmux VSS nm1p2_svt_lp L=6e-08 W=2.6e-07
MI31_MXNOE nm bclk XI31_n1 VSS nm1p2_svt_lp L=6e-08 W=1.5e-07
MI31_MXNA1 XI31_n1 m VSS VSS nm1p2_svt_lp L=6e-08 W=1.5e-07
MXN8 net64 SN VSS VSS nm1p2_svt_lp L=6e-08 W=1.9e-07
MXN7 m nm net64 VSS nm1p2_svt_lp L=6e-08 W=1.9e-07
MXN9 m R net64 VSS nm1p2_svt_lp L=6e-08 W=1.9e-07
MI20_MXNOE s bclk m VSS nm1p2_svt_lp L=6e-08 W=2.6e-07
MXN6 net56 R VSS VSS nm1p2_svt_lp L=6e-08 W=2e-07
MXN0 s SN net56 VSS nm1p2_svt_lp L=6e-08 W=2e-07
MXN4 s nclk net48 VSS nm1p2_svt_lp L=6e-08 W=2e-07
MXN1 net48 ns net44 VSS nm1p2_svt_lp L=6e-08 W=2e-07
MXN5 net44 SN VSS VSS nm1p2_svt_lp L=6e-08 W=2e-07
MI28_MXNA1 ns s VSS VSS nm1p2_svt_lp L=6e-08 W=3e-07
MI8_MXNA1 Q ns VSS VSS nm1p2_svt_lp L=6e-08 W=4.2e-07
MI23_MXNA1 bclk nclk VSS VSS nm1p2_svt_lp L=6e-08 W=1.5e-07
MI22_MXNA1 nclk CK VSS VSS nm1p2_svt_lp L=6e-08 W=1.7e-07
MI57_MXPA1 nse SE VDD VDD pm1p2_svt_lp L=6e-08 W=2e-07
MI14_MXPOEN nmux nse XI14_p1 VDD pm1p2_svt_lp L=6e-08 W=2e-07
MI14_MXPA1 XI14_p1 SI VDD VDD pm1p2_svt_lp L=6e-08 W=2e-07
MXP2 p1 SE VDD VDD pm1p2_svt_lp L=6e-08 W=3.2e-07
MXP3 nmux D p1 VDD pm1p2_svt_lp L=6e-08 W=3.2e-07
MI33_MXPOEN nm bclk nmux VDD pm1p2_svt_lp L=6e-08 W=2.6e-07
MI31_MXPOEN nm nclk XI31_p1 VDD pm1p2_svt_lp L=6e-08 W=1.5e-07
MI31_MXPA1 XI31_p1 m VDD VDD pm1p2_svt_lp L=6e-08 W=1.5e-07
MXP9 m SN VDD VDD pm1p2_svt_lp L=6e-08 W=3e-07
MXP8 net103 nm VDD VDD pm1p2_svt_lp L=6e-08 W=3e-07
MXP7 m R net103 VDD pm1p2_svt_lp L=6e-08 W=3e-07
MI20_MXPOEN s nclk m VDD pm1p2_svt_lp L=6e-08 W=2.6e-07
MXP5 net91 R VDD VDD pm1p2_svt_lp L=6e-08 W=2e-07
MXP1 net87 ns net91 VDD pm1p2_svt_lp L=6e-08 W=2e-07
MXP0 s bclk net87 VDD pm1p2_svt_lp L=6e-08 W=2e-07
MXP6 s SN VDD VDD pm1p2_svt_lp L=6e-08 W=2e-07
MI28_MXPA1 ns s VDD VDD pm1p2_svt_lp L=6e-08 W=2.8e-07
MI8_MXPA1 Q ns VDD VDD pm1p2_svt_lp L=6e-08 W=5.85e-07
MI23_MXPA1 bclk nclk VDD VDD pm1p2_svt_lp L=6e-08 W=3e-07
MI22_MXPA1 nclk CK VDD VDD pm1p2_svt_lp L=6e-08 W=1.9e-07
.ENDS

.SUBCKT SDFFSRPQX2H9R Q VDD VSS CK D R SE SI SN
MI57_MXNA1 nse SE VSS VSS nm1p2_svt_lp L=6e-08 W=1.5e-07
MI14_MXNOE nmux SE XI14_n1 VSS nm1p2_svt_lp L=6e-08 W=1.5e-07
MI14_MXNA1 XI14_n1 SI VSS VSS nm1p2_svt_lp L=6e-08 W=1.5e-07
MXN3 n1 nse VSS VSS nm1p2_svt_lp L=6e-08 W=3.7e-07
MXN2 nmux D n1 VSS nm1p2_svt_lp L=6e-08 W=3.7e-07
MI33_MXNOE nm nclk nmux VSS nm1p2_svt_lp L=6e-08 W=3.2e-07
MI31_MXNOE nm bclk XI31_n1 VSS nm1p2_svt_lp L=6e-08 W=1.5e-07
MI31_MXNA1 XI31_n1 m VSS VSS nm1p2_svt_lp L=6e-08 W=1.5e-07
MXN8 net64 SN VSS VSS nm1p2_svt_lp L=6e-08 W=3.2e-07
MXN7 m nm net64 VSS nm1p2_svt_lp L=6e-08 W=3.2e-07
MXN9 m R net64 VSS nm1p2_svt_lp L=6e-08 W=3.2e-07
MI20_MXNOE s bclk m VSS nm1p2_svt_lp L=6e-08 W=3.2e-07
MXN6 net56 R VSS VSS nm1p2_svt_lp L=6e-08 W=2e-07
MXN0 s SN net56 VSS nm1p2_svt_lp L=6e-08 W=2e-07
MXN4 s nclk net48 VSS nm1p2_svt_lp L=6e-08 W=2e-07
MXN1 net48 ns net44 VSS nm1p2_svt_lp L=6e-08 W=2e-07
MXN5 net44 SN VSS VSS nm1p2_svt_lp L=6e-08 W=2e-07
MI28_MXNA1 ns s VSS VSS nm1p2_svt_lp L=6e-08 W=3.9e-07
MI8_MXNA1 Q ns VSS VSS nm1p2_svt_lp L=6e-08 W=4.2e-07
MI8_MXNA1_2 Q ns VSS VSS nm1p2_svt_lp L=6e-08 W=4.2e-07
MI23_MXNA1 bclk nclk VSS VSS nm1p2_svt_lp L=6e-08 W=1.7e-07
MI22_MXNA1 nclk CK VSS VSS nm1p2_svt_lp L=6e-08 W=2.1e-07
MI57_MXPA1 nse SE VDD VDD pm1p2_svt_lp L=6e-08 W=2e-07
MI14_MXPOEN nmux nse XI14_p1 VDD pm1p2_svt_lp L=6e-08 W=2e-07
MI14_MXPA1 XI14_p1 SI VDD VDD pm1p2_svt_lp L=6e-08 W=2e-07
MXP2 p1 SE VDD VDD pm1p2_svt_lp L=6e-08 W=4.3e-07
MXP3 nmux D p1 VDD pm1p2_svt_lp L=6e-08 W=4.3e-07
MI33_MXPOEN nm bclk nmux VDD pm1p2_svt_lp L=6e-08 W=3.2e-07
MI31_MXPOEN nm nclk XI31_p1 VDD pm1p2_svt_lp L=6e-08 W=1.5e-07
MI31_MXPA1 XI31_p1 m VDD VDD pm1p2_svt_lp L=6e-08 W=1.5e-07
MXP9 m SN VDD VDD pm1p2_svt_lp L=6e-08 W=4e-07
MXP8 net103 nm VDD VDD pm1p2_svt_lp L=6e-08 W=4e-07
MXP7 m R net103 VDD pm1p2_svt_lp L=6e-08 W=4e-07
MI20_MXPOEN s nclk m VDD pm1p2_svt_lp L=6e-08 W=3.2e-07
MXP5 net91 R VDD VDD pm1p2_svt_lp L=6e-08 W=2e-07
MXP1 net87 ns net91 VDD pm1p2_svt_lp L=6e-08 W=2e-07
MXP0 s bclk net87 VDD pm1p2_svt_lp L=6e-08 W=2e-07
MXP6 s SN VDD VDD pm1p2_svt_lp L=6e-08 W=2e-07
MI28_MXPA1 ns s VDD VDD pm1p2_svt_lp L=6e-08 W=4.2e-07
MI8_MXPA1 Q ns VDD VDD pm1p2_svt_lp L=6e-08 W=5.85e-07
MI8_MXPA1_2 Q ns VDD VDD pm1p2_svt_lp L=6e-08 W=5.85e-07
MI23_MXPA1 bclk nclk VDD VDD pm1p2_svt_lp L=6e-08 W=3.3e-07
MI22_MXPA1 nclk CK VDD VDD pm1p2_svt_lp L=6e-08 W=2.3e-07
.ENDS

.SUBCKT SDFFSRPQX3H9R Q VDD VSS CK D R SE SI SN
MI57_MXNA1 nse SE VSS VSS nm1p2_svt_lp L=6e-08 W=1.5e-07
MI14_MXNOE nmux SE XI14_n1 VSS nm1p2_svt_lp L=6e-08 W=1.5e-07
MI14_MXNA1 XI14_n1 SI VSS VSS nm1p2_svt_lp L=6e-08 W=1.5e-07
MXN3 n1 nse VSS VSS nm1p2_svt_lp L=6e-08 W=4.3e-07
MXN2 nmux D n1 VSS nm1p2_svt_lp L=6e-08 W=4.3e-07
MI33_MXNOE nm nclk nmux VSS nm1p2_svt_lp L=6e-08 W=3.9e-07
MI31_MXNOE nm bclk XI31_n1 VSS nm1p2_svt_lp L=6e-08 W=1.5e-07
MI31_MXNA1 XI31_n1 m VSS VSS nm1p2_svt_lp L=6e-08 W=1.5e-07
MXN7 m nm net64 VSS nm1p2_svt_lp L=6e-08 W=3.9e-07
MXN9 m R net64 VSS nm1p2_svt_lp L=6e-08 W=3.9e-07
MXN8 net64 SN VSS VSS nm1p2_svt_lp L=6e-08 W=3.9e-07
MI20_MXNOE s bclk m VSS nm1p2_svt_lp L=6e-08 W=3.9e-07
MXN6 net56 R VSS VSS nm1p2_svt_lp L=6e-08 W=2e-07
MXN0 s SN net56 VSS nm1p2_svt_lp L=6e-08 W=2e-07
MXN4 s nclk net48 VSS nm1p2_svt_lp L=6e-08 W=2e-07
MXN1 net48 ns net44 VSS nm1p2_svt_lp L=6e-08 W=2e-07
MXN5 net44 SN VSS VSS nm1p2_svt_lp L=6e-08 W=2e-07
MI28_MXNA1 ns s VSS VSS nm1p2_svt_lp L=6e-08 W=4.4e-07
MI8_MXNA1 Q ns VSS VSS nm1p2_svt_lp L=6e-08 W=4.2e-07
MI8_MXNA1_2 Q ns VSS VSS nm1p2_svt_lp L=6e-08 W=4.2e-07
MI8_MXNA1_3 Q ns VSS VSS nm1p2_svt_lp L=6e-08 W=4.2e-07
MI23_MXNA1 bclk nclk VSS VSS nm1p2_svt_lp L=6e-08 W=1.8e-07
MI22_MXNA1 nclk CK VSS VSS nm1p2_svt_lp L=6e-08 W=2.2e-07
MI57_MXPA1 nse SE VDD VDD pm1p2_svt_lp L=6e-08 W=2e-07
MI14_MXPOEN nmux nse XI14_p1 VDD pm1p2_svt_lp L=6e-08 W=2e-07
MI14_MXPA1 XI14_p1 SI VDD VDD pm1p2_svt_lp L=6e-08 W=2e-07
MXP2 p1 SE VDD VDD pm1p2_svt_lp L=6e-08 W=5e-07
MXP3 nmux D p1 VDD pm1p2_svt_lp L=6e-08 W=5e-07
MI33_MXPOEN nm bclk nmux VDD pm1p2_svt_lp L=6e-08 W=3.9e-07
MI31_MXPOEN nm nclk XI31_p1 VDD pm1p2_svt_lp L=6e-08 W=1.5e-07
MI31_MXPA1 XI31_p1 m VDD VDD pm1p2_svt_lp L=6e-08 W=1.5e-07
MXP8 net103 nm VDD VDD pm1p2_svt_lp L=6e-08 W=5e-07
MXP7 m R net103 VDD pm1p2_svt_lp L=6e-08 W=5e-07
MXP9 m SN VDD VDD pm1p2_svt_lp L=6e-08 W=5e-07
MI20_MXPOEN s nclk m VDD pm1p2_svt_lp L=6e-08 W=3.9e-07
MXP5 net91 R VDD VDD pm1p2_svt_lp L=6e-08 W=2e-07
MXP1 net87 ns net91 VDD pm1p2_svt_lp L=6e-08 W=2e-07
MXP0 s bclk net87 VDD pm1p2_svt_lp L=6e-08 W=2e-07
MXP6 s SN VDD VDD pm1p2_svt_lp L=6e-08 W=2e-07
MI28_MXPA1 ns s VDD VDD pm1p2_svt_lp L=6e-08 W=5.4e-07
MI8_MXPA1 Q ns VDD VDD pm1p2_svt_lp L=6e-08 W=5.85e-07
MI8_MXPA1_2 Q ns VDD VDD pm1p2_svt_lp L=6e-08 W=5.85e-07
MI8_MXPA1_3 Q ns VDD VDD pm1p2_svt_lp L=6e-08 W=5.85e-07
MI23_MXPA1 bclk nclk VDD VDD pm1p2_svt_lp L=6e-08 W=3.6e-07
MI22_MXPA1 nclk CK VDD VDD pm1p2_svt_lp L=6e-08 W=2.4e-07
.ENDS

.SUBCKT SDFFSRPQX4H9R Q VDD VSS CK D R SE SI SN
MI57_MXNA1 nse SE VSS VSS nm1p2_svt_lp L=6e-08 W=1.5e-07
MI14_MXNOE nmux SE XI14_n1 VSS nm1p2_svt_lp L=6e-08 W=1.5e-07
MI14_MXNA1 XI14_n1 SI VSS VSS nm1p2_svt_lp L=6e-08 W=1.5e-07
MXN3 n1 nse VSS VSS nm1p2_svt_lp L=6e-08 W=4.4e-07
MXN2 nmux D n1 VSS nm1p2_svt_lp L=6e-08 W=4.4e-07
MI33_MXNOE nm nclk nmux VSS nm1p2_svt_lp L=6e-08 W=4.5e-07
MI31_MXNOE nm bclk XI31_n1 VSS nm1p2_svt_lp L=6e-08 W=1.5e-07
MI31_MXNA1 XI31_n1 m VSS VSS nm1p2_svt_lp L=6e-08 W=1.5e-07
MXN7 m nm net64 VSS nm1p2_svt_lp L=6e-08 W=3.8e-07
MXN9 m R net64 VSS nm1p2_svt_lp L=6e-08 W=3.8e-07
MXN8 net64 SN VSS VSS nm1p2_svt_lp L=6e-08 W=3.8e-07
MI20_MXNOE s bclk m VSS nm1p2_svt_lp L=6e-08 W=4.5e-07
MXN6 net56 R VSS VSS nm1p2_svt_lp L=6e-08 W=2e-07
MXN0 s SN net56 VSS nm1p2_svt_lp L=6e-08 W=2e-07
MXN4 s nclk net48 VSS nm1p2_svt_lp L=6e-08 W=2e-07
MXN1 net48 ns net44 VSS nm1p2_svt_lp L=6e-08 W=2e-07
MXN5 net44 SN VSS VSS nm1p2_svt_lp L=6e-08 W=2e-07
MI28_MXNA1 ns s VSS VSS nm1p2_svt_lp L=6e-08 W=4.45e-07
MI28_MXNA1_2 ns s VSS VSS nm1p2_svt_lp L=6e-08 W=4.45e-07
MI8_MXNA1 Q ns VSS VSS nm1p2_svt_lp L=6e-08 W=4.2e-07
MI8_MXNA1_2 Q ns VSS VSS nm1p2_svt_lp L=6e-08 W=4.2e-07
MI8_MXNA1_3 Q ns VSS VSS nm1p2_svt_lp L=6e-08 W=4.2e-07
MI8_MXNA1_4 Q ns VSS VSS nm1p2_svt_lp L=6e-08 W=4.2e-07
MI23_MXNA1 bclk nclk VSS VSS nm1p2_svt_lp L=6e-08 W=2.1e-07
MI22_MXNA1 nclk CK VSS VSS nm1p2_svt_lp L=6e-08 W=2.5e-07
MI57_MXPA1 nse SE VDD VDD pm1p2_svt_lp L=6e-08 W=2e-07
MI14_MXPOEN nmux nse XI14_p1 VDD pm1p2_svt_lp L=6e-08 W=2e-07
MI14_MXPA1 XI14_p1 SI VDD VDD pm1p2_svt_lp L=6e-08 W=2e-07
MXP2 p1 SE VDD VDD pm1p2_svt_lp L=6e-08 W=5.4e-07
MXP3 nmux D p1 VDD pm1p2_svt_lp L=6e-08 W=5.4e-07
MI33_MXPOEN nm bclk nmux VDD pm1p2_svt_lp L=6e-08 W=4.5e-07
MI31_MXPOEN nm nclk XI31_p1 VDD pm1p2_svt_lp L=6e-08 W=1.5e-07
MI31_MXPA1 XI31_p1 m VDD VDD pm1p2_svt_lp L=6e-08 W=1.5e-07
MXP8 net103 nm VDD VDD pm1p2_svt_lp L=6e-08 W=5.5e-07
MXP7 m R net103 VDD pm1p2_svt_lp L=6e-08 W=5.5e-07
MXP9 m SN VDD VDD pm1p2_svt_lp L=6e-08 W=5.5e-07
MI20_MXPOEN s nclk m VDD pm1p2_svt_lp L=6e-08 W=4.5e-07
MXP5 net91 R VDD VDD pm1p2_svt_lp L=6e-08 W=2e-07
MXP1 net87 ns net91 VDD pm1p2_svt_lp L=6e-08 W=2e-07
MXP0 s bclk net87 VDD pm1p2_svt_lp L=6e-08 W=2e-07
MXP6 s SN VDD VDD pm1p2_svt_lp L=6e-08 W=2e-07
MI28_MXPA1 ns s VDD VDD pm1p2_svt_lp L=6e-08 W=4.45e-07
MI28_MXPA1_2 ns s VDD VDD pm1p2_svt_lp L=6e-08 W=4.45e-07
MI8_MXPA1 Q ns VDD VDD pm1p2_svt_lp L=6e-08 W=5.85e-07
MI8_MXPA1_2 Q ns VDD VDD pm1p2_svt_lp L=6e-08 W=5.85e-07
MI8_MXPA1_3 Q ns VDD VDD pm1p2_svt_lp L=6e-08 W=5.85e-07
MI8_MXPA1_4 Q ns VDD VDD pm1p2_svt_lp L=6e-08 W=5.85e-07
MI23_MXPA1 bclk nclk VDD VDD pm1p2_svt_lp L=6e-08 W=4.2e-07
MI22_MXPA1 nclk CK VDD VDD pm1p2_svt_lp L=6e-08 W=2.8e-07
.ENDS

.SUBCKT SDFFNSRPQX1H9R Q VDD VSS CKN D R SE SI SN
MI57_MXNA1 nse SE VSS VSS nm1p2_svt_lp L=6e-08 W=1.5e-07
MI14_MXNOE nmux SE XI14_n1 VSS nm1p2_svt_lp L=6e-08 W=2e-07
MI14_MXNA1 XI14_n1 SI VSS VSS nm1p2_svt_lp L=6e-08 W=2e-07
MXN3 n1 nse VSS VSS nm1p2_svt_lp L=6e-08 W=1.65e-07
MXN2 nmux D n1 VSS nm1p2_svt_lp L=6e-08 W=1.65e-07
MI33_MXNOE nm bclk_ nmux VSS nm1p2_svt_lp L=6e-08 W=1.5e-07
MI31_MXNOE nm nclk_ XI31_n1 VSS nm1p2_svt_lp L=6e-08 W=1.5e-07
MI31_MXNA1 XI31_n1 m VSS VSS nm1p2_svt_lp L=6e-08 W=1.5e-07
MXN8 net64 SN VSS VSS nm1p2_svt_lp L=6e-08 W=1.5e-07
MXN7 m nm net64 VSS nm1p2_svt_lp L=6e-08 W=1.5e-07
MXN9 m R net64 VSS nm1p2_svt_lp L=6e-08 W=1.5e-07
MI20_MXNOE s nclk_ m VSS nm1p2_svt_lp L=6e-08 W=1.5e-07
MXN6 net56 R VSS VSS nm1p2_svt_lp L=6e-08 W=2e-07
MXN0 s SN net56 VSS nm1p2_svt_lp L=6e-08 W=2e-07
MXN4 s bclk_ net48 VSS nm1p2_svt_lp L=6e-08 W=2e-07
MXN1 net48 ns net44 VSS nm1p2_svt_lp L=6e-08 W=2e-07
MXN5 net44 SN VSS VSS nm1p2_svt_lp L=6e-08 W=2e-07
MI28_MXNA1 ns s VSS VSS nm1p2_svt_lp L=6e-08 W=2e-07
MI8_MXNA1 Q ns VSS VSS nm1p2_svt_lp L=6e-08 W=4.2e-07
MI23_MXNA1 bclk_ nclk_ VSS VSS nm1p2_svt_lp L=6e-08 W=1.7e-07
MI22_MXNA1 nclk_ CKN VSS VSS nm1p2_svt_lp L=6e-08 W=1.5e-07
MI57_MXPA1 nse SE VDD VDD pm1p2_svt_lp L=6e-08 W=2e-07
MI14_MXPOEN nmux nse XI14_p1 VDD pm1p2_svt_lp L=6e-08 W=2e-07
MI14_MXPA1 XI14_p1 SI VDD VDD pm1p2_svt_lp L=6e-08 W=2e-07
MXP2 p1 SE VDD VDD pm1p2_svt_lp L=6e-08 W=3.7e-07
MXP3 nmux D p1 VDD pm1p2_svt_lp L=6e-08 W=3.7e-07
MI33_MXPOEN nm nclk_ nmux VDD pm1p2_svt_lp L=6e-08 W=3.6e-07
MI31_MXPOEN nm bclk_ XI31_p1 VDD pm1p2_svt_lp L=6e-08 W=1.5e-07
MI31_MXPA1 XI31_p1 m VDD VDD pm1p2_svt_lp L=6e-08 W=1.5e-07
MXP9 m SN VDD VDD pm1p2_svt_lp L=6e-08 W=3.1e-07
MXP8 net103 nm VDD VDD pm1p2_svt_lp L=6e-08 W=3.1e-07
MXP7 m R net103 VDD pm1p2_svt_lp L=6e-08 W=3.1e-07
MI20_MXPOEN s bclk_ m VDD pm1p2_svt_lp L=6e-08 W=3.6e-07
MXP5 net91 R VDD VDD pm1p2_svt_lp L=6e-08 W=2e-07
MXP1 net87 ns net91 VDD pm1p2_svt_lp L=6e-08 W=2e-07
MXP0 s nclk_ net87 VDD pm1p2_svt_lp L=6e-08 W=2e-07
MXP6 s SN VDD VDD pm1p2_svt_lp L=6e-08 W=2e-07
MI28_MXPA1 ns s VDD VDD pm1p2_svt_lp L=6e-08 W=2e-07
MI8_MXPA1 Q ns VDD VDD pm1p2_svt_lp L=6e-08 W=5.85e-07
MI23_MXPA1 bclk_ nclk_ VDD VDD pm1p2_svt_lp L=6e-08 W=1.9e-07
MI22_MXPA1 nclk_ CKN VDD VDD pm1p2_svt_lp L=6e-08 W=3e-07
.ENDS

.SUBCKT SDFFNSRPQX2H9R Q VDD VSS CKN D R SE SI SN
MI57_MXNA1 nse SE VSS VSS nm1p2_svt_lp L=6e-08 W=1.5e-07
MI14_MXNOE nmux SE XI14_n1 VSS nm1p2_svt_lp L=6e-08 W=2e-07
MI14_MXNA1 XI14_n1 SI VSS VSS nm1p2_svt_lp L=6e-08 W=2e-07
MXN3 n1 nse VSS VSS nm1p2_svt_lp L=6e-08 W=2e-07
MXN2 nmux D n1 VSS nm1p2_svt_lp L=6e-08 W=2e-07
MI33_MXNOE nm bclk_ nmux VSS nm1p2_svt_lp L=6e-08 W=1.8e-07
MI31_MXNOE nm nclk_ XI31_n1 VSS nm1p2_svt_lp L=6e-08 W=1.5e-07
MI31_MXNA1 XI31_n1 m VSS VSS nm1p2_svt_lp L=6e-08 W=1.5e-07
MXN7 m nm net64 VSS nm1p2_svt_lp L=6e-08 W=2.4e-07
MXN9 m R net64 VSS nm1p2_svt_lp L=6e-08 W=2.4e-07
MXN8 net64 SN VSS VSS nm1p2_svt_lp L=6e-08 W=2.4e-07
MI20_MXNOE s nclk_ m VSS nm1p2_svt_lp L=6e-08 W=1.8e-07
MXN6 net56 R VSS VSS nm1p2_svt_lp L=6e-08 W=2e-07
MXN0 s SN net56 VSS nm1p2_svt_lp L=6e-08 W=2e-07
MXN4 s bclk_ net48 VSS nm1p2_svt_lp L=6e-08 W=2e-07
MXN1 net48 ns net44 VSS nm1p2_svt_lp L=6e-08 W=2e-07
MXN5 net44 SN VSS VSS nm1p2_svt_lp L=6e-08 W=2e-07
MI28_MXNA1 ns s VSS VSS nm1p2_svt_lp L=6e-08 W=3.2e-07
MI8_MXNA1 Q ns VSS VSS nm1p2_svt_lp L=6e-08 W=4.2e-07
MI8_MXNA1_2 Q ns VSS VSS nm1p2_svt_lp L=6e-08 W=4.2e-07
MI23_MXNA1 bclk_ nclk_ VSS VSS nm1p2_svt_lp L=6e-08 W=2.1e-07
MI22_MXNA1 nclk_ CKN VSS VSS nm1p2_svt_lp L=6e-08 W=1.7e-07
MI57_MXPA1 nse SE VDD VDD pm1p2_svt_lp L=6e-08 W=2e-07
MI14_MXPOEN nmux nse XI14_p1 VDD pm1p2_svt_lp L=6e-08 W=2e-07
MI14_MXPA1 XI14_p1 SI VDD VDD pm1p2_svt_lp L=6e-08 W=2e-07
MXP2 p1 SE VDD VDD pm1p2_svt_lp L=6e-08 W=4.3e-07
MXP3 nmux D p1 VDD pm1p2_svt_lp L=6e-08 W=4.3e-07
MI33_MXPOEN nm nclk_ nmux VDD pm1p2_svt_lp L=6e-08 W=4.5e-07
MI31_MXPOEN nm bclk_ XI31_p1 VDD pm1p2_svt_lp L=6e-08 W=1.5e-07
MI31_MXPA1 XI31_p1 m VDD VDD pm1p2_svt_lp L=6e-08 W=1.5e-07
MXP8 net103 nm VDD VDD pm1p2_svt_lp L=6e-08 W=4.05e-07
MXP7 m R net103 VDD pm1p2_svt_lp L=6e-08 W=4.05e-07
MXP9 m SN VDD VDD pm1p2_svt_lp L=6e-08 W=4.05e-07
MI20_MXPOEN s bclk_ m VDD pm1p2_svt_lp L=6e-08 W=4.5e-07
MXP5 net91 R VDD VDD pm1p2_svt_lp L=6e-08 W=2e-07
MXP1 net87 ns net91 VDD pm1p2_svt_lp L=6e-08 W=2e-07
MXP0 s nclk_ net87 VDD pm1p2_svt_lp L=6e-08 W=2e-07
MXP6 s SN VDD VDD pm1p2_svt_lp L=6e-08 W=2e-07
MI28_MXPA1 ns s VDD VDD pm1p2_svt_lp L=6e-08 W=2.6e-07
MI8_MXPA1 Q ns VDD VDD pm1p2_svt_lp L=6e-08 W=5.85e-07
MI8_MXPA1_2 Q ns VDD VDD pm1p2_svt_lp L=6e-08 W=5.85e-07
MI23_MXPA1 bclk_ nclk_ VDD VDD pm1p2_svt_lp L=6e-08 W=2.3e-07
MI22_MXPA1 nclk_ CKN VDD VDD pm1p2_svt_lp L=6e-08 W=3.3e-07
.ENDS

.SUBCKT SDFFNSRPQX3H9R Q VDD VSS CKN D R SE SI SN
MI57_MXNA1 nse SE VSS VSS nm1p2_svt_lp L=6e-08 W=1.5e-07
MI14_MXNOE nmux SE XI14_n1 VSS nm1p2_svt_lp L=6e-08 W=2e-07
MI14_MXNA1 XI14_n1 SI VSS VSS nm1p2_svt_lp L=6e-08 W=2e-07
MXN3 n1 nse VSS VSS nm1p2_svt_lp L=6e-08 W=2.4e-07
MXN2 nmux D n1 VSS nm1p2_svt_lp L=6e-08 W=2.4e-07
MI33_MXNOE nm bclk_ nmux VSS nm1p2_svt_lp L=6e-08 W=1.8e-07
MI31_MXNOE nm nclk_ XI31_n1 VSS nm1p2_svt_lp L=6e-08 W=1.5e-07
MI31_MXNA1 XI31_n1 m VSS VSS nm1p2_svt_lp L=6e-08 W=1.5e-07
MXN7 m nm net64 VSS nm1p2_svt_lp L=6e-08 W=3.5e-07
MXN9 m R net64 VSS nm1p2_svt_lp L=6e-08 W=3.5e-07
MXN8 net64 SN VSS VSS nm1p2_svt_lp L=6e-08 W=3.5e-07
MI20_MXNOE s nclk_ m VSS nm1p2_svt_lp L=6e-08 W=1.8e-07
MXN6 net56 R VSS VSS nm1p2_svt_lp L=6e-08 W=2e-07
MXN0 s SN net56 VSS nm1p2_svt_lp L=6e-08 W=2e-07
MXN4 s bclk_ net48 VSS nm1p2_svt_lp L=6e-08 W=2e-07
MXN1 net48 ns net44 VSS nm1p2_svt_lp L=6e-08 W=2e-07
MXN5 net44 SN VSS VSS nm1p2_svt_lp L=6e-08 W=2e-07
MI28_MXNA1 ns s VSS VSS nm1p2_svt_lp L=6e-08 W=3.3e-07
MI8_MXNA1 Q ns VSS VSS nm1p2_svt_lp L=6e-08 W=4.2e-07
MI8_MXNA1_2 Q ns VSS VSS nm1p2_svt_lp L=6e-08 W=4.2e-07
MI8_MXNA1_3 Q ns VSS VSS nm1p2_svt_lp L=6e-08 W=4.2e-07
MI23_MXNA1 bclk_ nclk_ VSS VSS nm1p2_svt_lp L=6e-08 W=2.2e-07
MI22_MXNA1 nclk_ CKN VSS VSS nm1p2_svt_lp L=6e-08 W=1.8e-07
MI57_MXPA1 nse SE VDD VDD pm1p2_svt_lp L=6e-08 W=2e-07
MI14_MXPOEN nmux nse XI14_p1 VDD pm1p2_svt_lp L=6e-08 W=2e-07
MI14_MXPA1 XI14_p1 SI VDD VDD pm1p2_svt_lp L=6e-08 W=2e-07
MXP2 p1 SE VDD VDD pm1p2_svt_lp L=6e-08 W=5e-07
MXP3 nmux D p1 VDD pm1p2_svt_lp L=6e-08 W=5e-07
MI33_MXPOEN nm nclk_ nmux VDD pm1p2_svt_lp L=6e-08 W=5.85e-07
MI31_MXPOEN nm bclk_ XI31_p1 VDD pm1p2_svt_lp L=6e-08 W=1.5e-07
MI31_MXPA1 XI31_p1 m VDD VDD pm1p2_svt_lp L=6e-08 W=1.5e-07
MXP8 net103 nm VDD VDD pm1p2_svt_lp L=6e-08 W=5e-07
MXP7 m R net103 VDD pm1p2_svt_lp L=6e-08 W=5e-07
MXP9 m SN VDD VDD pm1p2_svt_lp L=6e-08 W=5e-07
MI20_MXPOEN s bclk_ m VDD pm1p2_svt_lp L=6e-08 W=5.85e-07
MXP5 net91 R VDD VDD pm1p2_svt_lp L=6e-08 W=2e-07
MXP1 net87 ns net91 VDD pm1p2_svt_lp L=6e-08 W=2e-07
MXP0 s nclk_ net87 VDD pm1p2_svt_lp L=6e-08 W=2e-07
MXP6 s SN VDD VDD pm1p2_svt_lp L=6e-08 W=2e-07
MI28_MXPA1 ns s VDD VDD pm1p2_svt_lp L=6e-08 W=2.6e-07
MI8_MXPA1 Q ns VDD VDD pm1p2_svt_lp L=6e-08 W=5.85e-07
MI8_MXPA1_2 Q ns VDD VDD pm1p2_svt_lp L=6e-08 W=5.85e-07
MI8_MXPA1_3 Q ns VDD VDD pm1p2_svt_lp L=6e-08 W=5.85e-07
MI23_MXPA1 bclk_ nclk_ VDD VDD pm1p2_svt_lp L=6e-08 W=2.4e-07
MI22_MXPA1 nclk_ CKN VDD VDD pm1p2_svt_lp L=6e-08 W=3.6e-07
.ENDS

.SUBCKT MSDFFQX0P5H9R Q VDD VSS CK D0 D1 S0 SE SI
MI70_MXNA1 ns0 S0 VSS VSS nm1p2_svt_lp L=6e-08 W=2.3e-07
MI112_MXNA1 nd1 D1 VSS VSS nm1p2_svt_lp L=6e-08 W=2e-07
MI110_MXNOE nenmux S0 nd1 VSS nm1p2_svt_lp L=6e-08 W=2e-07
MI111_MXNOE nenmux ns0 nd0 VSS nm1p2_svt_lp L=6e-08 W=2e-07
MI113_MXNA1 nd0 D0 VSS VSS nm1p2_svt_lp L=6e-08 W=2e-07
MI57_MXNA1 nse SE VSS VSS nm1p2_svt_lp L=6e-08 W=1.5e-07
MI95_MXNOE nsemux nse nenmux VSS nm1p2_svt_lp L=6e-08 W=2e-07
MI69_MXNOE nsemux SE XI69_n1 VSS nm1p2_svt_lp L=6e-08 W=1.5e-07
MI69_MXNA1 XI69_n1 SI VSS VSS nm1p2_svt_lp L=6e-08 W=1.5e-07
MI93_MXNA1 semux nsemux VSS VSS nm1p2_svt_lp L=6e-08 W=2.6e-07
MI33_MXNOE m nclk semux VSS nm1p2_svt_lp L=6e-08 W=1.5e-07
MI31_MXNOE m bclk XI31_n1 VSS nm1p2_svt_lp L=6e-08 W=1.5e-07
MI31_MXNA1 XI31_n1 nm VSS VSS nm1p2_svt_lp L=6e-08 W=1.5e-07
MI32_MXNA1 nm m VSS VSS nm1p2_svt_lp L=6e-08 W=2.3e-07
MI20_MXNOE ns bclk nm VSS nm1p2_svt_lp L=6e-08 W=1.5e-07
MI68_MXNOE ns nclk XI68_n1 VSS nm1p2_svt_lp L=6e-08 W=1.5e-07
MI68_MXNA1 XI68_n1 s VSS VSS nm1p2_svt_lp L=6e-08 W=1.5e-07
MI28_MXNA1 s ns VSS VSS nm1p2_svt_lp L=6e-08 W=1.2e-07
MI75_MXNA1 Q ns VSS VSS nm1p2_svt_lp L=6e-08 W=2.1e-07
MI23_MXNA1 bclk nclk VSS VSS nm1p2_svt_lp L=6e-08 W=1.5e-07
MI22_MXNA1 nclk CK VSS VSS nm1p2_svt_lp L=6e-08 W=1.5e-07
MI70_MXPA1 ns0 S0 VDD VDD pm1p2_svt_lp L=6e-08 W=3.2e-07
MI112_MXPA1 nd1 D1 VDD VDD pm1p2_svt_lp L=6e-08 W=5e-07
MI110_MXPOEN nenmux ns0 nd1 VDD pm1p2_svt_lp L=6e-08 W=2.8e-07
MI111_MXPOEN nenmux S0 nd0 VDD pm1p2_svt_lp L=6e-08 W=2.8e-07
MI113_MXPA1 nd0 D0 VDD VDD pm1p2_svt_lp L=6e-08 W=5e-07
MI57_MXPA1 nse SE VDD VDD pm1p2_svt_lp L=6e-08 W=2e-07
MI95_MXPOEN nsemux SE nenmux VDD pm1p2_svt_lp L=6e-08 W=2.8e-07
MI69_MXPOEN nsemux nse XI69_p1 VDD pm1p2_svt_lp L=6e-08 W=1.5e-07
MI69_MXPA1 XI69_p1 SI VDD VDD pm1p2_svt_lp L=6e-08 W=1.5e-07
MI93_MXPA1 semux nsemux VDD VDD pm1p2_svt_lp L=6e-08 W=2.6e-07
MI33_MXPOEN m bclk semux VDD pm1p2_svt_lp L=6e-08 W=1.5e-07
MI31_MXPOEN m nclk XI31_p1 VDD pm1p2_svt_lp L=6e-08 W=1.5e-07
MI31_MXPA1 XI31_p1 nm VDD VDD pm1p2_svt_lp L=6e-08 W=1.5e-07
MI32_MXPA1 nm m VDD VDD pm1p2_svt_lp L=6e-08 W=2.1e-07
MI20_MXPOEN ns nclk nm VDD pm1p2_svt_lp L=6e-08 W=1.5e-07
MI68_MXPOEN ns bclk XI68_p1 VDD pm1p2_svt_lp L=6e-08 W=1.5e-07
MI68_MXPA1 XI68_p1 s VDD VDD pm1p2_svt_lp L=6e-08 W=1.5e-07
MI28_MXPA1 s ns VDD VDD pm1p2_svt_lp L=6e-08 W=1.2e-07
MI75_MXPA1 Q ns VDD VDD pm1p2_svt_lp L=6e-08 W=2.95e-07
MI23_MXPA1 bclk nclk VDD VDD pm1p2_svt_lp L=6e-08 W=1.9e-07
MI22_MXPA1 nclk CK VDD VDD pm1p2_svt_lp L=6e-08 W=1.7e-07
.ENDS

.SUBCKT MSDFFQX1H9R Q VDD VSS CK D0 D1 S0 SE SI
MI70_MXNA1 ns0 S0 VSS VSS nm1p2_svt_lp L=6e-08 W=3e-07
MI112_MXNA1 nd1 D1 VSS VSS nm1p2_svt_lp L=6e-08 W=2.6e-07
MI110_MXNOE nenmux S0 nd1 VSS nm1p2_svt_lp L=6e-08 W=2.6e-07
MI111_MXNOE nenmux ns0 nd0 VSS nm1p2_svt_lp L=6e-08 W=2.6e-07
MI113_MXNA1 nd0 D0 VSS VSS nm1p2_svt_lp L=6e-08 W=2.6e-07
MI57_MXNA1 nse SE VSS VSS nm1p2_svt_lp L=6e-08 W=1.5e-07
MI95_MXNOE nsemux nse nenmux VSS nm1p2_svt_lp L=6e-08 W=2.6e-07
MI69_MXNOE nsemux SE XI69_n1 VSS nm1p2_svt_lp L=6e-08 W=1.5e-07
MI69_MXNA1 XI69_n1 SI VSS VSS nm1p2_svt_lp L=6e-08 W=1.5e-07
MI93_MXNA1 semux nsemux VSS VSS nm1p2_svt_lp L=6e-08 W=2.6e-07
MI33_MXNOE m nclk semux VSS nm1p2_svt_lp L=6e-08 W=2.6e-07
MI31_MXNOE m bclk XI31_n1 VSS nm1p2_svt_lp L=6e-08 W=1.5e-07
MI31_MXNA1 XI31_n1 nm VSS VSS nm1p2_svt_lp L=6e-08 W=1.5e-07
MI32_MXNA1 nm m VSS VSS nm1p2_svt_lp L=6e-08 W=2.6e-07
MI20_MXNOE ns bclk nm VSS nm1p2_svt_lp L=6e-08 W=2.6e-07
MI68_MXNOE ns nclk XI68_n1 VSS nm1p2_svt_lp L=6e-08 W=1.5e-07
MI68_MXNA1 XI68_n1 s VSS VSS nm1p2_svt_lp L=6e-08 W=1.5e-07
MI28_MXNA1 s ns VSS VSS nm1p2_svt_lp L=6e-08 W=1.2e-07
MI75_MXNA1 Q ns VSS VSS nm1p2_svt_lp L=6e-08 W=4.2e-07
MI23_MXNA1 bclk nclk VSS VSS nm1p2_svt_lp L=6e-08 W=1.5e-07
MI22_MXNA1 nclk CK VSS VSS nm1p2_svt_lp L=6e-08 W=1.7e-07
MI70_MXPA1 ns0 S0 VDD VDD pm1p2_svt_lp L=6e-08 W=4.2e-07
MI112_MXPA1 nd1 D1 VDD VDD pm1p2_svt_lp L=6e-08 W=5.8e-07
MI110_MXPOEN nenmux ns0 nd1 VDD pm1p2_svt_lp L=6e-08 W=3.6e-07
MI111_MXPOEN nenmux S0 nd0 VDD pm1p2_svt_lp L=6e-08 W=3.6e-07
MI113_MXPA1 nd0 D0 VDD VDD pm1p2_svt_lp L=6e-08 W=5.8e-07
MI57_MXPA1 nse SE VDD VDD pm1p2_svt_lp L=6e-08 W=2e-07
MI95_MXPOEN nsemux SE nenmux VDD pm1p2_svt_lp L=6e-08 W=3.6e-07
MI69_MXPOEN nsemux nse XI69_p1 VDD pm1p2_svt_lp L=6e-08 W=2e-07
MI69_MXPA1 XI69_p1 SI VDD VDD pm1p2_svt_lp L=6e-08 W=2e-07
MI93_MXPA1 semux nsemux VDD VDD pm1p2_svt_lp L=6e-08 W=2.6e-07
MI33_MXPOEN m bclk semux VDD pm1p2_svt_lp L=6e-08 W=2.6e-07
MI31_MXPOEN m nclk XI31_p1 VDD pm1p2_svt_lp L=6e-08 W=1.5e-07
MI31_MXPA1 XI31_p1 nm VDD VDD pm1p2_svt_lp L=6e-08 W=1.5e-07
MI32_MXPA1 nm m VDD VDD pm1p2_svt_lp L=6e-08 W=2.8e-07
MI20_MXPOEN ns nclk nm VDD pm1p2_svt_lp L=6e-08 W=2.6e-07
MI68_MXPOEN ns bclk XI68_p1 VDD pm1p2_svt_lp L=6e-08 W=1.5e-07
MI68_MXPA1 XI68_p1 s VDD VDD pm1p2_svt_lp L=6e-08 W=1.5e-07
MI28_MXPA1 s ns VDD VDD pm1p2_svt_lp L=6e-08 W=1.2e-07
MI75_MXPA1 Q ns VDD VDD pm1p2_svt_lp L=6e-08 W=5.85e-07
MI23_MXPA1 bclk nclk VDD VDD pm1p2_svt_lp L=6e-08 W=3e-07
MI22_MXPA1 nclk CK VDD VDD pm1p2_svt_lp L=6e-08 W=1.9e-07
.ENDS

.SUBCKT MSDFFQX2H9R Q VDD VSS CK D0 D1 S0 SE SI
MI70_MXNA1 ns0 S0 VSS VSS nm1p2_svt_lp L=6e-08 W=3e-07
MI112_MXNA1 nd1 D1 VSS VSS nm1p2_svt_lp L=6e-08 W=2.6e-07
MI110_MXNOE nenmux S0 nd1 VSS nm1p2_svt_lp L=6e-08 W=2.6e-07
MI111_MXNOE nenmux ns0 nd0 VSS nm1p2_svt_lp L=6e-08 W=2.6e-07
MI113_MXNA1 nd0 D0 VSS VSS nm1p2_svt_lp L=6e-08 W=2.6e-07
MI57_MXNA1 nse SE VSS VSS nm1p2_svt_lp L=6e-08 W=1.5e-07
MI95_MXNOE nsemux nse nenmux VSS nm1p2_svt_lp L=6e-08 W=2.6e-07
MI69_MXNOE nsemux SE XI69_n1 VSS nm1p2_svt_lp L=6e-08 W=1.5e-07
MI69_MXNA1 XI69_n1 SI VSS VSS nm1p2_svt_lp L=6e-08 W=1.5e-07
MI93_MXNA1 semux nsemux VSS VSS nm1p2_svt_lp L=6e-08 W=3.2e-07
MI33_MXNOE m nclk semux VSS nm1p2_svt_lp L=6e-08 W=3.2e-07
MI31_MXNOE m bclk XI31_n1 VSS nm1p2_svt_lp L=6e-08 W=1.5e-07
MI31_MXNA1 XI31_n1 nm VSS VSS nm1p2_svt_lp L=6e-08 W=1.5e-07
MI32_MXNA1 nm m VSS VSS nm1p2_svt_lp L=6e-08 W=3.5e-07
MI20_MXNOE ns bclk nm VSS nm1p2_svt_lp L=6e-08 W=3.2e-07
MI68_MXNOE ns nclk XI68_n1 VSS nm1p2_svt_lp L=6e-08 W=1.5e-07
MI68_MXNA1 XI68_n1 s VSS VSS nm1p2_svt_lp L=6e-08 W=1.5e-07
MI28_MXNA1 s ns VSS VSS nm1p2_svt_lp L=6e-08 W=1.2e-07
MI75_MXNA1 Q ns VSS VSS nm1p2_svt_lp L=6e-08 W=4.2e-07
MI75_MXNA1_2 Q ns VSS VSS nm1p2_svt_lp L=6e-08 W=4.2e-07
MI23_MXNA1 bclk nclk VSS VSS nm1p2_svt_lp L=6e-08 W=1.7e-07
MI22_MXNA1 nclk CK VSS VSS nm1p2_svt_lp L=6e-08 W=2.1e-07
MI70_MXPA1 ns0 S0 VDD VDD pm1p2_svt_lp L=6e-08 W=4.2e-07
MI112_MXPA1 nd1 D1 VDD VDD pm1p2_svt_lp L=6e-08 W=5.6e-07
MI110_MXPOEN nenmux ns0 nd1 VDD pm1p2_svt_lp L=6e-08 W=4.2e-07
MI111_MXPOEN nenmux S0 nd0 VDD pm1p2_svt_lp L=6e-08 W=4.2e-07
MI113_MXPA1 nd0 D0 VDD VDD pm1p2_svt_lp L=6e-08 W=5.6e-07
MI57_MXPA1 nse SE VDD VDD pm1p2_svt_lp L=6e-08 W=2e-07
MI95_MXPOEN nsemux SE nenmux VDD pm1p2_svt_lp L=6e-08 W=4.2e-07
MI69_MXPOEN nsemux nse XI69_p1 VDD pm1p2_svt_lp L=6e-08 W=2e-07
MI69_MXPA1 XI69_p1 SI VDD VDD pm1p2_svt_lp L=6e-08 W=2e-07
MI93_MXPA1 semux nsemux VDD VDD pm1p2_svt_lp L=6e-08 W=3.2e-07
MI33_MXPOEN m bclk semux VDD pm1p2_svt_lp L=6e-08 W=3.2e-07
MI31_MXPOEN m nclk XI31_p1 VDD pm1p2_svt_lp L=6e-08 W=1.5e-07
MI31_MXPA1 XI31_p1 nm VDD VDD pm1p2_svt_lp L=6e-08 W=1.5e-07
MI32_MXPA1 nm m VDD VDD pm1p2_svt_lp L=6e-08 W=4.55e-07
MI20_MXPOEN ns nclk nm VDD pm1p2_svt_lp L=6e-08 W=3.2e-07
MI68_MXPOEN ns bclk XI68_p1 VDD pm1p2_svt_lp L=6e-08 W=1.5e-07
MI68_MXPA1 XI68_p1 s VDD VDD pm1p2_svt_lp L=6e-08 W=1.5e-07
MI28_MXPA1 s ns VDD VDD pm1p2_svt_lp L=6e-08 W=1.2e-07
MI75_MXPA1 Q ns VDD VDD pm1p2_svt_lp L=6e-08 W=5.85e-07
MI75_MXPA1_2 Q ns VDD VDD pm1p2_svt_lp L=6e-08 W=5.85e-07
MI23_MXPA1 bclk nclk VDD VDD pm1p2_svt_lp L=6e-08 W=3.3e-07
MI22_MXPA1 nclk CK VDD VDD pm1p2_svt_lp L=6e-08 W=2.3e-07
.ENDS

.SUBCKT MSDFFQX3H9R Q VDD VSS CK D0 D1 S0 SE SI
MI70_MXNA1 ns0 S0 VSS VSS nm1p2_svt_lp L=6e-08 W=3.3e-07
MI112_MXNA1 nd1 D1 VSS VSS nm1p2_svt_lp L=6e-08 W=2.6e-07
MI110_MXNOE nenmux S0 nd1 VSS nm1p2_svt_lp L=6e-08 W=2.6e-07
MI111_MXNOE nenmux ns0 nd0 VSS nm1p2_svt_lp L=6e-08 W=2.6e-07
MI113_MXNA1 nd0 D0 VSS VSS nm1p2_svt_lp L=6e-08 W=2.6e-07
MI57_MXNA1 nse SE VSS VSS nm1p2_svt_lp L=6e-08 W=1.5e-07
MI95_MXNOE nsemux nse nenmux VSS nm1p2_svt_lp L=6e-08 W=2.6e-07
MI69_MXNOE nsemux SE XI69_n1 VSS nm1p2_svt_lp L=6e-08 W=1.5e-07
MI69_MXNA1 XI69_n1 SI VSS VSS nm1p2_svt_lp L=6e-08 W=1.5e-07
MI93_MXNA1 semux nsemux VSS VSS nm1p2_svt_lp L=6e-08 W=3.9e-07
MI33_MXNOE m nclk semux VSS nm1p2_svt_lp L=6e-08 W=3.9e-07
MI31_MXNOE m bclk XI31_n1 VSS nm1p2_svt_lp L=6e-08 W=1.5e-07
MI31_MXNA1 XI31_n1 nm VSS VSS nm1p2_svt_lp L=6e-08 W=1.5e-07
MI32_MXNA1 nm m VSS VSS nm1p2_svt_lp L=6e-08 W=3.9e-07
MI20_MXNOE ns bclk nm VSS nm1p2_svt_lp L=6e-08 W=3.9e-07
MI68_MXNOE ns nclk XI68_n1 VSS nm1p2_svt_lp L=6e-08 W=1.5e-07
MI68_MXNA1 XI68_n1 s VSS VSS nm1p2_svt_lp L=6e-08 W=1.5e-07
MI28_MXNA1 s ns VSS VSS nm1p2_svt_lp L=6e-08 W=1.2e-07
MI75_MXNA1 Q ns VSS VSS nm1p2_svt_lp L=6e-08 W=4.2e-07
MI75_MXNA1_2 Q ns VSS VSS nm1p2_svt_lp L=6e-08 W=4.2e-07
MI75_MXNA1_3 Q ns VSS VSS nm1p2_svt_lp L=6e-08 W=4.2e-07
MI23_MXNA1 bclk nclk VSS VSS nm1p2_svt_lp L=6e-08 W=1.8e-07
MI22_MXNA1 nclk CK VSS VSS nm1p2_svt_lp L=6e-08 W=2.2e-07
MI70_MXPA1 ns0 S0 VDD VDD pm1p2_svt_lp L=6e-08 W=4.6e-07
MI112_MXPA1 nd1 D1 VDD VDD pm1p2_svt_lp L=6e-08 W=5.4e-07
MI110_MXPOEN nenmux ns0 nd1 VDD pm1p2_svt_lp L=6e-08 W=4.5e-07
MI111_MXPOEN nenmux S0 nd0 VDD pm1p2_svt_lp L=6e-08 W=4.5e-07
MI113_MXPA1 nd0 D0 VDD VDD pm1p2_svt_lp L=6e-08 W=5.4e-07
MI57_MXPA1 nse SE VDD VDD pm1p2_svt_lp L=6e-08 W=2e-07
MI95_MXPOEN nsemux SE nenmux VDD pm1p2_svt_lp L=6e-08 W=4.5e-07
MI69_MXPOEN nsemux nse XI69_p1 VDD pm1p2_svt_lp L=6e-08 W=2e-07
MI69_MXPA1 XI69_p1 SI VDD VDD pm1p2_svt_lp L=6e-08 W=2e-07
MI93_MXPA1 semux nsemux VDD VDD pm1p2_svt_lp L=6e-08 W=3.9e-07
MI33_MXPOEN m bclk semux VDD pm1p2_svt_lp L=6e-08 W=3.9e-07
MI31_MXPOEN m nclk XI31_p1 VDD pm1p2_svt_lp L=6e-08 W=1.5e-07
MI31_MXPA1 XI31_p1 nm VDD VDD pm1p2_svt_lp L=6e-08 W=1.5e-07
MI32_MXPA1 nm m VDD VDD pm1p2_svt_lp L=6e-08 W=5.7e-07
MI20_MXPOEN ns nclk nm VDD pm1p2_svt_lp L=6e-08 W=3.9e-07
MI68_MXPOEN ns bclk XI68_p1 VDD pm1p2_svt_lp L=6e-08 W=1.5e-07
MI68_MXPA1 XI68_p1 s VDD VDD pm1p2_svt_lp L=6e-08 W=1.5e-07
MI28_MXPA1 s ns VDD VDD pm1p2_svt_lp L=6e-08 W=1.2e-07
MI75_MXPA1 Q ns VDD VDD pm1p2_svt_lp L=6e-08 W=5.85e-07
MI75_MXPA1_2 Q ns VDD VDD pm1p2_svt_lp L=6e-08 W=5.85e-07
MI75_MXPA1_3 Q ns VDD VDD pm1p2_svt_lp L=6e-08 W=5.85e-07
MI23_MXPA1 bclk nclk VDD VDD pm1p2_svt_lp L=6e-08 W=3.6e-07
MI22_MXPA1 nclk CK VDD VDD pm1p2_svt_lp L=6e-08 W=2.4e-07
.ENDS

.SUBCKT MSDFFQX4H9R Q VDD VSS CK D0 D1 S0 SE SI
MI70_MXNA1 ns0 S0 VSS VSS nm1p2_svt_lp L=6e-08 W=3.5e-07
MI112_MXNA1 nd1 D1 VSS VSS nm1p2_svt_lp L=6e-08 W=3.3e-07
MI110_MXNOE nenmux S0 nd1 VSS nm1p2_svt_lp L=6e-08 W=3.3e-07
MI111_MXNOE nenmux ns0 nd0 VSS nm1p2_svt_lp L=6e-08 W=3.3e-07
MI113_MXNA1 nd0 D0 VSS VSS nm1p2_svt_lp L=6e-08 W=3.3e-07
MI57_MXNA1 nse SE VSS VSS nm1p2_svt_lp L=6e-08 W=1.5e-07
MI95_MXNOE nsemux nse nenmux VSS nm1p2_svt_lp L=6e-08 W=3.3e-07
MI69_MXNOE nsemux SE XI69_n1 VSS nm1p2_svt_lp L=6e-08 W=1.5e-07
MI69_MXNA1 XI69_n1 SI VSS VSS nm1p2_svt_lp L=6e-08 W=1.5e-07
MI93_MXNA1 semux nsemux VSS VSS nm1p2_svt_lp L=6e-08 W=4.5e-07
MI33_MXNOE m nclk semux VSS nm1p2_svt_lp L=6e-08 W=4.5e-07
MI31_MXNOE m bclk XI31_n1 VSS nm1p2_svt_lp L=6e-08 W=1.5e-07
MI31_MXNA1 XI31_n1 nm VSS VSS nm1p2_svt_lp L=6e-08 W=1.5e-07
MI32_MXNA1 nm m VSS VSS nm1p2_svt_lp L=6e-08 W=3.1e-07
MI20_MXNOE ns bclk nm VSS nm1p2_svt_lp L=6e-08 W=4.5e-07
MI68_MXNOE ns nclk XI68_n1 VSS nm1p2_svt_lp L=6e-08 W=1.5e-07
MI68_MXNA1 XI68_n1 s VSS VSS nm1p2_svt_lp L=6e-08 W=1.5e-07
MI28_MXNA1 s ns VSS VSS nm1p2_svt_lp L=6e-08 W=1.2e-07
MI75_MXNA1 Q ns VSS VSS nm1p2_svt_lp L=6e-08 W=4.2e-07
MI75_MXNA1_2 Q ns VSS VSS nm1p2_svt_lp L=6e-08 W=4.2e-07
MI75_MXNA1_3 Q ns VSS VSS nm1p2_svt_lp L=6e-08 W=4.2e-07
MI75_MXNA1_4 Q ns VSS VSS nm1p2_svt_lp L=6e-08 W=4.2e-07
MI23_MXNA1 bclk nclk VSS VSS nm1p2_svt_lp L=6e-08 W=2.1e-07
MI22_MXNA1 nclk CK VSS VSS nm1p2_svt_lp L=6e-08 W=2.5e-07
MI70_MXPA1 ns0 S0 VDD VDD pm1p2_svt_lp L=6e-08 W=4.95e-07
MI112_MXPA1 nd1 D1 VDD VDD pm1p2_svt_lp L=6e-08 W=5.85e-07
MI110_MXPOEN nenmux ns0 nd1 VDD pm1p2_svt_lp L=6e-08 W=5.6e-07
MI111_MXPOEN nenmux S0 nd0 VDD pm1p2_svt_lp L=6e-08 W=5.6e-07
MI113_MXPA1 nd0 D0 VDD VDD pm1p2_svt_lp L=6e-08 W=5.85e-07
MI57_MXPA1 nse SE VDD VDD pm1p2_svt_lp L=6e-08 W=2e-07
MI95_MXPOEN nsemux SE nenmux VDD pm1p2_svt_lp L=6e-08 W=5.6e-07
MI69_MXPOEN nsemux nse XI69_p1 VDD pm1p2_svt_lp L=6e-08 W=2e-07
MI69_MXPA1 XI69_p1 SI VDD VDD pm1p2_svt_lp L=6e-08 W=2e-07
MI93_MXPA1 semux nsemux VDD VDD pm1p2_svt_lp L=6e-08 W=4.5e-07
MI33_MXPOEN m bclk semux VDD pm1p2_svt_lp L=6e-08 W=4.5e-07
MI31_MXPOEN m nclk XI31_p1 VDD pm1p2_svt_lp L=6e-08 W=1.5e-07
MI31_MXPA1 XI31_p1 nm VDD VDD pm1p2_svt_lp L=6e-08 W=1.5e-07
MI32_MXPA1 nm m VDD VDD pm1p2_svt_lp L=6e-08 W=5.85e-07
MI20_MXPOEN ns nclk nm VDD pm1p2_svt_lp L=6e-08 W=4.5e-07
MI68_MXPOEN ns bclk XI68_p1 VDD pm1p2_svt_lp L=6e-08 W=1.5e-07
MI68_MXPA1 XI68_p1 s VDD VDD pm1p2_svt_lp L=6e-08 W=1.5e-07
MI28_MXPA1 s ns VDD VDD pm1p2_svt_lp L=6e-08 W=1.2e-07
MI75_MXPA1 Q ns VDD VDD pm1p2_svt_lp L=6e-08 W=5.85e-07
MI75_MXPA1_2 Q ns VDD VDD pm1p2_svt_lp L=6e-08 W=5.85e-07
MI75_MXPA1_3 Q ns VDD VDD pm1p2_svt_lp L=6e-08 W=5.85e-07
MI75_MXPA1_4 Q ns VDD VDD pm1p2_svt_lp L=6e-08 W=5.85e-07
MI23_MXPA1 bclk nclk VDD VDD pm1p2_svt_lp L=6e-08 W=4.2e-07
MI22_MXPA1 nclk CK VDD VDD pm1p2_svt_lp L=6e-08 W=2.8e-07
.ENDS

.SUBCKT MSDFFQNX0P5H9R QN VDD VSS CK D0 D1 S0 SE SI
MI70_MXNA1 ns0 S0 VSS VSS nm1p2_svt_lp L=6e-08 W=2.3e-07
MI112_MXNA1 nd1 D1 VSS VSS nm1p2_svt_lp L=6e-08 W=2e-07
MI110_MXNOE nenmux S0 nd1 VSS nm1p2_svt_lp L=6e-08 W=2e-07
MI111_MXNOE nenmux ns0 nd0 VSS nm1p2_svt_lp L=6e-08 W=2e-07
MI113_MXNA1 nd0 D0 VSS VSS nm1p2_svt_lp L=6e-08 W=2e-07
MI57_MXNA1 nse SE VSS VSS nm1p2_svt_lp L=6e-08 W=1.5e-07
MI95_MXNOE nsemux nse nenmux VSS nm1p2_svt_lp L=6e-08 W=2e-07
MI69_MXNOE nsemux SE XI69_n1 VSS nm1p2_svt_lp L=6e-08 W=1.5e-07
MI69_MXNA1 XI69_n1 SI VSS VSS nm1p2_svt_lp L=6e-08 W=1.5e-07
MI93_MXNA1 semux nsemux VSS VSS nm1p2_svt_lp L=6e-08 W=1.8e-07
MI33_MXNOE m nclk semux VSS nm1p2_svt_lp L=6e-08 W=1.5e-07
MI31_MXNOE m bclk XI31_n1 VSS nm1p2_svt_lp L=6e-08 W=1.5e-07
MI31_MXNA1 XI31_n1 nm VSS VSS nm1p2_svt_lp L=6e-08 W=1.5e-07
MI32_MXNA1 nm m VSS VSS nm1p2_svt_lp L=6e-08 W=1.5e-07
MI20_MXNOE ns bclk nm VSS nm1p2_svt_lp L=6e-08 W=1.5e-07
MI29_MXNOE ns nclk XI29_n1 VSS nm1p2_svt_lp L=6e-08 W=1.5e-07
MI29_MXNA1 XI29_n1 s VSS VSS nm1p2_svt_lp L=6e-08 W=1.5e-07
MI28_MXNA1 s ns VSS VSS nm1p2_svt_lp L=6e-08 W=1.5e-07
MI8_MXNA1 QN s VSS VSS nm1p2_svt_lp L=6e-08 W=2.1e-07
MI23_MXNA1 bclk nclk VSS VSS nm1p2_svt_lp L=6e-08 W=1.5e-07
MI22_MXNA1 nclk CK VSS VSS nm1p2_svt_lp L=6e-08 W=1.5e-07
MI70_MXPA1 ns0 S0 VDD VDD pm1p2_svt_lp L=6e-08 W=3.2e-07
MI112_MXPA1 nd1 D1 VDD VDD pm1p2_svt_lp L=6e-08 W=4.4e-07
MI110_MXPOEN nenmux ns0 nd1 VDD pm1p2_svt_lp L=6e-08 W=2.8e-07
MI111_MXPOEN nenmux S0 nd0 VDD pm1p2_svt_lp L=6e-08 W=2.8e-07
MI113_MXPA1 nd0 D0 VDD VDD pm1p2_svt_lp L=6e-08 W=4.4e-07
MI57_MXPA1 nse SE VDD VDD pm1p2_svt_lp L=6e-08 W=2e-07
MI95_MXPOEN nsemux SE nenmux VDD pm1p2_svt_lp L=6e-08 W=2.8e-07
MI69_MXPOEN nsemux nse XI69_p1 VDD pm1p2_svt_lp L=6e-08 W=1.5e-07
MI69_MXPA1 XI69_p1 SI VDD VDD pm1p2_svt_lp L=6e-08 W=1.5e-07
MI93_MXPA1 semux nsemux VDD VDD pm1p2_svt_lp L=6e-08 W=1.8e-07
MI33_MXPOEN m bclk semux VDD pm1p2_svt_lp L=6e-08 W=1.5e-07
MI31_MXPOEN m nclk XI31_p1 VDD pm1p2_svt_lp L=6e-08 W=1.5e-07
MI31_MXPA1 XI31_p1 nm VDD VDD pm1p2_svt_lp L=6e-08 W=1.5e-07
MI32_MXPA1 nm m VDD VDD pm1p2_svt_lp L=6e-08 W=2.2e-07
MI20_MXPOEN ns nclk nm VDD pm1p2_svt_lp L=6e-08 W=1.5e-07
MI29_MXPOEN ns bclk XI29_p1 VDD pm1p2_svt_lp L=6e-08 W=1.5e-07
MI29_MXPA1 XI29_p1 s VDD VDD pm1p2_svt_lp L=6e-08 W=1.5e-07
MI28_MXPA1 s ns VDD VDD pm1p2_svt_lp L=6e-08 W=3e-07
MI8_MXPA1 QN s VDD VDD pm1p2_svt_lp L=6e-08 W=2.95e-07
MI23_MXPA1 bclk nclk VDD VDD pm1p2_svt_lp L=6e-08 W=1.9e-07
MI22_MXPA1 nclk CK VDD VDD pm1p2_svt_lp L=6e-08 W=1.7e-07
.ENDS

.SUBCKT MSDFFQNX1H9R QN VDD VSS CK D0 D1 S0 SE SI
MI70_MXNA1 ns0 S0 VSS VSS nm1p2_svt_lp L=6e-08 W=2.75e-07
MI112_MXNA1 nd1 D1 VSS VSS nm1p2_svt_lp L=6e-08 W=2.6e-07
MI110_MXNOE nenmux S0 nd1 VSS nm1p2_svt_lp L=6e-08 W=2.6e-07
MI111_MXNOE nenmux ns0 nd0 VSS nm1p2_svt_lp L=6e-08 W=2.6e-07
MI113_MXNA1 nd0 D0 VSS VSS nm1p2_svt_lp L=6e-08 W=2.6e-07
MI57_MXNA1 nse SE VSS VSS nm1p2_svt_lp L=6e-08 W=1.5e-07
MI95_MXNOE nsemux nse nenmux VSS nm1p2_svt_lp L=6e-08 W=2.6e-07
MI69_MXNOE nsemux SE XI69_n1 VSS nm1p2_svt_lp L=6e-08 W=1.5e-07
MI69_MXNA1 XI69_n1 SI VSS VSS nm1p2_svt_lp L=6e-08 W=1.5e-07
MI93_MXNA1 semux nsemux VSS VSS nm1p2_svt_lp L=6e-08 W=2.6e-07
MI33_MXNOE m nclk semux VSS nm1p2_svt_lp L=6e-08 W=2.6e-07
MI31_MXNOE m bclk XI31_n1 VSS nm1p2_svt_lp L=6e-08 W=1.5e-07
MI31_MXNA1 XI31_n1 nm VSS VSS nm1p2_svt_lp L=6e-08 W=1.5e-07
MI32_MXNA1 nm m VSS VSS nm1p2_svt_lp L=6e-08 W=3.2e-07
MI20_MXNOE ns bclk nm VSS nm1p2_svt_lp L=6e-08 W=2.6e-07
MI29_MXNOE ns nclk XI29_n1 VSS nm1p2_svt_lp L=6e-08 W=1.5e-07
MI29_MXNA1 XI29_n1 s VSS VSS nm1p2_svt_lp L=6e-08 W=1.5e-07
MI28_MXNA1 s ns VSS VSS nm1p2_svt_lp L=6e-08 W=2.7e-07
MI8_MXNA1 QN s VSS VSS nm1p2_svt_lp L=6e-08 W=4.2e-07
MI23_MXNA1 bclk nclk VSS VSS nm1p2_svt_lp L=6e-08 W=1.5e-07
MI22_MXNA1 nclk CK VSS VSS nm1p2_svt_lp L=6e-08 W=1.7e-07
MI70_MXPA1 ns0 S0 VDD VDD pm1p2_svt_lp L=6e-08 W=3.85e-07
MI112_MXPA1 nd1 D1 VDD VDD pm1p2_svt_lp L=6e-08 W=5.7e-07
MI110_MXPOEN nenmux ns0 nd1 VDD pm1p2_svt_lp L=6e-08 W=3.6e-07
MI111_MXPOEN nenmux S0 nd0 VDD pm1p2_svt_lp L=6e-08 W=3.6e-07
MI113_MXPA1 nd0 D0 VDD VDD pm1p2_svt_lp L=6e-08 W=5.7e-07
MI57_MXPA1 nse SE VDD VDD pm1p2_svt_lp L=6e-08 W=2e-07
MI95_MXPOEN nsemux SE nenmux VDD pm1p2_svt_lp L=6e-08 W=3.6e-07
MI69_MXPOEN nsemux nse XI69_p1 VDD pm1p2_svt_lp L=6e-08 W=2e-07
MI69_MXPA1 XI69_p1 SI VDD VDD pm1p2_svt_lp L=6e-08 W=2e-07
MI93_MXPA1 semux nsemux VDD VDD pm1p2_svt_lp L=6e-08 W=2.6e-07
MI33_MXPOEN m bclk semux VDD pm1p2_svt_lp L=6e-08 W=2.6e-07
MI31_MXPOEN m nclk XI31_p1 VDD pm1p2_svt_lp L=6e-08 W=1.5e-07
MI31_MXPA1 XI31_p1 nm VDD VDD pm1p2_svt_lp L=6e-08 W=1.5e-07
MI32_MXPA1 nm m VDD VDD pm1p2_svt_lp L=6e-08 W=4.1e-07
MI20_MXPOEN ns nclk nm VDD pm1p2_svt_lp L=6e-08 W=2.6e-07
MI29_MXPOEN ns bclk XI29_p1 VDD pm1p2_svt_lp L=6e-08 W=1.5e-07
MI29_MXPA1 XI29_p1 s VDD VDD pm1p2_svt_lp L=6e-08 W=1.5e-07
MI28_MXPA1 s ns VDD VDD pm1p2_svt_lp L=6e-08 W=5.2e-07
MI8_MXPA1 QN s VDD VDD pm1p2_svt_lp L=6e-08 W=5.85e-07
MI23_MXPA1 bclk nclk VDD VDD pm1p2_svt_lp L=6e-08 W=3e-07
MI22_MXPA1 nclk CK VDD VDD pm1p2_svt_lp L=6e-08 W=1.9e-07
.ENDS

.SUBCKT MSDFFQNX2H9R QN VDD VSS CK D0 D1 S0 SE SI
MI70_MXNA1 ns0 S0 VSS VSS nm1p2_svt_lp L=6e-08 W=2.6e-07
MI112_MXNA1 nd1 D1 VSS VSS nm1p2_svt_lp L=6e-08 W=2.6e-07
MI110_MXNOE nenmux S0 nd1 VSS nm1p2_svt_lp L=6e-08 W=2.6e-07
MI111_MXNOE nenmux ns0 nd0 VSS nm1p2_svt_lp L=6e-08 W=2.6e-07
MI113_MXNA1 nd0 D0 VSS VSS nm1p2_svt_lp L=6e-08 W=2.6e-07
MI57_MXNA1 nse SE VSS VSS nm1p2_svt_lp L=6e-08 W=1.5e-07
MI95_MXNOE nsemux nse nenmux VSS nm1p2_svt_lp L=6e-08 W=2.6e-07
MI69_MXNOE nsemux SE XI69_n1 VSS nm1p2_svt_lp L=6e-08 W=1.5e-07
MI69_MXNA1 XI69_n1 SI VSS VSS nm1p2_svt_lp L=6e-08 W=1.5e-07
MI93_MXNA1 semux nsemux VSS VSS nm1p2_svt_lp L=6e-08 W=3.2e-07
MI33_MXNOE m nclk semux VSS nm1p2_svt_lp L=6e-08 W=3.2e-07
MI31_MXNOE m bclk XI31_n1 VSS nm1p2_svt_lp L=6e-08 W=1.5e-07
MI31_MXNA1 XI31_n1 nm VSS VSS nm1p2_svt_lp L=6e-08 W=1.5e-07
MI32_MXNA1 nm m VSS VSS nm1p2_svt_lp L=6e-08 W=2.9e-07
MI20_MXNOE ns bclk nm VSS nm1p2_svt_lp L=6e-08 W=3.2e-07
MI29_MXNOE ns nclk XI29_n1 VSS nm1p2_svt_lp L=6e-08 W=1.5e-07
MI29_MXNA1 XI29_n1 s VSS VSS nm1p2_svt_lp L=6e-08 W=1.5e-07
MI28_MXNA1 s ns VSS VSS nm1p2_svt_lp L=6e-08 W=3.2e-07
MI8_MXNA1 QN s VSS VSS nm1p2_svt_lp L=6e-08 W=4.2e-07
MI8_MXNA1_2 QN s VSS VSS nm1p2_svt_lp L=6e-08 W=4.2e-07
MI23_MXNA1 bclk nclk VSS VSS nm1p2_svt_lp L=6e-08 W=1.7e-07
MI22_MXNA1 nclk CK VSS VSS nm1p2_svt_lp L=6e-08 W=2.1e-07
MI70_MXPA1 ns0 S0 VDD VDD pm1p2_svt_lp L=6e-08 W=3.6e-07
MI112_MXPA1 nd1 D1 VDD VDD pm1p2_svt_lp L=6e-08 W=5.7e-07
MI110_MXPOEN nenmux ns0 nd1 VDD pm1p2_svt_lp L=6e-08 W=4.2e-07
MI111_MXPOEN nenmux S0 nd0 VDD pm1p2_svt_lp L=6e-08 W=4.2e-07
MI113_MXPA1 nd0 D0 VDD VDD pm1p2_svt_lp L=6e-08 W=5.7e-07
MI57_MXPA1 nse SE VDD VDD pm1p2_svt_lp L=6e-08 W=2e-07
MI95_MXPOEN nsemux SE nenmux VDD pm1p2_svt_lp L=6e-08 W=4.2e-07
MI69_MXPOEN nsemux nse XI69_p1 VDD pm1p2_svt_lp L=6e-08 W=2e-07
MI69_MXPA1 XI69_p1 SI VDD VDD pm1p2_svt_lp L=6e-08 W=2e-07
MI93_MXPA1 semux nsemux VDD VDD pm1p2_svt_lp L=6e-08 W=3.2e-07
MI33_MXPOEN m bclk semux VDD pm1p2_svt_lp L=6e-08 W=3.2e-07
MI31_MXPOEN m nclk XI31_p1 VDD pm1p2_svt_lp L=6e-08 W=1.5e-07
MI31_MXPA1 XI31_p1 nm VDD VDD pm1p2_svt_lp L=6e-08 W=1.5e-07
MI32_MXPA1 nm m VDD VDD pm1p2_svt_lp L=6e-08 W=2.9e-07
MI20_MXPOEN ns nclk nm VDD pm1p2_svt_lp L=6e-08 W=3.2e-07
MI29_MXPOEN ns bclk XI29_p1 VDD pm1p2_svt_lp L=6e-08 W=1.5e-07
MI29_MXPA1 XI29_p1 s VDD VDD pm1p2_svt_lp L=6e-08 W=1.5e-07
MI28_MXPA1 s ns VDD VDD pm1p2_svt_lp L=6e-08 W=5.2e-07
MI8_MXPA1 QN s VDD VDD pm1p2_svt_lp L=6e-08 W=5.85e-07
MI8_MXPA1_2 QN s VDD VDD pm1p2_svt_lp L=6e-08 W=5.85e-07
MI23_MXPA1 bclk nclk VDD VDD pm1p2_svt_lp L=6e-08 W=3.3e-07
MI22_MXPA1 nclk CK VDD VDD pm1p2_svt_lp L=6e-08 W=2.3e-07
.ENDS

.SUBCKT MSDFFQNX3H9R QN VDD VSS CK D0 D1 S0 SE SI
MI70_MXNA1 ns0 S0 VSS VSS nm1p2_svt_lp L=6e-08 W=2.5e-07
MI112_MXNA1 nd1 D1 VSS VSS nm1p2_svt_lp L=6e-08 W=2.6e-07
MI110_MXNOE nenmux S0 nd1 VSS nm1p2_svt_lp L=6e-08 W=2.6e-07
MI111_MXNOE nenmux ns0 nd0 VSS nm1p2_svt_lp L=6e-08 W=2.6e-07
MI113_MXNA1 nd0 D0 VSS VSS nm1p2_svt_lp L=6e-08 W=2.6e-07
MI57_MXNA1 nse SE VSS VSS nm1p2_svt_lp L=6e-08 W=1.5e-07
MI95_MXNOE nsemux nse nenmux VSS nm1p2_svt_lp L=6e-08 W=2.6e-07
MI69_MXNOE nsemux SE XI69_n1 VSS nm1p2_svt_lp L=6e-08 W=1.5e-07
MI69_MXNA1 XI69_n1 SI VSS VSS nm1p2_svt_lp L=6e-08 W=1.5e-07
MI93_MXNA1 semux nsemux VSS VSS nm1p2_svt_lp L=6e-08 W=3.9e-07
MI33_MXNOE m nclk semux VSS nm1p2_svt_lp L=6e-08 W=3.9e-07
MI31_MXNOE m bclk XI31_n1 VSS nm1p2_svt_lp L=6e-08 W=1.5e-07
MI31_MXNA1 XI31_n1 nm VSS VSS nm1p2_svt_lp L=6e-08 W=1.5e-07
MI32_MXNA1 nm m VSS VSS nm1p2_svt_lp L=6e-08 W=3.7e-07
MI20_MXNOE ns bclk nm VSS nm1p2_svt_lp L=6e-08 W=3.9e-07
MI29_MXNOE ns nclk XI29_n1 VSS nm1p2_svt_lp L=6e-08 W=1.5e-07
MI29_MXNA1 XI29_n1 s VSS VSS nm1p2_svt_lp L=6e-08 W=1.5e-07
MI28_MXNA1 s ns VSS VSS nm1p2_svt_lp L=6e-08 W=3.5e-07
MI8_MXNA1 QN s VSS VSS nm1p2_svt_lp L=6e-08 W=4.2e-07
MI8_MXNA1_2 QN s VSS VSS nm1p2_svt_lp L=6e-08 W=4.2e-07
MI8_MXNA1_3 QN s VSS VSS nm1p2_svt_lp L=6e-08 W=4.2e-07
MI23_MXNA1 bclk nclk VSS VSS nm1p2_svt_lp L=6e-08 W=1.8e-07
MI22_MXNA1 nclk CK VSS VSS nm1p2_svt_lp L=6e-08 W=2.2e-07
MI70_MXPA1 ns0 S0 VDD VDD pm1p2_svt_lp L=6e-08 W=3.5e-07
MI112_MXPA1 nd1 D1 VDD VDD pm1p2_svt_lp L=6e-08 W=5.6e-07
MI110_MXPOEN nenmux ns0 nd1 VDD pm1p2_svt_lp L=6e-08 W=4.5e-07
MI111_MXPOEN nenmux S0 nd0 VDD pm1p2_svt_lp L=6e-08 W=4.5e-07
MI113_MXPA1 nd0 D0 VDD VDD pm1p2_svt_lp L=6e-08 W=5.6e-07
MI57_MXPA1 nse SE VDD VDD pm1p2_svt_lp L=6e-08 W=2e-07
MI95_MXPOEN nsemux SE nenmux VDD pm1p2_svt_lp L=6e-08 W=4.5e-07
MI69_MXPOEN nsemux nse XI69_p1 VDD pm1p2_svt_lp L=6e-08 W=2e-07
MI69_MXPA1 XI69_p1 SI VDD VDD pm1p2_svt_lp L=6e-08 W=2e-07
MI93_MXPA1 semux nsemux VDD VDD pm1p2_svt_lp L=6e-08 W=3.9e-07
MI33_MXPOEN m bclk semux VDD pm1p2_svt_lp L=6e-08 W=3.9e-07
MI31_MXPOEN m nclk XI31_p1 VDD pm1p2_svt_lp L=6e-08 W=1.5e-07
MI31_MXPA1 XI31_p1 nm VDD VDD pm1p2_svt_lp L=6e-08 W=1.5e-07
MI32_MXPA1 nm m VDD VDD pm1p2_svt_lp L=6e-08 W=3.7e-07
MI20_MXPOEN ns nclk nm VDD pm1p2_svt_lp L=6e-08 W=3.9e-07
MI29_MXPOEN ns bclk XI29_p1 VDD pm1p2_svt_lp L=6e-08 W=1.5e-07
MI29_MXPA1 XI29_p1 s VDD VDD pm1p2_svt_lp L=6e-08 W=1.5e-07
MI28_MXPA1 s ns VDD VDD pm1p2_svt_lp L=6e-08 W=5.85e-07
MI8_MXPA1 QN s VDD VDD pm1p2_svt_lp L=6e-08 W=5.85e-07
MI8_MXPA1_2 QN s VDD VDD pm1p2_svt_lp L=6e-08 W=5.85e-07
MI8_MXPA1_3 QN s VDD VDD pm1p2_svt_lp L=6e-08 W=5.85e-07
MI23_MXPA1 bclk nclk VDD VDD pm1p2_svt_lp L=6e-08 W=3.6e-07
MI22_MXPA1 nclk CK VDD VDD pm1p2_svt_lp L=6e-08 W=2.4e-07
.ENDS

.SUBCKT ASDFFQX0P5H9R Q VDD VSS A B CK SE SI
MI57_MXNA1 nse SE VSS VSS nm1p2_svt_lp L=6e-08 W=1.5e-07
MI14_MXNOE nmux SE XI14_n1 VSS nm1p2_svt_lp L=6e-08 W=1.5e-07
MI14_MXNA1 XI14_n1 SI VSS VSS nm1p2_svt_lp L=6e-08 W=1.5e-07
MXN1 n2 nse VSS VSS nm1p2_svt_lp L=6e-08 W=2.5e-07
MXN2 n1 B n2 VSS nm1p2_svt_lp L=6e-08 W=2.5e-07
MXN0 nmux A n1 VSS nm1p2_svt_lp L=6e-08 W=2.5e-07
MI33_MXNOE nm nclk nmux VSS nm1p2_svt_lp L=6e-08 W=1.5e-07
MI31_MXNOE nm bclk XI31_n1 VSS nm1p2_svt_lp L=6e-08 W=1.5e-07
MI31_MXNA1 XI31_n1 m VSS VSS nm1p2_svt_lp L=6e-08 W=1.5e-07
MI32_MXNA1 m nm VSS VSS nm1p2_svt_lp L=6e-08 W=1.9e-07
MI20_MXNOE s bclk m VSS nm1p2_svt_lp L=6e-08 W=1.5e-07
MI29_MXNOE s nclk XI29_n1 VSS nm1p2_svt_lp L=6e-08 W=1.5e-07
MI29_MXNA1 XI29_n1 ns VSS VSS nm1p2_svt_lp L=6e-08 W=1.5e-07
MI28_MXNA1 ns s VSS VSS nm1p2_svt_lp L=6e-08 W=3.2e-07
MI8_MXNA1 Q ns VSS VSS nm1p2_svt_lp L=6e-08 W=2.1e-07
MI23_MXNA1 bclk nclk VSS VSS nm1p2_svt_lp L=6e-08 W=1.5e-07
MI22_MXNA1 nclk CK VSS VSS nm1p2_svt_lp L=6e-08 W=1.5e-07
MI57_MXPA1 nse SE VDD VDD pm1p2_svt_lp L=6e-08 W=2e-07
MI14_MXPOEN nmux nse XI14_p1 VDD pm1p2_svt_lp L=6e-08 W=1.5e-07
MI14_MXPA1 XI14_p1 SI VDD VDD pm1p2_svt_lp L=6e-08 W=1.5e-07
MXP1 p1 SE VDD VDD pm1p2_svt_lp L=6e-08 W=2.5e-07
MXP0 nmux B p1 VDD pm1p2_svt_lp L=6e-08 W=2.5e-07
MXP2 nmux A p1 VDD pm1p2_svt_lp L=6e-08 W=2.5e-07
MI33_MXPOEN nm bclk nmux VDD pm1p2_svt_lp L=6e-08 W=1.5e-07
MI31_MXPOEN nm nclk XI31_p1 VDD pm1p2_svt_lp L=6e-08 W=1.5e-07
MI31_MXPA1 XI31_p1 m VDD VDD pm1p2_svt_lp L=6e-08 W=1.5e-07
MI32_MXPA1 m nm VDD VDD pm1p2_svt_lp L=6e-08 W=3.3e-07
MI20_MXPOEN s nclk m VDD pm1p2_svt_lp L=6e-08 W=1.5e-07
MI29_MXPOEN s bclk XI29_p1 VDD pm1p2_svt_lp L=6e-08 W=1.5e-07
MI29_MXPA1 XI29_p1 ns VDD VDD pm1p2_svt_lp L=6e-08 W=1.5e-07
MI28_MXPA1 ns s VDD VDD pm1p2_svt_lp L=6e-08 W=3.2e-07
MI8_MXPA1 Q ns VDD VDD pm1p2_svt_lp L=6e-08 W=2.95e-07
MI23_MXPA1 bclk nclk VDD VDD pm1p2_svt_lp L=6e-08 W=1.9e-07
MI22_MXPA1 nclk CK VDD VDD pm1p2_svt_lp L=6e-08 W=1.7e-07
.ENDS

.SUBCKT ASDFFQX1H9R Q VDD VSS A B CK SE SI
MI57_MXNA1 nse SE VSS VSS nm1p2_svt_lp L=6e-08 W=1.5e-07
MI14_MXNOE nmux SE XI14_n1 VSS nm1p2_svt_lp L=6e-08 W=1.5e-07
MI14_MXNA1 XI14_n1 SI VSS VSS nm1p2_svt_lp L=6e-08 W=1.5e-07
MXN1 n2 nse VSS VSS nm1p2_svt_lp L=6e-08 W=2.7e-07
MXN2 n1 B n2 VSS nm1p2_svt_lp L=6e-08 W=2.7e-07
MXN0 nmux A n1 VSS nm1p2_svt_lp L=6e-08 W=2.7e-07
MI33_MXNOE nm nclk nmux VSS nm1p2_svt_lp L=6e-08 W=2.6e-07
MI31_MXNOE nm bclk XI31_n1 VSS nm1p2_svt_lp L=6e-08 W=1.5e-07
MI31_MXNA1 XI31_n1 m VSS VSS nm1p2_svt_lp L=6e-08 W=1.5e-07
MI32_MXNA1 m nm VSS VSS nm1p2_svt_lp L=6e-08 W=2.2e-07
MI20_MXNOE s bclk m VSS nm1p2_svt_lp L=6e-08 W=2.6e-07
MI29_MXNOE s nclk XI29_n1 VSS nm1p2_svt_lp L=6e-08 W=1.5e-07
MI29_MXNA1 XI29_n1 ns VSS VSS nm1p2_svt_lp L=6e-08 W=1.5e-07
MI28_MXNA1 ns s VSS VSS nm1p2_svt_lp L=6e-08 W=2.1e-07
MI8_MXNA1 Q ns VSS VSS nm1p2_svt_lp L=6e-08 W=4.2e-07
MI23_MXNA1 bclk nclk VSS VSS nm1p2_svt_lp L=6e-08 W=1.5e-07
MI22_MXNA1 nclk CK VSS VSS nm1p2_svt_lp L=6e-08 W=1.7e-07
MI57_MXPA1 nse SE VDD VDD pm1p2_svt_lp L=6e-08 W=2e-07
MI14_MXPOEN nmux nse XI14_p1 VDD pm1p2_svt_lp L=6e-08 W=2e-07
MI14_MXPA1 XI14_p1 SI VDD VDD pm1p2_svt_lp L=6e-08 W=2e-07
MXP1 p1 SE VDD VDD pm1p2_svt_lp L=6e-08 W=2.7e-07
MXP0 nmux B p1 VDD pm1p2_svt_lp L=6e-08 W=2.7e-07
MXP2 nmux A p1 VDD pm1p2_svt_lp L=6e-08 W=2.7e-07
MI33_MXPOEN nm bclk nmux VDD pm1p2_svt_lp L=6e-08 W=2.6e-07
MI31_MXPOEN nm nclk XI31_p1 VDD pm1p2_svt_lp L=6e-08 W=1.5e-07
MI31_MXPA1 XI31_p1 m VDD VDD pm1p2_svt_lp L=6e-08 W=1.5e-07
MI32_MXPA1 m nm VDD VDD pm1p2_svt_lp L=6e-08 W=3.1e-07
MI20_MXPOEN s nclk m VDD pm1p2_svt_lp L=6e-08 W=2.6e-07
MI29_MXPOEN s bclk XI29_p1 VDD pm1p2_svt_lp L=6e-08 W=1.5e-07
MI29_MXPA1 XI29_p1 ns VDD VDD pm1p2_svt_lp L=6e-08 W=1.5e-07
MI28_MXPA1 ns s VDD VDD pm1p2_svt_lp L=6e-08 W=3.7e-07
MI8_MXPA1 Q ns VDD VDD pm1p2_svt_lp L=6e-08 W=5.85e-07
MI23_MXPA1 bclk nclk VDD VDD pm1p2_svt_lp L=6e-08 W=3e-07
MI22_MXPA1 nclk CK VDD VDD pm1p2_svt_lp L=6e-08 W=1.9e-07
.ENDS

.SUBCKT ASDFFQX2H9R Q VDD VSS A B CK SE SI
MI57_MXNA1 nse SE VSS VSS nm1p2_svt_lp L=6e-08 W=1.5e-07
MI14_MXNOE nmux SE XI14_n1 VSS nm1p2_svt_lp L=6e-08 W=1.5e-07
MI14_MXNA1 XI14_n1 SI VSS VSS nm1p2_svt_lp L=6e-08 W=1.5e-07
MXN1 n2 nse VSS VSS nm1p2_svt_lp L=6e-08 W=3e-07
MXN2 n1 B n2 VSS nm1p2_svt_lp L=6e-08 W=3e-07
MXN0 nmux A n1 VSS nm1p2_svt_lp L=6e-08 W=3e-07
MI33_MXNOE nm nclk nmux VSS nm1p2_svt_lp L=6e-08 W=3.2e-07
MI31_MXNOE nm bclk XI31_n1 VSS nm1p2_svt_lp L=6e-08 W=1.5e-07
MI31_MXNA1 XI31_n1 m VSS VSS nm1p2_svt_lp L=6e-08 W=1.5e-07
MI32_MXNA1 m nm VSS VSS nm1p2_svt_lp L=6e-08 W=2.9e-07
MI20_MXNOE s bclk m VSS nm1p2_svt_lp L=6e-08 W=3.2e-07
MI29_MXNOE s nclk XI29_n1 VSS nm1p2_svt_lp L=6e-08 W=1.5e-07
MI29_MXNA1 XI29_n1 ns VSS VSS nm1p2_svt_lp L=6e-08 W=1.5e-07
MI28_MXNA1 ns s VSS VSS nm1p2_svt_lp L=6e-08 W=2.9e-07
MI8_MXNA1 Q ns VSS VSS nm1p2_svt_lp L=6e-08 W=4.2e-07
MI8_MXNA1_2 Q ns VSS VSS nm1p2_svt_lp L=6e-08 W=4.2e-07
MI23_MXNA1 bclk nclk VSS VSS nm1p2_svt_lp L=6e-08 W=1.7e-07
MI22_MXNA1 nclk CK VSS VSS nm1p2_svt_lp L=6e-08 W=2.1e-07
MI57_MXPA1 nse SE VDD VDD pm1p2_svt_lp L=6e-08 W=2e-07
MI14_MXPOEN nmux nse XI14_p1 VDD pm1p2_svt_lp L=6e-08 W=2e-07
MI14_MXPA1 XI14_p1 SI VDD VDD pm1p2_svt_lp L=6e-08 W=2e-07
MXP1 p1 SE VDD VDD pm1p2_svt_lp L=6e-08 W=3e-07
MXP0 nmux B p1 VDD pm1p2_svt_lp L=6e-08 W=3e-07
MXP2 nmux A p1 VDD pm1p2_svt_lp L=6e-08 W=3e-07
MI33_MXPOEN nm bclk nmux VDD pm1p2_svt_lp L=6e-08 W=3.2e-07
MI31_MXPOEN nm nclk XI31_p1 VDD pm1p2_svt_lp L=6e-08 W=1.5e-07
MI31_MXPA1 XI31_p1 m VDD VDD pm1p2_svt_lp L=6e-08 W=1.5e-07
MI32_MXPA1 m nm VDD VDD pm1p2_svt_lp L=6e-08 W=4e-07
MI20_MXPOEN s nclk m VDD pm1p2_svt_lp L=6e-08 W=3.2e-07
MI29_MXPOEN s bclk XI29_p1 VDD pm1p2_svt_lp L=6e-08 W=1.5e-07
MI29_MXPA1 XI29_p1 ns VDD VDD pm1p2_svt_lp L=6e-08 W=1.5e-07
MI28_MXPA1 ns s VDD VDD pm1p2_svt_lp L=6e-08 W=5e-07
MI8_MXPA1 Q ns VDD VDD pm1p2_svt_lp L=6e-08 W=5.85e-07
MI8_MXPA1_2 Q ns VDD VDD pm1p2_svt_lp L=6e-08 W=5.85e-07
MI23_MXPA1 bclk nclk VDD VDD pm1p2_svt_lp L=6e-08 W=3.3e-07
MI22_MXPA1 nclk CK VDD VDD pm1p2_svt_lp L=6e-08 W=2.3e-07
.ENDS

.SUBCKT ASDFFQX3H9R Q VDD VSS A B CK SE SI
MI57_MXNA1 nse SE VSS VSS nm1p2_svt_lp L=6e-08 W=1.5e-07
MI14_MXNOE nmux SE XI14_n1 VSS nm1p2_svt_lp L=6e-08 W=1.5e-07
MI14_MXNA1 XI14_n1 SI VSS VSS nm1p2_svt_lp L=6e-08 W=1.5e-07
MXN1 n2 nse VSS VSS nm1p2_svt_lp L=6e-08 W=4.95e-07
MXN2 n1 B n2 VSS nm1p2_svt_lp L=6e-08 W=4.95e-07
MXN0 nmux A n1 VSS nm1p2_svt_lp L=6e-08 W=4.95e-07
MI33_MXNOE nm nclk nmux VSS nm1p2_svt_lp L=6e-08 W=3.9e-07
MI31_MXNOE nm bclk XI31_n1 VSS nm1p2_svt_lp L=6e-08 W=1.5e-07
MI31_MXNA1 XI31_n1 m VSS VSS nm1p2_svt_lp L=6e-08 W=1.5e-07
MI32_MXNA1 m nm VSS VSS nm1p2_svt_lp L=6e-08 W=3.9e-07
MI20_MXNOE s bclk m VSS nm1p2_svt_lp L=6e-08 W=3.9e-07
MI29_MXNOE s nclk XI29_n1 VSS nm1p2_svt_lp L=6e-08 W=1.5e-07
MI29_MXNA1 XI29_n1 ns VSS VSS nm1p2_svt_lp L=6e-08 W=1.5e-07
MI28_MXNA1 ns s VSS VSS nm1p2_svt_lp L=6e-08 W=3.2e-07
MI8_MXNA1 Q ns VSS VSS nm1p2_svt_lp L=6e-08 W=4.2e-07
MI8_MXNA1_2 Q ns VSS VSS nm1p2_svt_lp L=6e-08 W=4.2e-07
MI8_MXNA1_3 Q ns VSS VSS nm1p2_svt_lp L=6e-08 W=4.2e-07
MI23_MXNA1 bclk nclk VSS VSS nm1p2_svt_lp L=6e-08 W=1.8e-07
MI22_MXNA1 nclk CK VSS VSS nm1p2_svt_lp L=6e-08 W=2.2e-07
MI57_MXPA1 nse SE VDD VDD pm1p2_svt_lp L=6e-08 W=2e-07
MI14_MXPOEN nmux nse XI14_p1 VDD pm1p2_svt_lp L=6e-08 W=2e-07
MI14_MXPA1 XI14_p1 SI VDD VDD pm1p2_svt_lp L=6e-08 W=2e-07
MXP1 p1 SE VDD VDD pm1p2_svt_lp L=6e-08 W=4.5e-07
MXP0 nmux B p1 VDD pm1p2_svt_lp L=6e-08 W=4.5e-07
MXP2 nmux A p1 VDD pm1p2_svt_lp L=6e-08 W=4.5e-07
MI33_MXPOEN nm bclk nmux VDD pm1p2_svt_lp L=6e-08 W=3.9e-07
MI31_MXPOEN nm nclk XI31_p1 VDD pm1p2_svt_lp L=6e-08 W=1.5e-07
MI31_MXPA1 XI31_p1 m VDD VDD pm1p2_svt_lp L=6e-08 W=1.5e-07
MI32_MXPA1 m nm VDD VDD pm1p2_svt_lp L=6e-08 W=5.1e-07
MI20_MXPOEN s nclk m VDD pm1p2_svt_lp L=6e-08 W=3.9e-07
MI29_MXPOEN s bclk XI29_p1 VDD pm1p2_svt_lp L=6e-08 W=1.5e-07
MI29_MXPA1 XI29_p1 ns VDD VDD pm1p2_svt_lp L=6e-08 W=1.5e-07
MI28_MXPA1 ns s VDD VDD pm1p2_svt_lp L=6e-08 W=5.8e-07
MI8_MXPA1 Q ns VDD VDD pm1p2_svt_lp L=6e-08 W=5.85e-07
MI8_MXPA1_2 Q ns VDD VDD pm1p2_svt_lp L=6e-08 W=5.85e-07
MI8_MXPA1_3 Q ns VDD VDD pm1p2_svt_lp L=6e-08 W=5.85e-07
MI23_MXPA1 bclk nclk VDD VDD pm1p2_svt_lp L=6e-08 W=3.6e-07
MI22_MXPA1 nclk CK VDD VDD pm1p2_svt_lp L=6e-08 W=2.4e-07
.ENDS

.SUBCKT ASDFFQX4H9R Q VDD VSS A B CK SE SI
MI57_MXNA1 nse SE VSS VSS nm1p2_svt_lp L=6e-08 W=1.5e-07
MI14_MXNOE nmux SE XI14_n1 VSS nm1p2_svt_lp L=6e-08 W=1.5e-07
MI14_MXNA1 XI14_n1 SI VSS VSS nm1p2_svt_lp L=6e-08 W=1.5e-07
MXN1 n2 nse VSS VSS nm1p2_svt_lp L=6e-08 W=4.8e-07
MXN2 n1 B n2 VSS nm1p2_svt_lp L=6e-08 W=4.8e-07
MXN0 nmux A n1 VSS nm1p2_svt_lp L=6e-08 W=4.8e-07
MI33_MXNOE nm nclk nmux VSS nm1p2_svt_lp L=6e-08 W=4.5e-07
MI31_MXNOE nm bclk XI31_n1 VSS nm1p2_svt_lp L=6e-08 W=1.5e-07
MI31_MXNA1 XI31_n1 m VSS VSS nm1p2_svt_lp L=6e-08 W=1.5e-07
MI32_MXNA1 m nm VSS VSS nm1p2_svt_lp L=6e-08 W=4.2e-07
MI20_MXNOE s bclk m VSS nm1p2_svt_lp L=6e-08 W=4.5e-07
MI29_MXNOE s nclk XI29_n1 VSS nm1p2_svt_lp L=6e-08 W=1.5e-07
MI29_MXNA1 XI29_n1 ns VSS VSS nm1p2_svt_lp L=6e-08 W=1.5e-07
MI28_MXNA1 ns s VSS VSS nm1p2_svt_lp L=6e-08 W=3.1e-07
MI28_MXNA1_2 ns s VSS VSS nm1p2_svt_lp L=6e-08 W=3.1e-07
MI8_MXNA1 Q ns VSS VSS nm1p2_svt_lp L=6e-08 W=4.2e-07
MI8_MXNA1_2 Q ns VSS VSS nm1p2_svt_lp L=6e-08 W=4.2e-07
MI8_MXNA1_3 Q ns VSS VSS nm1p2_svt_lp L=6e-08 W=4.2e-07
MI8_MXNA1_4 Q ns VSS VSS nm1p2_svt_lp L=6e-08 W=4.2e-07
MI23_MXNA1 bclk nclk VSS VSS nm1p2_svt_lp L=6e-08 W=2.1e-07
MI22_MXNA1 nclk CK VSS VSS nm1p2_svt_lp L=6e-08 W=2.5e-07
MI57_MXPA1 nse SE VDD VDD pm1p2_svt_lp L=6e-08 W=2e-07
MI14_MXPOEN nmux nse XI14_p1 VDD pm1p2_svt_lp L=6e-08 W=2e-07
MI14_MXPA1 XI14_p1 SI VDD VDD pm1p2_svt_lp L=6e-08 W=2e-07
MXP1 p1 SE VDD VDD pm1p2_svt_lp L=6e-08 W=4.5e-07
MXP0 nmux B p1 VDD pm1p2_svt_lp L=6e-08 W=4.5e-07
MXP2 nmux A p1 VDD pm1p2_svt_lp L=6e-08 W=4.5e-07
MI33_MXPOEN nm bclk nmux VDD pm1p2_svt_lp L=6e-08 W=4.5e-07
MI31_MXPOEN nm nclk XI31_p1 VDD pm1p2_svt_lp L=6e-08 W=1.5e-07
MI31_MXPA1 XI31_p1 m VDD VDD pm1p2_svt_lp L=6e-08 W=1.5e-07
MI32_MXPA1 m nm VDD VDD pm1p2_svt_lp L=6e-08 W=5.85e-07
MI20_MXPOEN s nclk m VDD pm1p2_svt_lp L=6e-08 W=4.5e-07
MI29_MXPOEN s bclk XI29_p1 VDD pm1p2_svt_lp L=6e-08 W=1.5e-07
MI29_MXPA1 XI29_p1 ns VDD VDD pm1p2_svt_lp L=6e-08 W=1.5e-07
MI28_MXPA1 ns s VDD VDD pm1p2_svt_lp L=6e-08 W=5e-07
MI28_MXPA1_2 ns s VDD VDD pm1p2_svt_lp L=6e-08 W=5e-07
MI8_MXPA1 Q ns VDD VDD pm1p2_svt_lp L=6e-08 W=5.85e-07
MI8_MXPA1_2 Q ns VDD VDD pm1p2_svt_lp L=6e-08 W=5.85e-07
MI8_MXPA1_3 Q ns VDD VDD pm1p2_svt_lp L=6e-08 W=5.85e-07
MI8_MXPA1_4 Q ns VDD VDD pm1p2_svt_lp L=6e-08 W=5.85e-07
MI23_MXPA1 bclk nclk VDD VDD pm1p2_svt_lp L=6e-08 W=4.2e-07
MI22_MXPA1 nclk CK VDD VDD pm1p2_svt_lp L=6e-08 W=2.8e-07
.ENDS

.SUBCKT ASDFFQNX0P5H9R QN VDD VSS A B CK SE SI
MI57_MXNA1 nse SE VSS VSS nm1p2_svt_lp L=6e-08 W=1.5e-07
MI14_MXNOE nmux SE XI14_n1 VSS nm1p2_svt_lp L=6e-08 W=1.5e-07
MI14_MXNA1 XI14_n1 SI VSS VSS nm1p2_svt_lp L=6e-08 W=1.5e-07
MXN1 n2 nse VSS VSS nm1p2_svt_lp L=6e-08 W=3e-07
MXN2 n1 B n2 VSS nm1p2_svt_lp L=6e-08 W=3e-07
MXN0 nmux A n1 VSS nm1p2_svt_lp L=6e-08 W=3e-07
MI33_MXNOE nm nclk nmux VSS nm1p2_svt_lp L=6e-08 W=1.5e-07
MI31_MXNOE nm bclk XI31_n1 VSS nm1p2_svt_lp L=6e-08 W=1.5e-07
MI31_MXNA1 XI31_n1 m VSS VSS nm1p2_svt_lp L=6e-08 W=1.5e-07
MI32_MXNA1 m nm VSS VSS nm1p2_svt_lp L=6e-08 W=1.5e-07
MI20_MXNOE s bclk m VSS nm1p2_svt_lp L=6e-08 W=1.5e-07
MI69_MXNOE s nclk XI69_n1 VSS nm1p2_svt_lp L=6e-08 W=1.5e-07
MI69_MXNA1 XI69_n1 ns VSS VSS nm1p2_svt_lp L=6e-08 W=1.5e-07
MI28_MXNA1 ns s VSS VSS nm1p2_svt_lp L=6e-08 W=1.2e-07
MI75_MXNA1 QN s VSS VSS nm1p2_svt_lp L=6e-08 W=2.1e-07
MI23_MXNA1 bclk nclk VSS VSS nm1p2_svt_lp L=6e-08 W=1.5e-07
MI22_MXNA1 nclk CK VSS VSS nm1p2_svt_lp L=6e-08 W=1.5e-07
MI57_MXPA1 nse SE VDD VDD pm1p2_svt_lp L=6e-08 W=2e-07
MI14_MXPOEN nmux nse XI14_p1 VDD pm1p2_svt_lp L=6e-08 W=1.5e-07
MI14_MXPA1 XI14_p1 SI VDD VDD pm1p2_svt_lp L=6e-08 W=1.5e-07
MXP1 p1 SE VDD VDD pm1p2_svt_lp L=6e-08 W=2.9e-07
MXP0 nmux B p1 VDD pm1p2_svt_lp L=6e-08 W=2.9e-07
MXP2 nmux A p1 VDD pm1p2_svt_lp L=6e-08 W=2.9e-07
MI33_MXPOEN nm bclk nmux VDD pm1p2_svt_lp L=6e-08 W=1.5e-07
MI31_MXPOEN nm nclk XI31_p1 VDD pm1p2_svt_lp L=6e-08 W=1.5e-07
MI31_MXPA1 XI31_p1 m VDD VDD pm1p2_svt_lp L=6e-08 W=1.5e-07
MI32_MXPA1 m nm VDD VDD pm1p2_svt_lp L=6e-08 W=2.8e-07
MI20_MXPOEN s nclk m VDD pm1p2_svt_lp L=6e-08 W=1.5e-07
MI69_MXPOEN s bclk XI69_p1 VDD pm1p2_svt_lp L=6e-08 W=1.5e-07
MI69_MXPA1 XI69_p1 ns VDD VDD pm1p2_svt_lp L=6e-08 W=1.5e-07
MI28_MXPA1 ns s VDD VDD pm1p2_svt_lp L=6e-08 W=1.2e-07
MI75_MXPA1 QN s VDD VDD pm1p2_svt_lp L=6e-08 W=2.95e-07
MI23_MXPA1 bclk nclk VDD VDD pm1p2_svt_lp L=6e-08 W=1.9e-07
MI22_MXPA1 nclk CK VDD VDD pm1p2_svt_lp L=6e-08 W=1.7e-07
.ENDS

.SUBCKT ASDFFQNX1H9R QN VDD VSS A B CK SE SI
MI57_MXNA1 nse SE VSS VSS nm1p2_svt_lp L=6e-08 W=1.5e-07
MI14_MXNOE nmux SE XI14_n1 VSS nm1p2_svt_lp L=6e-08 W=1.5e-07
MI14_MXNA1 XI14_n1 SI VSS VSS nm1p2_svt_lp L=6e-08 W=1.5e-07
MXN1 n2 nse VSS VSS nm1p2_svt_lp L=6e-08 W=3.1e-07
MXN2 n1 B n2 VSS nm1p2_svt_lp L=6e-08 W=3.1e-07
MXN0 nmux A n1 VSS nm1p2_svt_lp L=6e-08 W=3.1e-07
MI33_MXNOE nm nclk nmux VSS nm1p2_svt_lp L=6e-08 W=2.6e-07
MI31_MXNOE nm bclk XI31_n1 VSS nm1p2_svt_lp L=6e-08 W=1.5e-07
MI31_MXNA1 XI31_n1 m VSS VSS nm1p2_svt_lp L=6e-08 W=1.5e-07
MI32_MXNA1 m nm VSS VSS nm1p2_svt_lp L=6e-08 W=2.6e-07
MI20_MXNOE s bclk m VSS nm1p2_svt_lp L=6e-08 W=2.6e-07
MI69_MXNOE s nclk XI69_n1 VSS nm1p2_svt_lp L=6e-08 W=1.5e-07
MI69_MXNA1 XI69_n1 ns VSS VSS nm1p2_svt_lp L=6e-08 W=1.5e-07
MI28_MXNA1 ns s VSS VSS nm1p2_svt_lp L=6e-08 W=1.2e-07
MI75_MXNA1 QN s VSS VSS nm1p2_svt_lp L=6e-08 W=4.2e-07
MI23_MXNA1 bclk nclk VSS VSS nm1p2_svt_lp L=6e-08 W=1.5e-07
MI22_MXNA1 nclk CK VSS VSS nm1p2_svt_lp L=6e-08 W=1.7e-07
MI57_MXPA1 nse SE VDD VDD pm1p2_svt_lp L=6e-08 W=2e-07
MI14_MXPOEN nmux nse XI14_p1 VDD pm1p2_svt_lp L=6e-08 W=2e-07
MI14_MXPA1 XI14_p1 SI VDD VDD pm1p2_svt_lp L=6e-08 W=2e-07
MXP1 p1 SE VDD VDD pm1p2_svt_lp L=6e-08 W=2.9e-07
MXP0 nmux B p1 VDD pm1p2_svt_lp L=6e-08 W=2.9e-07
MXP2 nmux A p1 VDD pm1p2_svt_lp L=6e-08 W=2.9e-07
MI33_MXPOEN nm bclk nmux VDD pm1p2_svt_lp L=6e-08 W=2.6e-07
MI31_MXPOEN nm nclk XI31_p1 VDD pm1p2_svt_lp L=6e-08 W=1.5e-07
MI31_MXPA1 XI31_p1 m VDD VDD pm1p2_svt_lp L=6e-08 W=1.5e-07
MI32_MXPA1 m nm VDD VDD pm1p2_svt_lp L=6e-08 W=2.9e-07
MI20_MXPOEN s nclk m VDD pm1p2_svt_lp L=6e-08 W=2.6e-07
MI69_MXPOEN s bclk XI69_p1 VDD pm1p2_svt_lp L=6e-08 W=1.5e-07
MI69_MXPA1 XI69_p1 ns VDD VDD pm1p2_svt_lp L=6e-08 W=1.5e-07
MI28_MXPA1 ns s VDD VDD pm1p2_svt_lp L=6e-08 W=1.2e-07
MI75_MXPA1 QN s VDD VDD pm1p2_svt_lp L=6e-08 W=5.85e-07
MI23_MXPA1 bclk nclk VDD VDD pm1p2_svt_lp L=6e-08 W=3e-07
MI22_MXPA1 nclk CK VDD VDD pm1p2_svt_lp L=6e-08 W=1.9e-07
.ENDS

.SUBCKT ASDFFQNX2H9R QN VDD VSS A B CK SE SI
MI57_MXNA1 nse SE VSS VSS nm1p2_svt_lp L=6e-08 W=1.5e-07
MI14_MXNOE nmux SE XI14_n1 VSS nm1p2_svt_lp L=6e-08 W=1.5e-07
MI14_MXNA1 XI14_n1 SI VSS VSS nm1p2_svt_lp L=6e-08 W=1.5e-07
MXN1 n2 nse VSS VSS nm1p2_svt_lp L=6e-08 W=4.95e-07
MXN2 n1 B n2 VSS nm1p2_svt_lp L=6e-08 W=4.95e-07
MXN0 nmux A n1 VSS nm1p2_svt_lp L=6e-08 W=4.95e-07
MI33_MXNOE nm nclk nmux VSS nm1p2_svt_lp L=6e-08 W=3.2e-07
MI31_MXNOE nm bclk XI31_n1 VSS nm1p2_svt_lp L=6e-08 W=1.5e-07
MI31_MXNA1 XI31_n1 m VSS VSS nm1p2_svt_lp L=6e-08 W=1.5e-07
MI32_MXNA1 m nm VSS VSS nm1p2_svt_lp L=6e-08 W=3.5e-07
MI20_MXNOE s bclk m VSS nm1p2_svt_lp L=6e-08 W=3.2e-07
MI69_MXNOE s nclk XI69_n1 VSS nm1p2_svt_lp L=6e-08 W=1.5e-07
MI69_MXNA1 XI69_n1 ns VSS VSS nm1p2_svt_lp L=6e-08 W=1.5e-07
MI28_MXNA1 ns s VSS VSS nm1p2_svt_lp L=6e-08 W=1.2e-07
MI75_MXNA1 QN s VSS VSS nm1p2_svt_lp L=6e-08 W=4.2e-07
MI75_MXNA1_2 QN s VSS VSS nm1p2_svt_lp L=6e-08 W=4.2e-07
MI23_MXNA1 bclk nclk VSS VSS nm1p2_svt_lp L=6e-08 W=1.7e-07
MI22_MXNA1 nclk CK VSS VSS nm1p2_svt_lp L=6e-08 W=2.1e-07
MI57_MXPA1 nse SE VDD VDD pm1p2_svt_lp L=6e-08 W=2e-07
MI14_MXPOEN nmux nse XI14_p1 VDD pm1p2_svt_lp L=6e-08 W=2e-07
MI14_MXPA1 XI14_p1 SI VDD VDD pm1p2_svt_lp L=6e-08 W=2e-07
MXP1 p1 SE VDD VDD pm1p2_svt_lp L=6e-08 W=4.5e-07
MXP0 nmux B p1 VDD pm1p2_svt_lp L=6e-08 W=4.5e-07
MXP2 nmux A p1 VDD pm1p2_svt_lp L=6e-08 W=4.5e-07
MI33_MXPOEN nm bclk nmux VDD pm1p2_svt_lp L=6e-08 W=3.2e-07
MI31_MXPOEN nm nclk XI31_p1 VDD pm1p2_svt_lp L=6e-08 W=1.5e-07
MI31_MXPA1 XI31_p1 m VDD VDD pm1p2_svt_lp L=6e-08 W=1.5e-07
MI32_MXPA1 m nm VDD VDD pm1p2_svt_lp L=6e-08 W=4.5e-07
MI20_MXPOEN s nclk m VDD pm1p2_svt_lp L=6e-08 W=3.2e-07
MI69_MXPOEN s bclk XI69_p1 VDD pm1p2_svt_lp L=6e-08 W=1.5e-07
MI69_MXPA1 XI69_p1 ns VDD VDD pm1p2_svt_lp L=6e-08 W=1.5e-07
MI28_MXPA1 ns s VDD VDD pm1p2_svt_lp L=6e-08 W=1.2e-07
MI75_MXPA1 QN s VDD VDD pm1p2_svt_lp L=6e-08 W=5.85e-07
MI75_MXPA1_2 QN s VDD VDD pm1p2_svt_lp L=6e-08 W=5.85e-07
MI23_MXPA1 bclk nclk VDD VDD pm1p2_svt_lp L=6e-08 W=3.3e-07
MI22_MXPA1 nclk CK VDD VDD pm1p2_svt_lp L=6e-08 W=2.3e-07
.ENDS

.SUBCKT ASDFFQNX3H9R QN VDD VSS A B CK SE SI
MI57_MXNA1 nse SE VSS VSS nm1p2_svt_lp L=6e-08 W=1.5e-07
MI14_MXNOE nmux SE XI14_n1 VSS nm1p2_svt_lp L=6e-08 W=1.5e-07
MI14_MXNA1 XI14_n1 SI VSS VSS nm1p2_svt_lp L=6e-08 W=1.5e-07
MXN1 n2 nse VSS VSS nm1p2_svt_lp L=6e-08 W=4.95e-07
MXN2 n1 B n2 VSS nm1p2_svt_lp L=6e-08 W=4.95e-07
MXN0 nmux A n1 VSS nm1p2_svt_lp L=6e-08 W=4.95e-07
MI33_MXNOE nm nclk nmux VSS nm1p2_svt_lp L=6e-08 W=3.9e-07
MI31_MXNOE nm bclk XI31_n1 VSS nm1p2_svt_lp L=6e-08 W=1.5e-07
MI31_MXNA1 XI31_n1 m VSS VSS nm1p2_svt_lp L=6e-08 W=1.5e-07
MI32_MXNA1 m nm VSS VSS nm1p2_svt_lp L=6e-08 W=4e-07
MI20_MXNOE s bclk m VSS nm1p2_svt_lp L=6e-08 W=3.9e-07
MI69_MXNOE s nclk XI69_n1 VSS nm1p2_svt_lp L=6e-08 W=1.5e-07
MI69_MXNA1 XI69_n1 ns VSS VSS nm1p2_svt_lp L=6e-08 W=1.5e-07
MI28_MXNA1 ns s VSS VSS nm1p2_svt_lp L=6e-08 W=1.2e-07
MI75_MXNA1 QN s VSS VSS nm1p2_svt_lp L=6e-08 W=4.2e-07
MI75_MXNA1_2 QN s VSS VSS nm1p2_svt_lp L=6e-08 W=4.2e-07
MI75_MXNA1_3 QN s VSS VSS nm1p2_svt_lp L=6e-08 W=4.2e-07
MI23_MXNA1 bclk nclk VSS VSS nm1p2_svt_lp L=6e-08 W=1.8e-07
MI22_MXNA1 nclk CK VSS VSS nm1p2_svt_lp L=6e-08 W=2.2e-07
MI57_MXPA1 nse SE VDD VDD pm1p2_svt_lp L=6e-08 W=2e-07
MI14_MXPOEN nmux nse XI14_p1 VDD pm1p2_svt_lp L=6e-08 W=2e-07
MI14_MXPA1 XI14_p1 SI VDD VDD pm1p2_svt_lp L=6e-08 W=2e-07
MXP1 p1 SE VDD VDD pm1p2_svt_lp L=6e-08 W=4.7e-07
MXP0 nmux B p1 VDD pm1p2_svt_lp L=6e-08 W=4.7e-07
MXP2 nmux A p1 VDD pm1p2_svt_lp L=6e-08 W=4.7e-07
MI33_MXPOEN nm bclk nmux VDD pm1p2_svt_lp L=6e-08 W=3.9e-07
MI31_MXPOEN nm nclk XI31_p1 VDD pm1p2_svt_lp L=6e-08 W=1.5e-07
MI31_MXPA1 XI31_p1 m VDD VDD pm1p2_svt_lp L=6e-08 W=1.5e-07
MI32_MXPA1 m nm VDD VDD pm1p2_svt_lp L=6e-08 W=5.7e-07
MI20_MXPOEN s nclk m VDD pm1p2_svt_lp L=6e-08 W=3.9e-07
MI69_MXPOEN s bclk XI69_p1 VDD pm1p2_svt_lp L=6e-08 W=1.5e-07
MI69_MXPA1 XI69_p1 ns VDD VDD pm1p2_svt_lp L=6e-08 W=1.5e-07
MI28_MXPA1 ns s VDD VDD pm1p2_svt_lp L=6e-08 W=1.2e-07
MI75_MXPA1 QN s VDD VDD pm1p2_svt_lp L=6e-08 W=5.85e-07
MI75_MXPA1_2 QN s VDD VDD pm1p2_svt_lp L=6e-08 W=5.85e-07
MI75_MXPA1_3 QN s VDD VDD pm1p2_svt_lp L=6e-08 W=5.85e-07
MI23_MXPA1 bclk nclk VDD VDD pm1p2_svt_lp L=6e-08 W=3.6e-07
MI22_MXPA1 nclk CK VDD VDD pm1p2_svt_lp L=6e-08 W=2.4e-07
.ENDS

.SUBCKT ESDFFQX0P5H9R Q VDD VSS CK D E SE SI
MI70_MXNA1 ne E VSS VSS nm1p2_svt_lp L=6e-08 W=1.8e-07
MI112_MXNA1 nd D VSS VSS nm1p2_svt_lp L=6e-08 W=1.7e-07
MI110_MXNOE nenmux E nd VSS nm1p2_svt_lp L=6e-08 W=1.7e-07
MI99_MXNOE nenmux ne nfb VSS nm1p2_svt_lp L=6e-08 W=1.7e-07
MI57_MXNA1 nse SE VSS VSS nm1p2_svt_lp L=6e-08 W=1.5e-07
MI95_MXNOE nsemux nse nenmux VSS nm1p2_svt_lp L=6e-08 W=1.7e-07
MI69_MXNOE nsemux SE XI69_n1 VSS nm1p2_svt_lp L=6e-08 W=1.5e-07
MI69_MXNA1 XI69_n1 SI VSS VSS nm1p2_svt_lp L=6e-08 W=1.5e-07
MI93_MXNA1 semux nsemux VSS VSS nm1p2_svt_lp L=6e-08 W=1.5e-07
MI33_MXNOE m nclk semux VSS nm1p2_svt_lp L=6e-08 W=1.5e-07
MI31_MXNOE m bclk XI31_n1 VSS nm1p2_svt_lp L=6e-08 W=1.5e-07
MI31_MXNA1 XI31_n1 nm VSS VSS nm1p2_svt_lp L=6e-08 W=1.5e-07
MI32_MXNA1 nm m VSS VSS nm1p2_svt_lp L=6e-08 W=4.8e-07
MI20_MXNOE ns bclk nm VSS nm1p2_svt_lp L=6e-08 W=1.5e-07
MI68_MXNOE ns nclk XI68_n1 VSS nm1p2_svt_lp L=6e-08 W=1.5e-07
MI68_MXNA1 XI68_n1 s VSS VSS nm1p2_svt_lp L=6e-08 W=1.5e-07
MI103_MXNA1 nfb s VSS VSS nm1p2_svt_lp L=6e-08 W=1.7e-07
MI28_MXNA1 s ns VSS VSS nm1p2_svt_lp L=6e-08 W=1.2e-07
MI75_MXNA1 Q ns VSS VSS nm1p2_svt_lp L=6e-08 W=2.1e-07
MI23_MXNA1 bclk nclk VSS VSS nm1p2_svt_lp L=6e-08 W=1.5e-07
MI22_MXNA1 nclk CK VSS VSS nm1p2_svt_lp L=6e-08 W=1.5e-07
MI70_MXPA1 ne E VDD VDD pm1p2_svt_lp L=6e-08 W=2.5e-07
MI112_MXPA1 nd D VDD VDD pm1p2_svt_lp L=6e-08 W=4.7e-07
MI110_MXPOEN nenmux ne nd VDD pm1p2_svt_lp L=6e-08 W=2.7e-07
MI99_MXPOEN nenmux E nfb VDD pm1p2_svt_lp L=6e-08 W=2.7e-07
MI57_MXPA1 nse SE VDD VDD pm1p2_svt_lp L=6e-08 W=2e-07
MI95_MXPOEN nsemux SE nenmux VDD pm1p2_svt_lp L=6e-08 W=2.7e-07
MI69_MXPOEN nsemux nse XI69_p1 VDD pm1p2_svt_lp L=6e-08 W=1.5e-07
MI69_MXPA1 XI69_p1 SI VDD VDD pm1p2_svt_lp L=6e-08 W=1.5e-07
MI93_MXPA1 semux nsemux VDD VDD pm1p2_svt_lp L=6e-08 W=1.5e-07
MI33_MXPOEN m bclk semux VDD pm1p2_svt_lp L=6e-08 W=1.5e-07
MI31_MXPOEN m nclk XI31_p1 VDD pm1p2_svt_lp L=6e-08 W=1.5e-07
MI31_MXPA1 XI31_p1 nm VDD VDD pm1p2_svt_lp L=6e-08 W=1.5e-07
MI32_MXPA1 nm m VDD VDD pm1p2_svt_lp L=6e-08 W=2.5e-07
MI20_MXPOEN ns nclk nm VDD pm1p2_svt_lp L=6e-08 W=1.5e-07
MI68_MXPOEN ns bclk XI68_p1 VDD pm1p2_svt_lp L=6e-08 W=1.5e-07
MI68_MXPA1 XI68_p1 s VDD VDD pm1p2_svt_lp L=6e-08 W=1.5e-07
MI103_MXPA1 nfb s VDD VDD pm1p2_svt_lp L=6e-08 W=4.7e-07
MI28_MXPA1 s ns VDD VDD pm1p2_svt_lp L=6e-08 W=1.2e-07
MI75_MXPA1 Q ns VDD VDD pm1p2_svt_lp L=6e-08 W=2.95e-07
MI23_MXPA1 bclk nclk VDD VDD pm1p2_svt_lp L=6e-08 W=1.9e-07
MI22_MXPA1 nclk CK VDD VDD pm1p2_svt_lp L=6e-08 W=1.7e-07
.ENDS

.SUBCKT ESDFFQX1H9R Q VDD VSS CK D E SE SI
MI70_MXNA1 ne E VSS VSS nm1p2_svt_lp L=6e-08 W=3e-07
MI112_MXNA1 nd D VSS VSS nm1p2_svt_lp L=6e-08 W=2e-07
MI110_MXNOE nenmux E nd VSS nm1p2_svt_lp L=6e-08 W=2e-07
MI99_MXNOE nenmux ne nfb VSS nm1p2_svt_lp L=6e-08 W=2e-07
MI57_MXNA1 nse SE VSS VSS nm1p2_svt_lp L=6e-08 W=1.5e-07
MI95_MXNOE nsemux nse nenmux VSS nm1p2_svt_lp L=6e-08 W=2e-07
MI69_MXNOE nsemux SE XI69_n1 VSS nm1p2_svt_lp L=6e-08 W=1.5e-07
MI69_MXNA1 XI69_n1 SI VSS VSS nm1p2_svt_lp L=6e-08 W=1.5e-07
MI93_MXNA1 semux nsemux VSS VSS nm1p2_svt_lp L=6e-08 W=2.6e-07
MI33_MXNOE m nclk semux VSS nm1p2_svt_lp L=6e-08 W=2.6e-07
MI31_MXNOE m bclk XI31_n1 VSS nm1p2_svt_lp L=6e-08 W=1.5e-07
MI31_MXNA1 XI31_n1 nm VSS VSS nm1p2_svt_lp L=6e-08 W=1.5e-07
MI32_MXNA1 nm m VSS VSS nm1p2_svt_lp L=6e-08 W=2.8e-07
MI20_MXNOE ns bclk nm VSS nm1p2_svt_lp L=6e-08 W=2.6e-07
MI68_MXNOE ns nclk XI68_n1 VSS nm1p2_svt_lp L=6e-08 W=1.5e-07
MI68_MXNA1 XI68_n1 s VSS VSS nm1p2_svt_lp L=6e-08 W=1.5e-07
MI103_MXNA1 nfb s VSS VSS nm1p2_svt_lp L=6e-08 W=2e-07
MI28_MXNA1 s ns VSS VSS nm1p2_svt_lp L=6e-08 W=1.2e-07
MI75_MXNA1 Q ns VSS VSS nm1p2_svt_lp L=6e-08 W=4.2e-07
MI23_MXNA1 bclk nclk VSS VSS nm1p2_svt_lp L=6e-08 W=1.5e-07
MI22_MXNA1 nclk CK VSS VSS nm1p2_svt_lp L=6e-08 W=1.7e-07
MI70_MXPA1 ne E VDD VDD pm1p2_svt_lp L=6e-08 W=4.2e-07
MI112_MXPA1 nd D VDD VDD pm1p2_svt_lp L=6e-08 W=4.2e-07
MI110_MXPOEN nenmux ne nd VDD pm1p2_svt_lp L=6e-08 W=3.8e-07
MI99_MXPOEN nenmux E nfb VDD pm1p2_svt_lp L=6e-08 W=3.8e-07
MI57_MXPA1 nse SE VDD VDD pm1p2_svt_lp L=6e-08 W=2e-07
MI95_MXPOEN nsemux SE nenmux VDD pm1p2_svt_lp L=6e-08 W=3.8e-07
MI69_MXPOEN nsemux nse XI69_p1 VDD pm1p2_svt_lp L=6e-08 W=2e-07
MI69_MXPA1 XI69_p1 SI VDD VDD pm1p2_svt_lp L=6e-08 W=2e-07
MI93_MXPA1 semux nsemux VDD VDD pm1p2_svt_lp L=6e-08 W=2.6e-07
MI33_MXPOEN m bclk semux VDD pm1p2_svt_lp L=6e-08 W=2.6e-07
MI31_MXPOEN m nclk XI31_p1 VDD pm1p2_svt_lp L=6e-08 W=1.5e-07
MI31_MXPA1 XI31_p1 nm VDD VDD pm1p2_svt_lp L=6e-08 W=1.5e-07
MI32_MXPA1 nm m VDD VDD pm1p2_svt_lp L=6e-08 W=2.8e-07
MI20_MXPOEN ns nclk nm VDD pm1p2_svt_lp L=6e-08 W=2.6e-07
MI68_MXPOEN ns bclk XI68_p1 VDD pm1p2_svt_lp L=6e-08 W=1.5e-07
MI68_MXPA1 XI68_p1 s VDD VDD pm1p2_svt_lp L=6e-08 W=1.5e-07
MI103_MXPA1 nfb s VDD VDD pm1p2_svt_lp L=6e-08 W=4.2e-07
MI28_MXPA1 s ns VDD VDD pm1p2_svt_lp L=6e-08 W=1.2e-07
MI75_MXPA1 Q ns VDD VDD pm1p2_svt_lp L=6e-08 W=5.85e-07
MI23_MXPA1 bclk nclk VDD VDD pm1p2_svt_lp L=6e-08 W=3e-07
MI22_MXPA1 nclk CK VDD VDD pm1p2_svt_lp L=6e-08 W=1.9e-07
.ENDS

.SUBCKT ESDFFQX2H9R Q VDD VSS CK D E SE SI
MI70_MXNA1 ne E VSS VSS nm1p2_svt_lp L=6e-08 W=3.25e-07
MI112_MXNA1 nd D VSS VSS nm1p2_svt_lp L=6e-08 W=2.6e-07
MI110_MXNOE nenmux E nd VSS nm1p2_svt_lp L=6e-08 W=2.6e-07
MI99_MXNOE nenmux ne nfb VSS nm1p2_svt_lp L=6e-08 W=2.6e-07
MI57_MXNA1 nse SE VSS VSS nm1p2_svt_lp L=6e-08 W=1.5e-07
MI95_MXNOE nsemux nse nenmux VSS nm1p2_svt_lp L=6e-08 W=2.6e-07
MI69_MXNOE nsemux SE XI69_n1 VSS nm1p2_svt_lp L=6e-08 W=1.5e-07
MI69_MXNA1 XI69_n1 SI VSS VSS nm1p2_svt_lp L=6e-08 W=1.5e-07
MI93_MXNA1 semux nsemux VSS VSS nm1p2_svt_lp L=6e-08 W=3.2e-07
MI33_MXNOE m nclk semux VSS nm1p2_svt_lp L=6e-08 W=3.2e-07
MI31_MXNOE m bclk XI31_n1 VSS nm1p2_svt_lp L=6e-08 W=1.5e-07
MI31_MXNA1 XI31_n1 nm VSS VSS nm1p2_svt_lp L=6e-08 W=1.5e-07
MI32_MXNA1 nm m VSS VSS nm1p2_svt_lp L=6e-08 W=3.1e-07
MI20_MXNOE ns bclk nm VSS nm1p2_svt_lp L=6e-08 W=3.2e-07
MI68_MXNOE ns nclk XI68_n1 VSS nm1p2_svt_lp L=6e-08 W=1.5e-07
MI68_MXNA1 XI68_n1 s VSS VSS nm1p2_svt_lp L=6e-08 W=1.5e-07
MI103_MXNA1 nfb s VSS VSS nm1p2_svt_lp L=6e-08 W=2.6e-07
MI28_MXNA1 s ns VSS VSS nm1p2_svt_lp L=6e-08 W=1.2e-07
MI75_MXNA1 Q ns VSS VSS nm1p2_svt_lp L=6e-08 W=4.2e-07
MI75_MXNA1_2 Q ns VSS VSS nm1p2_svt_lp L=6e-08 W=4.2e-07
MI23_MXNA1 bclk nclk VSS VSS nm1p2_svt_lp L=6e-08 W=1.7e-07
MI22_MXNA1 nclk CK VSS VSS nm1p2_svt_lp L=6e-08 W=2.1e-07
MI70_MXPA1 ne E VDD VDD pm1p2_svt_lp L=6e-08 W=4.45e-07
MI112_MXPA1 nd D VDD VDD pm1p2_svt_lp L=6e-08 W=5.2e-07
MI110_MXPOEN nenmux ne nd VDD pm1p2_svt_lp L=6e-08 W=4.4e-07
MI99_MXPOEN nenmux E nfb VDD pm1p2_svt_lp L=6e-08 W=4.4e-07
MI57_MXPA1 nse SE VDD VDD pm1p2_svt_lp L=6e-08 W=2e-07
MI95_MXPOEN nsemux SE nenmux VDD pm1p2_svt_lp L=6e-08 W=4.4e-07
MI69_MXPOEN nsemux nse XI69_p1 VDD pm1p2_svt_lp L=6e-08 W=2e-07
MI69_MXPA1 XI69_p1 SI VDD VDD pm1p2_svt_lp L=6e-08 W=2e-07
MI93_MXPA1 semux nsemux VDD VDD pm1p2_svt_lp L=6e-08 W=3.2e-07
MI33_MXPOEN m bclk semux VDD pm1p2_svt_lp L=6e-08 W=3.2e-07
MI31_MXPOEN m nclk XI31_p1 VDD pm1p2_svt_lp L=6e-08 W=1.5e-07
MI31_MXPA1 XI31_p1 nm VDD VDD pm1p2_svt_lp L=6e-08 W=1.5e-07
MI32_MXPA1 nm m VDD VDD pm1p2_svt_lp L=6e-08 W=4.55e-07
MI20_MXPOEN ns nclk nm VDD pm1p2_svt_lp L=6e-08 W=3.2e-07
MI68_MXPOEN ns bclk XI68_p1 VDD pm1p2_svt_lp L=6e-08 W=1.5e-07
MI68_MXPA1 XI68_p1 s VDD VDD pm1p2_svt_lp L=6e-08 W=1.5e-07
MI103_MXPA1 nfb s VDD VDD pm1p2_svt_lp L=6e-08 W=5.2e-07
MI28_MXPA1 s ns VDD VDD pm1p2_svt_lp L=6e-08 W=1.2e-07
MI75_MXPA1 Q ns VDD VDD pm1p2_svt_lp L=6e-08 W=5.85e-07
MI75_MXPA1_2 Q ns VDD VDD pm1p2_svt_lp L=6e-08 W=5.85e-07
MI23_MXPA1 bclk nclk VDD VDD pm1p2_svt_lp L=6e-08 W=3.3e-07
MI22_MXPA1 nclk CK VDD VDD pm1p2_svt_lp L=6e-08 W=2.3e-07
.ENDS

.SUBCKT ESDFFQX3H9R Q VDD VSS CK D E SE SI
MI70_MXNA1 ne E VSS VSS nm1p2_svt_lp L=6e-08 W=3.7e-07
MI112_MXNA1 nd D VSS VSS nm1p2_svt_lp L=6e-08 W=2.6e-07
MI110_MXNOE nenmux E nd VSS nm1p2_svt_lp L=6e-08 W=2.6e-07
MI99_MXNOE nenmux ne nfb VSS nm1p2_svt_lp L=6e-08 W=2.6e-07
MI57_MXNA1 nse SE VSS VSS nm1p2_svt_lp L=6e-08 W=1.5e-07
MI95_MXNOE nsemux nse nenmux VSS nm1p2_svt_lp L=6e-08 W=2.6e-07
MI69_MXNOE nsemux SE XI69_n1 VSS nm1p2_svt_lp L=6e-08 W=1.5e-07
MI69_MXNA1 XI69_n1 SI VSS VSS nm1p2_svt_lp L=6e-08 W=1.5e-07
MI93_MXNA1 semux nsemux VSS VSS nm1p2_svt_lp L=6e-08 W=3.9e-07
MI33_MXNOE m nclk semux VSS nm1p2_svt_lp L=6e-08 W=3.9e-07
MI31_MXNOE m bclk XI31_n1 VSS nm1p2_svt_lp L=6e-08 W=1.5e-07
MI31_MXNA1 XI31_n1 nm VSS VSS nm1p2_svt_lp L=6e-08 W=1.5e-07
MI32_MXNA1 nm m VSS VSS nm1p2_svt_lp L=6e-08 W=3.9e-07
MI20_MXNOE ns bclk nm VSS nm1p2_svt_lp L=6e-08 W=3.9e-07
MI68_MXNOE ns nclk XI68_n1 VSS nm1p2_svt_lp L=6e-08 W=1.5e-07
MI68_MXNA1 XI68_n1 s VSS VSS nm1p2_svt_lp L=6e-08 W=1.5e-07
MI103_MXNA1 nfb s VSS VSS nm1p2_svt_lp L=6e-08 W=2.6e-07
MI28_MXNA1 s ns VSS VSS nm1p2_svt_lp L=6e-08 W=1.2e-07
MI75_MXNA1 Q ns VSS VSS nm1p2_svt_lp L=6e-08 W=4.2e-07
MI75_MXNA1_2 Q ns VSS VSS nm1p2_svt_lp L=6e-08 W=4.2e-07
MI75_MXNA1_3 Q ns VSS VSS nm1p2_svt_lp L=6e-08 W=4.2e-07
MI23_MXNA1 bclk nclk VSS VSS nm1p2_svt_lp L=6e-08 W=1.8e-07
MI22_MXNA1 nclk CK VSS VSS nm1p2_svt_lp L=6e-08 W=2.2e-07
MI70_MXPA1 ne E VDD VDD pm1p2_svt_lp L=6e-08 W=5.2e-07
MI112_MXPA1 nd D VDD VDD pm1p2_svt_lp L=6e-08 W=5.55e-07
MI110_MXPOEN nenmux ne nd VDD pm1p2_svt_lp L=6e-08 W=4.5e-07
MI99_MXPOEN nenmux E nfb VDD pm1p2_svt_lp L=6e-08 W=4.5e-07
MI57_MXPA1 nse SE VDD VDD pm1p2_svt_lp L=6e-08 W=2e-07
MI95_MXPOEN nsemux SE nenmux VDD pm1p2_svt_lp L=6e-08 W=4.5e-07
MI69_MXPOEN nsemux nse XI69_p1 VDD pm1p2_svt_lp L=6e-08 W=2e-07
MI69_MXPA1 XI69_p1 SI VDD VDD pm1p2_svt_lp L=6e-08 W=2e-07
MI93_MXPA1 semux nsemux VDD VDD pm1p2_svt_lp L=6e-08 W=3.9e-07
MI33_MXPOEN m bclk semux VDD pm1p2_svt_lp L=6e-08 W=3.9e-07
MI31_MXPOEN m nclk XI31_p1 VDD pm1p2_svt_lp L=6e-08 W=1.5e-07
MI31_MXPA1 XI31_p1 nm VDD VDD pm1p2_svt_lp L=6e-08 W=1.5e-07
MI32_MXPA1 nm m VDD VDD pm1p2_svt_lp L=6e-08 W=5.75e-07
MI20_MXPOEN ns nclk nm VDD pm1p2_svt_lp L=6e-08 W=3.9e-07
MI68_MXPOEN ns bclk XI68_p1 VDD pm1p2_svt_lp L=6e-08 W=1.5e-07
MI68_MXPA1 XI68_p1 s VDD VDD pm1p2_svt_lp L=6e-08 W=1.5e-07
MI103_MXPA1 nfb s VDD VDD pm1p2_svt_lp L=6e-08 W=5.55e-07
MI28_MXPA1 s ns VDD VDD pm1p2_svt_lp L=6e-08 W=1.2e-07
MI75_MXPA1 Q ns VDD VDD pm1p2_svt_lp L=6e-08 W=5.85e-07
MI75_MXPA1_2 Q ns VDD VDD pm1p2_svt_lp L=6e-08 W=5.85e-07
MI75_MXPA1_3 Q ns VDD VDD pm1p2_svt_lp L=6e-08 W=5.85e-07
MI23_MXPA1 bclk nclk VDD VDD pm1p2_svt_lp L=6e-08 W=3.6e-07
MI22_MXPA1 nclk CK VDD VDD pm1p2_svt_lp L=6e-08 W=2.4e-07
.ENDS

.SUBCKT ESDFFQNX0P5H9R QN VDD VSS CK D E SE SI
MI70_MXNA1 ne E VSS VSS nm1p2_svt_lp L=6e-08 W=2.5e-07
MI112_MXNA1 nd D VSS VSS nm1p2_svt_lp L=6e-08 W=2e-07
MI110_MXNOE nenmux E nd VSS nm1p2_svt_lp L=6e-08 W=2e-07
MI99_MXNOE nenmux ne nfb VSS nm1p2_svt_lp L=6e-08 W=2e-07
MI57_MXNA1 nse SE VSS VSS nm1p2_svt_lp L=6e-08 W=1.5e-07
MI95_MXNOE nsemux nse nenmux VSS nm1p2_svt_lp L=6e-08 W=2e-07
MI69_MXNOE nsemux SE XI69_n1 VSS nm1p2_svt_lp L=6e-08 W=1.5e-07
MI69_MXNA1 XI69_n1 SI VSS VSS nm1p2_svt_lp L=6e-08 W=1.5e-07
MI93_MXNA1 semux nsemux VSS VSS nm1p2_svt_lp L=6e-08 W=2.6e-07
MI33_MXNOE m nclk semux VSS nm1p2_svt_lp L=6e-08 W=1.5e-07
MI31_MXNOE m bclk XI31_n1 VSS nm1p2_svt_lp L=6e-08 W=1.5e-07
MI31_MXNA1 XI31_n1 nm VSS VSS nm1p2_svt_lp L=6e-08 W=1.5e-07
MI32_MXNA1 nm m VSS VSS nm1p2_svt_lp L=6e-08 W=1.5e-07
MI20_MXNOE ns bclk nm VSS nm1p2_svt_lp L=6e-08 W=1.5e-07
MI29_MXNOE ns nclk XI29_n1 VSS nm1p2_svt_lp L=6e-08 W=1.5e-07
MI29_MXNA1 XI29_n1 s VSS VSS nm1p2_svt_lp L=6e-08 W=1.5e-07
MI28_MXNA1 s ns VSS VSS nm1p2_svt_lp L=6e-08 W=3e-07
MI103_MXNA1 nfb s VSS VSS nm1p2_svt_lp L=6e-08 W=2e-07
MI75_MXNA1 QN s VSS VSS nm1p2_svt_lp L=6e-08 W=2.1e-07
MI23_MXNA1 bclk nclk VSS VSS nm1p2_svt_lp L=6e-08 W=1.5e-07
MI22_MXNA1 nclk CK VSS VSS nm1p2_svt_lp L=6e-08 W=1.5e-07
MI70_MXPA1 ne E VDD VDD pm1p2_svt_lp L=6e-08 W=3.5e-07
MI112_MXPA1 nd D VDD VDD pm1p2_svt_lp L=6e-08 W=5e-07
MI110_MXPOEN nenmux ne nd VDD pm1p2_svt_lp L=6e-08 W=2.8e-07
MI99_MXPOEN nenmux E nfb VDD pm1p2_svt_lp L=6e-08 W=2.8e-07
MI57_MXPA1 nse SE VDD VDD pm1p2_svt_lp L=6e-08 W=2e-07
MI95_MXPOEN nsemux SE nenmux VDD pm1p2_svt_lp L=6e-08 W=2.8e-07
MI69_MXPOEN nsemux nse XI69_p1 VDD pm1p2_svt_lp L=6e-08 W=1.5e-07
MI69_MXPA1 XI69_p1 SI VDD VDD pm1p2_svt_lp L=6e-08 W=1.5e-07
MI93_MXPA1 semux nsemux VDD VDD pm1p2_svt_lp L=6e-08 W=2.6e-07
MI33_MXPOEN m bclk semux VDD pm1p2_svt_lp L=6e-08 W=1.5e-07
MI31_MXPOEN m nclk XI31_p1 VDD pm1p2_svt_lp L=6e-08 W=1.5e-07
MI31_MXPA1 XI31_p1 nm VDD VDD pm1p2_svt_lp L=6e-08 W=1.5e-07
MI32_MXPA1 nm m VDD VDD pm1p2_svt_lp L=6e-08 W=1.9e-07
MI20_MXPOEN ns nclk nm VDD pm1p2_svt_lp L=6e-08 W=1.5e-07
MI29_MXPOEN ns bclk XI29_p1 VDD pm1p2_svt_lp L=6e-08 W=1.5e-07
MI29_MXPA1 XI29_p1 s VDD VDD pm1p2_svt_lp L=6e-08 W=1.5e-07
MI28_MXPA1 s ns VDD VDD pm1p2_svt_lp L=6e-08 W=4.5e-07
MI103_MXPA1 nfb s VDD VDD pm1p2_svt_lp L=6e-08 W=5e-07
MI75_MXPA1 QN s VDD VDD pm1p2_svt_lp L=6e-08 W=2.95e-07
MI23_MXPA1 bclk nclk VDD VDD pm1p2_svt_lp L=6e-08 W=1.9e-07
MI22_MXPA1 nclk CK VDD VDD pm1p2_svt_lp L=6e-08 W=1.7e-07
.ENDS

.SUBCKT ESDFFQNX1H9R QN VDD VSS CK D E SE SI
MI70_MXNA1 ne E VSS VSS nm1p2_svt_lp L=6e-08 W=2.95e-07
MI112_MXNA1 nd D VSS VSS nm1p2_svt_lp L=6e-08 W=2e-07
MI110_MXNOE nenmux E nd VSS nm1p2_svt_lp L=6e-08 W=2e-07
MI99_MXNOE nenmux ne nfb VSS nm1p2_svt_lp L=6e-08 W=2e-07
MI57_MXNA1 nse SE VSS VSS nm1p2_svt_lp L=6e-08 W=1.5e-07
MI95_MXNOE nsemux nse nenmux VSS nm1p2_svt_lp L=6e-08 W=2e-07
MI69_MXNOE nsemux SE XI69_n1 VSS nm1p2_svt_lp L=6e-08 W=1.5e-07
MI69_MXNA1 XI69_n1 SI VSS VSS nm1p2_svt_lp L=6e-08 W=1.5e-07
MI93_MXNA1 semux nsemux VSS VSS nm1p2_svt_lp L=6e-08 W=2.6e-07
MI33_MXNOE m nclk semux VSS nm1p2_svt_lp L=6e-08 W=2.6e-07
MI31_MXNOE m bclk XI31_n1 VSS nm1p2_svt_lp L=6e-08 W=1.5e-07
MI31_MXNA1 XI31_n1 nm VSS VSS nm1p2_svt_lp L=6e-08 W=1.5e-07
MI32_MXNA1 nm m VSS VSS nm1p2_svt_lp L=6e-08 W=2.2e-07
MI20_MXNOE ns bclk nm VSS nm1p2_svt_lp L=6e-08 W=2.6e-07
MI29_MXNOE ns nclk XI29_n1 VSS nm1p2_svt_lp L=6e-08 W=1.5e-07
MI29_MXNA1 XI29_n1 s VSS VSS nm1p2_svt_lp L=6e-08 W=1.5e-07
MI28_MXNA1 s ns VSS VSS nm1p2_svt_lp L=6e-08 W=2.1e-07
MI103_MXNA1 nfb s VSS VSS nm1p2_svt_lp L=6e-08 W=2e-07
MI75_MXNA1 QN s VSS VSS nm1p2_svt_lp L=6e-08 W=4.2e-07
MI23_MXNA1 bclk nclk VSS VSS nm1p2_svt_lp L=6e-08 W=1.5e-07
MI22_MXNA1 nclk CK VSS VSS nm1p2_svt_lp L=6e-08 W=1.7e-07
MI70_MXPA1 ne E VDD VDD pm1p2_svt_lp L=6e-08 W=4.15e-07
MI112_MXPA1 nd D VDD VDD pm1p2_svt_lp L=6e-08 W=4.2e-07
MI110_MXPOEN nenmux ne nd VDD pm1p2_svt_lp L=6e-08 W=3.2e-07
MI99_MXPOEN nenmux E nfb VDD pm1p2_svt_lp L=6e-08 W=3.2e-07
MI57_MXPA1 nse SE VDD VDD pm1p2_svt_lp L=6e-08 W=2e-07
MI95_MXPOEN nsemux SE nenmux VDD pm1p2_svt_lp L=6e-08 W=3.2e-07
MI69_MXPOEN nsemux nse XI69_p1 VDD pm1p2_svt_lp L=6e-08 W=2e-07
MI69_MXPA1 XI69_p1 SI VDD VDD pm1p2_svt_lp L=6e-08 W=2e-07
MI93_MXPA1 semux nsemux VDD VDD pm1p2_svt_lp L=6e-08 W=2.6e-07
MI33_MXPOEN m bclk semux VDD pm1p2_svt_lp L=6e-08 W=2.6e-07
MI31_MXPOEN m nclk XI31_p1 VDD pm1p2_svt_lp L=6e-08 W=1.5e-07
MI31_MXPA1 XI31_p1 nm VDD VDD pm1p2_svt_lp L=6e-08 W=1.5e-07
MI32_MXPA1 nm m VDD VDD pm1p2_svt_lp L=6e-08 W=3.1e-07
MI20_MXPOEN ns nclk nm VDD pm1p2_svt_lp L=6e-08 W=2.6e-07
MI29_MXPOEN ns bclk XI29_p1 VDD pm1p2_svt_lp L=6e-08 W=1.5e-07
MI29_MXPA1 XI29_p1 s VDD VDD pm1p2_svt_lp L=6e-08 W=1.5e-07
MI28_MXPA1 s ns VDD VDD pm1p2_svt_lp L=6e-08 W=3.7e-07
MI103_MXPA1 nfb s VDD VDD pm1p2_svt_lp L=6e-08 W=4.2e-07
MI75_MXPA1 QN s VDD VDD pm1p2_svt_lp L=6e-08 W=5.85e-07
MI23_MXPA1 bclk nclk VDD VDD pm1p2_svt_lp L=6e-08 W=3e-07
MI22_MXPA1 nclk CK VDD VDD pm1p2_svt_lp L=6e-08 W=1.9e-07
.ENDS

.SUBCKT ESDFFQNX2H9R QN VDD VSS CK D E SE SI
MI70_MXNA1 ne E VSS VSS nm1p2_svt_lp L=6e-08 W=3.2e-07
MI112_MXNA1 nd D VSS VSS nm1p2_svt_lp L=6e-08 W=2.6e-07
MI110_MXNOE nenmux E nd VSS nm1p2_svt_lp L=6e-08 W=2.6e-07
MI99_MXNOE nenmux ne nfb VSS nm1p2_svt_lp L=6e-08 W=2.6e-07
MI57_MXNA1 nse SE VSS VSS nm1p2_svt_lp L=6e-08 W=1.5e-07
MI95_MXNOE nsemux nse nenmux VSS nm1p2_svt_lp L=6e-08 W=2.6e-07
MI69_MXNOE nsemux SE XI69_n1 VSS nm1p2_svt_lp L=6e-08 W=1.5e-07
MI69_MXNA1 XI69_n1 SI VSS VSS nm1p2_svt_lp L=6e-08 W=1.5e-07
MI93_MXNA1 semux nsemux VSS VSS nm1p2_svt_lp L=6e-08 W=3.2e-07
MI33_MXNOE m nclk semux VSS nm1p2_svt_lp L=6e-08 W=3.2e-07
MI31_MXNOE m bclk XI31_n1 VSS nm1p2_svt_lp L=6e-08 W=1.5e-07
MI31_MXNA1 XI31_n1 nm VSS VSS nm1p2_svt_lp L=6e-08 W=1.5e-07
MI32_MXNA1 nm m VSS VSS nm1p2_svt_lp L=6e-08 W=2.9e-07
MI20_MXNOE ns bclk nm VSS nm1p2_svt_lp L=6e-08 W=3.2e-07
MI29_MXNOE ns nclk XI29_n1 VSS nm1p2_svt_lp L=6e-08 W=1.5e-07
MI29_MXNA1 XI29_n1 s VSS VSS nm1p2_svt_lp L=6e-08 W=1.5e-07
MI28_MXNA1 s ns VSS VSS nm1p2_svt_lp L=6e-08 W=3e-07
MI103_MXNA1 nfb s VSS VSS nm1p2_svt_lp L=6e-08 W=2.6e-07
MI75_MXNA1 QN s VSS VSS nm1p2_svt_lp L=6e-08 W=4.2e-07
MI75_MXNA1_2 QN s VSS VSS nm1p2_svt_lp L=6e-08 W=4.2e-07
MI23_MXNA1 bclk nclk VSS VSS nm1p2_svt_lp L=6e-08 W=1.7e-07
MI22_MXNA1 nclk CK VSS VSS nm1p2_svt_lp L=6e-08 W=2.1e-07
MI70_MXPA1 ne E VDD VDD pm1p2_svt_lp L=6e-08 W=4.5e-07
MI112_MXPA1 nd D VDD VDD pm1p2_svt_lp L=6e-08 W=5.8e-07
MI110_MXPOEN nenmux ne nd VDD pm1p2_svt_lp L=6e-08 W=4e-07
MI99_MXPOEN nenmux E nfb VDD pm1p2_svt_lp L=6e-08 W=4e-07
MI57_MXPA1 nse SE VDD VDD pm1p2_svt_lp L=6e-08 W=2e-07
MI95_MXPOEN nsemux SE nenmux VDD pm1p2_svt_lp L=6e-08 W=4e-07
MI69_MXPOEN nsemux nse XI69_p1 VDD pm1p2_svt_lp L=6e-08 W=2e-07
MI69_MXPA1 XI69_p1 SI VDD VDD pm1p2_svt_lp L=6e-08 W=2e-07
MI93_MXPA1 semux nsemux VDD VDD pm1p2_svt_lp L=6e-08 W=3.2e-07
MI33_MXPOEN m bclk semux VDD pm1p2_svt_lp L=6e-08 W=3.2e-07
MI31_MXPOEN m nclk XI31_p1 VDD pm1p2_svt_lp L=6e-08 W=1.5e-07
MI31_MXPA1 XI31_p1 nm VDD VDD pm1p2_svt_lp L=6e-08 W=1.5e-07
MI32_MXPA1 nm m VDD VDD pm1p2_svt_lp L=6e-08 W=3.9e-07
MI20_MXPOEN ns nclk nm VDD pm1p2_svt_lp L=6e-08 W=3.2e-07
MI29_MXPOEN ns bclk XI29_p1 VDD pm1p2_svt_lp L=6e-08 W=1.5e-07
MI29_MXPA1 XI29_p1 s VDD VDD pm1p2_svt_lp L=6e-08 W=1.5e-07
MI28_MXPA1 s ns VDD VDD pm1p2_svt_lp L=6e-08 W=5.2e-07
MI103_MXPA1 nfb s VDD VDD pm1p2_svt_lp L=6e-08 W=5.8e-07
MI75_MXPA1 QN s VDD VDD pm1p2_svt_lp L=6e-08 W=5.85e-07
MI75_MXPA1_2 QN s VDD VDD pm1p2_svt_lp L=6e-08 W=5.85e-07
MI23_MXPA1 bclk nclk VDD VDD pm1p2_svt_lp L=6e-08 W=3.3e-07
MI22_MXPA1 nclk CK VDD VDD pm1p2_svt_lp L=6e-08 W=2.3e-07
.ENDS

.SUBCKT ESDFFQNX3H9R QN VDD VSS CK D E SE SI
MI70_MXNA1 ne E VSS VSS nm1p2_svt_lp L=6e-08 W=4.05e-07
MI112_MXNA1 nd D VSS VSS nm1p2_svt_lp L=6e-08 W=2.6e-07
MI110_MXNOE nenmux E nd VSS nm1p2_svt_lp L=6e-08 W=2.6e-07
MI99_MXNOE nenmux ne nfb VSS nm1p2_svt_lp L=6e-08 W=2.6e-07
MI57_MXNA1 nse SE VSS VSS nm1p2_svt_lp L=6e-08 W=1.5e-07
MI95_MXNOE nsemux nse nenmux VSS nm1p2_svt_lp L=6e-08 W=2.6e-07
MI69_MXNOE nsemux SE XI69_n1 VSS nm1p2_svt_lp L=6e-08 W=1.5e-07
MI69_MXNA1 XI69_n1 SI VSS VSS nm1p2_svt_lp L=6e-08 W=1.5e-07
MI93_MXNA1 semux nsemux VSS VSS nm1p2_svt_lp L=6e-08 W=3.9e-07
MI33_MXNOE m nclk semux VSS nm1p2_svt_lp L=6e-08 W=3.9e-07
MI31_MXNOE m bclk XI31_n1 VSS nm1p2_svt_lp L=6e-08 W=1.5e-07
MI31_MXNA1 XI31_n1 nm VSS VSS nm1p2_svt_lp L=6e-08 W=1.5e-07
MI32_MXNA1 nm m VSS VSS nm1p2_svt_lp L=6e-08 W=3.9e-07
MI20_MXNOE ns bclk nm VSS nm1p2_svt_lp L=6e-08 W=3.9e-07
MI29_MXNOE ns nclk XI29_n1 VSS nm1p2_svt_lp L=6e-08 W=1.5e-07
MI29_MXNA1 XI29_n1 s VSS VSS nm1p2_svt_lp L=6e-08 W=1.5e-07
MI28_MXNA1 s ns VSS VSS nm1p2_svt_lp L=6e-08 W=1.7e-07
MI103_MXNA1 nfb s VSS VSS nm1p2_svt_lp L=6e-08 W=2.6e-07
MI75_MXNA1 QN s VSS VSS nm1p2_svt_lp L=6e-08 W=4.2e-07
MI75_MXNA1_2 QN s VSS VSS nm1p2_svt_lp L=6e-08 W=4.2e-07
MI75_MXNA1_3 QN s VSS VSS nm1p2_svt_lp L=6e-08 W=4.2e-07
MI23_MXNA1 bclk nclk VSS VSS nm1p2_svt_lp L=6e-08 W=1.8e-07
MI22_MXNA1 nclk CK VSS VSS nm1p2_svt_lp L=6e-08 W=2.2e-07
MI70_MXPA1 ne E VDD VDD pm1p2_svt_lp L=6e-08 W=5.65e-07
MI112_MXPA1 nd D VDD VDD pm1p2_svt_lp L=6e-08 W=5.6e-07
MI110_MXPOEN nenmux ne nd VDD pm1p2_svt_lp L=6e-08 W=4.5e-07
MI99_MXPOEN nenmux E nfb VDD pm1p2_svt_lp L=6e-08 W=4.5e-07
MI57_MXPA1 nse SE VDD VDD pm1p2_svt_lp L=6e-08 W=2e-07
MI95_MXPOEN nsemux SE nenmux VDD pm1p2_svt_lp L=6e-08 W=4.5e-07
MI69_MXPOEN nsemux nse XI69_p1 VDD pm1p2_svt_lp L=6e-08 W=2e-07
MI69_MXPA1 XI69_p1 SI VDD VDD pm1p2_svt_lp L=6e-08 W=2e-07
MI93_MXPA1 semux nsemux VDD VDD pm1p2_svt_lp L=6e-08 W=3.9e-07
MI33_MXPOEN m bclk semux VDD pm1p2_svt_lp L=6e-08 W=3.9e-07
MI31_MXPOEN m nclk XI31_p1 VDD pm1p2_svt_lp L=6e-08 W=1.5e-07
MI31_MXPA1 XI31_p1 nm VDD VDD pm1p2_svt_lp L=6e-08 W=1.5e-07
MI32_MXPA1 nm m VDD VDD pm1p2_svt_lp L=6e-08 W=5.05e-07
MI20_MXPOEN ns nclk nm VDD pm1p2_svt_lp L=6e-08 W=3.9e-07
MI29_MXPOEN ns bclk XI29_p1 VDD pm1p2_svt_lp L=6e-08 W=1.5e-07
MI29_MXPA1 XI29_p1 s VDD VDD pm1p2_svt_lp L=6e-08 W=1.5e-07
MI28_MXPA1 s ns VDD VDD pm1p2_svt_lp L=6e-08 W=3.2e-07
MI103_MXPA1 nfb s VDD VDD pm1p2_svt_lp L=6e-08 W=5.6e-07
MI75_MXPA1 QN s VDD VDD pm1p2_svt_lp L=6e-08 W=5.85e-07
MI75_MXPA1_2 QN s VDD VDD pm1p2_svt_lp L=6e-08 W=5.85e-07
MI75_MXPA1_3 QN s VDD VDD pm1p2_svt_lp L=6e-08 W=5.85e-07
MI23_MXPA1 bclk nclk VDD VDD pm1p2_svt_lp L=6e-08 W=3.6e-07
MI22_MXPA1 nclk CK VDD VDD pm1p2_svt_lp L=6e-08 W=2.4e-07
.ENDS

.SUBCKT FILLTAP2H9R VDD VSS
*.CONNECT VSS VSS
*.CONNECT VDD VDD
.ENDS

.SUBCKT FILLTAP4H9R VDD VSS
*.CONNECT VSS VSS
*.CONNECT VDD VDD
.ENDS

.SUBCKT FILLTAP8H9R VDD VSS
*.CONNECT VSS VSS
*.CONNECT VDD VDD
.ENDS

.SUBCKT FILLTAP16H9R VDD VSS
*.CONNECT VSS VSS
*.CONNECT VDD VDD
.ENDS

.SUBCKT FILLTAP32H9R VDD VSS
*.CONNECT VSS VSS
*.CONNECT VDD VDD
.ENDS

.SUBCKT FILLTAP64H9R VDD VSS
*.CONNECT VSS VSS
*.CONNECT VDD VDD
.ENDS

.SUBCKT FILLTAP128H9R VDD VSS
*.CONNECT VSS VSS
*.CONNECT VDD VDD
.ENDS

.SUBCKT FILLCAP6H9R VDD VSS
M0_noxref VSS VDD VSS VSS nm1p2_svt_lp L=1e-07 W=1.205e-06
.ENDS

.SUBCKT FILLCAP8H9R VDD VSS
M0_noxref VSS VDD VSS VSS nm1p2_svt_lp L=1e-07 W=1.205e-06
M1_noxref VSS VDD VSS VSS nm1p2_svt_lp L=1e-07 W=1.205e-06
.ENDS

.SUBCKT FILLCAP17H9R VDD VSS
M0_noxref VSS VDD VSS VSS nm1p2_svt_lp L=1e-07 W=1.205e-06
M1_noxref VSS VDD VSS VSS nm1p2_svt_lp L=1e-07 W=1.205e-06
M2_noxref VSS VDD VSS VSS nm1p2_svt_lp L=1e-07 W=1.205e-06
M3_noxref VSS VDD VSS VSS nm1p2_svt_lp L=1e-07 W=1.205e-06
M4_noxref VSS VDD VSS VSS nm1p2_svt_lp L=1e-07 W=1.205e-06
M5_noxref VSS VDD VSS VSS nm1p2_svt_lp L=1e-07 W=1.205e-06
M6_noxref VSS VDD VSS VSS nm1p2_svt_lp L=1e-07 W=1.205e-06
M7_noxref VSS VDD VSS VSS nm1p2_svt_lp L=1e-07 W=1.205e-06
.ENDS

.SUBCKT FILLCAP32H9R VDD VSS
M0_noxref VSS VDD VSS VSS nm1p2_svt_lp L=1e-07 W=1.205e-06
M1_noxref VSS VDD VSS VSS nm1p2_svt_lp L=1e-07 W=1.205e-06
M2_noxref VSS VDD VSS VSS nm1p2_svt_lp L=1e-07 W=1.205e-06
M3_noxref VSS VDD VSS VSS nm1p2_svt_lp L=1e-07 W=1.205e-06
M4_noxref VSS VDD VSS VSS nm1p2_svt_lp L=1e-07 W=1.205e-06
M5_noxref VSS VDD VSS VSS nm1p2_svt_lp L=1e-07 W=1.205e-06
M6_noxref VSS VDD VSS VSS nm1p2_svt_lp L=1e-07 W=1.205e-06
M7_noxref VSS VDD VSS VSS nm1p2_svt_lp L=1e-07 W=1.205e-06
M8_noxref VSS VDD VSS VSS nm1p2_svt_lp L=1e-07 W=1.205e-06
M9_noxref VSS VDD VSS VSS nm1p2_svt_lp L=1e-07 W=1.205e-06
M10_noxref VSS VDD VSS VSS nm1p2_svt_lp L=1e-07 W=1.205e-06
M11_noxref VSS VDD VSS VSS nm1p2_svt_lp L=1e-07 W=1.205e-06
M12_noxref VSS VDD VSS VSS nm1p2_svt_lp L=1e-07 W=1.205e-06
M13_noxref VSS VDD VSS VSS nm1p2_svt_lp L=1e-07 W=1.205e-06
M14_noxref VSS VDD VSS VSS nm1p2_svt_lp L=1e-07 W=1.205e-06
M15_noxref VSS VDD VSS VSS nm1p2_svt_lp L=1e-07 W=1.205e-06
M16_noxref VSS VDD VSS VSS nm1p2_svt_lp L=1e-07 W=1.205e-06
M17_noxref VSS VDD VSS VSS nm1p2_svt_lp L=1e-07 W=1.205e-06
.ENDS

.SUBCKT FILLCAP65H9R VDD VSS
M0_noxref VSS VDD VSS VSS nm1p2_svt_lp L=1e-07 W=1.205e-06
M1_noxref VSS VDD VSS VSS nm1p2_svt_lp L=1e-07 W=1.205e-06
M2_noxref VSS VDD VSS VSS nm1p2_svt_lp L=1e-07 W=1.205e-06
M3_noxref VSS VDD VSS VSS nm1p2_svt_lp L=1e-07 W=1.205e-06
M4_noxref VSS VDD VSS VSS nm1p2_svt_lp L=1e-07 W=1.205e-06
M5_noxref VSS VDD VSS VSS nm1p2_svt_lp L=1e-07 W=1.205e-06
M6_noxref VSS VDD VSS VSS nm1p2_svt_lp L=1e-07 W=1.205e-06
M7_noxref VSS VDD VSS VSS nm1p2_svt_lp L=1e-07 W=1.205e-06
M8_noxref VSS VDD VSS VSS nm1p2_svt_lp L=1e-07 W=1.205e-06
M9_noxref VSS VDD VSS VSS nm1p2_svt_lp L=1e-07 W=1.205e-06
M10_noxref VSS VDD VSS VSS nm1p2_svt_lp L=1e-07 W=1.205e-06
M11_noxref VSS VDD VSS VSS nm1p2_svt_lp L=1e-07 W=1.205e-06
M12_noxref VSS VDD VSS VSS nm1p2_svt_lp L=1e-07 W=1.205e-06
M13_noxref VSS VDD VSS VSS nm1p2_svt_lp L=1e-07 W=1.205e-06
M14_noxref VSS VDD VSS VSS nm1p2_svt_lp L=1e-07 W=1.205e-06
M15_noxref VSS VDD VSS VSS nm1p2_svt_lp L=1e-07 W=1.205e-06
M16_noxref VSS VDD VSS VSS nm1p2_svt_lp L=1e-07 W=1.205e-06
M17_noxref VSS VDD VSS VSS nm1p2_svt_lp L=1e-07 W=1.205e-06
M18_noxref VSS VDD VSS VSS nm1p2_svt_lp L=1e-07 W=1.205e-06
M19_noxref VSS VDD VSS VSS nm1p2_svt_lp L=1e-07 W=1.205e-06
M20_noxref VSS VDD VSS VSS nm1p2_svt_lp L=1e-07 W=1.205e-06
M21_noxref VSS VDD VSS VSS nm1p2_svt_lp L=1e-07 W=1.205e-06
M22_noxref VSS VDD VSS VSS nm1p2_svt_lp L=1e-07 W=1.205e-06
M23_noxref VSS VDD VSS VSS nm1p2_svt_lp L=1e-07 W=1.205e-06
M24_noxref VSS VDD VSS VSS nm1p2_svt_lp L=1e-07 W=1.205e-06
M25_noxref VSS VDD VSS VSS nm1p2_svt_lp L=1e-07 W=1.205e-06
M26_noxref VSS VDD VSS VSS nm1p2_svt_lp L=1e-07 W=1.205e-06
M27_noxref VSS VDD VSS VSS nm1p2_svt_lp L=1e-07 W=1.205e-06
M28_noxref VSS VDD VSS VSS nm1p2_svt_lp L=1e-07 W=1.205e-06
M29_noxref VSS VDD VSS VSS nm1p2_svt_lp L=1e-07 W=1.205e-06
M30_noxref VSS VDD VSS VSS nm1p2_svt_lp L=1e-07 W=1.205e-06
M31_noxref VSS VDD VSS VSS nm1p2_svt_lp L=1e-07 W=1.205e-06
M32_noxref VSS VDD VSS VSS nm1p2_svt_lp L=1e-07 W=1.205e-06
M33_noxref VSS VDD VSS VSS nm1p2_svt_lp L=1e-07 W=1.205e-06
M34_noxref VSS VDD VSS VSS nm1p2_svt_lp L=1e-07 W=1.205e-06
M35_noxref VSS VDD VSS VSS nm1p2_svt_lp L=1e-07 W=1.205e-06
M36_noxref VSS VDD VSS VSS nm1p2_svt_lp L=1e-07 W=1.205e-06
M37_noxref VSS VDD VSS VSS nm1p2_svt_lp L=1e-07 W=1.205e-06
M38_noxref VSS VDD VSS VSS nm1p2_svt_lp L=1e-07 W=1.205e-06
M39_noxref VSS VDD VSS VSS nm1p2_svt_lp L=1e-07 W=1.205e-06
.ENDS

.SUBCKT FILLCAP128H9R VDD VSS
M0_noxref VSS VDD VSS VSS nm1p2_svt_lp L=1e-07 W=1.205e-06
M1_noxref VSS VDD VSS VSS nm1p2_svt_lp L=1e-07 W=1.205e-06
M2_noxref VSS VDD VSS VSS nm1p2_svt_lp L=1e-07 W=1.205e-06
M3_noxref VSS VDD VSS VSS nm1p2_svt_lp L=1e-07 W=1.205e-06
M4_noxref VSS VDD VSS VSS nm1p2_svt_lp L=1e-07 W=1.205e-06
M5_noxref VSS VDD VSS VSS nm1p2_svt_lp L=1e-07 W=1.205e-06
M6_noxref VSS VDD VSS VSS nm1p2_svt_lp L=1e-07 W=1.205e-06
M7_noxref VSS VDD VSS VSS nm1p2_svt_lp L=1e-07 W=1.205e-06
M8_noxref VSS VDD VSS VSS nm1p2_svt_lp L=1e-07 W=1.205e-06
M9_noxref VSS VDD VSS VSS nm1p2_svt_lp L=1e-07 W=1.205e-06
M10_noxref VSS VDD VSS VSS nm1p2_svt_lp L=1e-07 W=1.205e-06
M11_noxref VSS VDD VSS VSS nm1p2_svt_lp L=1e-07 W=1.205e-06
M12_noxref VSS VDD VSS VSS nm1p2_svt_lp L=1e-07 W=1.205e-06
M13_noxref VSS VDD VSS VSS nm1p2_svt_lp L=1e-07 W=1.205e-06
M14_noxref VSS VDD VSS VSS nm1p2_svt_lp L=1e-07 W=1.205e-06
M15_noxref VSS VDD VSS VSS nm1p2_svt_lp L=1e-07 W=1.205e-06
M16_noxref VSS VDD VSS VSS nm1p2_svt_lp L=1e-07 W=1.205e-06
M17_noxref VSS VDD VSS VSS nm1p2_svt_lp L=1e-07 W=1.205e-06
M18_noxref VSS VDD VSS VSS nm1p2_svt_lp L=1e-07 W=1.205e-06
M19_noxref VSS VDD VSS VSS nm1p2_svt_lp L=1e-07 W=1.205e-06
M20_noxref VSS VDD VSS VSS nm1p2_svt_lp L=1e-07 W=1.205e-06
M21_noxref VSS VDD VSS VSS nm1p2_svt_lp L=1e-07 W=1.205e-06
M22_noxref VSS VDD VSS VSS nm1p2_svt_lp L=1e-07 W=1.205e-06
M23_noxref VSS VDD VSS VSS nm1p2_svt_lp L=1e-07 W=1.205e-06
M24_noxref VSS VDD VSS VSS nm1p2_svt_lp L=1e-07 W=1.205e-06
M25_noxref VSS VDD VSS VSS nm1p2_svt_lp L=1e-07 W=1.205e-06
M26_noxref VSS VDD VSS VSS nm1p2_svt_lp L=1e-07 W=1.205e-06
M27_noxref VSS VDD VSS VSS nm1p2_svt_lp L=1e-07 W=1.205e-06
M28_noxref VSS VDD VSS VSS nm1p2_svt_lp L=1e-07 W=1.205e-06
M29_noxref VSS VDD VSS VSS nm1p2_svt_lp L=1e-07 W=1.205e-06
M30_noxref VSS VDD VSS VSS nm1p2_svt_lp L=1e-07 W=1.205e-06
M31_noxref VSS VDD VSS VSS nm1p2_svt_lp L=1e-07 W=1.205e-06
M32_noxref VSS VDD VSS VSS nm1p2_svt_lp L=1e-07 W=1.205e-06
M33_noxref VSS VDD VSS VSS nm1p2_svt_lp L=1e-07 W=1.205e-06
M34_noxref VSS VDD VSS VSS nm1p2_svt_lp L=1e-07 W=1.205e-06
M35_noxref VSS VDD VSS VSS nm1p2_svt_lp L=1e-07 W=1.205e-06
M36_noxref VSS VDD VSS VSS nm1p2_svt_lp L=1e-07 W=1.205e-06
M37_noxref VSS VDD VSS VSS nm1p2_svt_lp L=1e-07 W=1.205e-06
M38_noxref VSS VDD VSS VSS nm1p2_svt_lp L=1e-07 W=1.205e-06
M39_noxref VSS VDD VSS VSS nm1p2_svt_lp L=1e-07 W=1.205e-06
M40_noxref VSS VDD VSS VSS nm1p2_svt_lp L=1e-07 W=1.205e-06
M41_noxref VSS VDD VSS VSS nm1p2_svt_lp L=1e-07 W=1.205e-06
M42_noxref VSS VDD VSS VSS nm1p2_svt_lp L=1e-07 W=1.205e-06
M43_noxref VSS VDD VSS VSS nm1p2_svt_lp L=1e-07 W=1.205e-06
M44_noxref VSS VDD VSS VSS nm1p2_svt_lp L=1e-07 W=1.205e-06
M45_noxref VSS VDD VSS VSS nm1p2_svt_lp L=1e-07 W=1.205e-06
M46_noxref VSS VDD VSS VSS nm1p2_svt_lp L=1e-07 W=1.205e-06
M47_noxref VSS VDD VSS VSS nm1p2_svt_lp L=1e-07 W=1.205e-06
M48_noxref VSS VDD VSS VSS nm1p2_svt_lp L=1e-07 W=1.205e-06
M49_noxref VSS VDD VSS VSS nm1p2_svt_lp L=1e-07 W=1.205e-06
M50_noxref VSS VDD VSS VSS nm1p2_svt_lp L=1e-07 W=1.205e-06
M51_noxref VSS VDD VSS VSS nm1p2_svt_lp L=1e-07 W=1.205e-06
M52_noxref VSS VDD VSS VSS nm1p2_svt_lp L=1e-07 W=1.205e-06
M53_noxref VSS VDD VSS VSS nm1p2_svt_lp L=1e-07 W=1.205e-06
M54_noxref VSS VDD VSS VSS nm1p2_svt_lp L=1e-07 W=1.205e-06
M55_noxref VSS VDD VSS VSS nm1p2_svt_lp L=1e-07 W=1.205e-06
M56_noxref VSS VDD VSS VSS nm1p2_svt_lp L=1e-07 W=1.205e-06
M57_noxref VSS VDD VSS VSS nm1p2_svt_lp L=1e-07 W=1.205e-06
M58_noxref VSS VDD VSS VSS nm1p2_svt_lp L=1e-07 W=1.205e-06
M59_noxref VSS VDD VSS VSS nm1p2_svt_lp L=1e-07 W=1.205e-06
M60_noxref VSS VDD VSS VSS nm1p2_svt_lp L=1e-07 W=1.205e-06
M61_noxref VSS VDD VSS VSS nm1p2_svt_lp L=1e-07 W=1.205e-06
M62_noxref VSS VDD VSS VSS nm1p2_svt_lp L=1e-07 W=1.205e-06
M63_noxref VSS VDD VSS VSS nm1p2_svt_lp L=1e-07 W=1.205e-06
M64_noxref VSS VDD VSS VSS nm1p2_svt_lp L=1e-07 W=1.205e-06
M65_noxref VSS VDD VSS VSS nm1p2_svt_lp L=1e-07 W=1.205e-06
M66_noxref VSS VDD VSS VSS nm1p2_svt_lp L=1e-07 W=1.205e-06
M67_noxref VSS VDD VSS VSS nm1p2_svt_lp L=1e-07 W=1.205e-06
M68_noxref VSS VDD VSS VSS nm1p2_svt_lp L=1e-07 W=1.205e-06
M69_noxref VSS VDD VSS VSS nm1p2_svt_lp L=1e-07 W=1.205e-06
M70_noxref VSS VDD VSS VSS nm1p2_svt_lp L=1e-07 W=1.205e-06
M71_noxref VSS VDD VSS VSS nm1p2_svt_lp L=1e-07 W=1.205e-06
M72_noxref VSS VDD VSS VSS nm1p2_svt_lp L=1e-07 W=1.205e-06
M73_noxref VSS VDD VSS VSS nm1p2_svt_lp L=1e-07 W=1.205e-06
M74_noxref VSS VDD VSS VSS nm1p2_svt_lp L=1e-07 W=1.205e-06
M75_noxref VSS VDD VSS VSS nm1p2_svt_lp L=1e-07 W=1.205e-06
M76_noxref VSS VDD VSS VSS nm1p2_svt_lp L=1e-07 W=1.205e-06
M77_noxref VSS VDD VSS VSS nm1p2_svt_lp L=1e-07 W=1.205e-06
M78_noxref VSS VDD VSS VSS nm1p2_svt_lp L=1e-07 W=1.205e-06
M79_noxref VSS VDD VSS VSS nm1p2_svt_lp L=1e-07 W=1.205e-06
M80_noxref VSS VDD VSS VSS nm1p2_svt_lp L=1e-07 W=1.205e-06
M81_noxref VSS VDD VSS VSS nm1p2_svt_lp L=1e-07 W=1.205e-06
.ENDS

.SUBCKT FILLCAPTAP8H9R VDD VSS
*.CONNECT VSS VSS
*.CONNECT VDD VDD
M0_noxref VSS VDD VSS VSS nm1p2_svt_lp L=1e-07 W=1.205e-06
.ENDS

.SUBCKT FILLCAPTAP17H9R VDD VSS
*.CONNECT VSS VSS
*.CONNECT VDD VDD
M0_noxref VSS VDD VSS VSS nm1p2_svt_lp L=1e-07 W=1.205e-06
M1_noxref VSS VDD VSS VSS nm1p2_svt_lp L=1e-07 W=1.205e-06
M2_noxref VSS VDD VSS VSS nm1p2_svt_lp L=1e-07 W=1.205e-06
M3_noxref VSS VDD VSS VSS nm1p2_svt_lp L=1e-07 W=1.205e-06
M4_noxref VSS VDD VSS VSS nm1p2_svt_lp L=1e-07 W=1.205e-06
M5_noxref VSS VDD VSS VSS nm1p2_svt_lp L=1e-07 W=1.205e-06
.ENDS

.SUBCKT FILLCAPTAP32H9R VDD VSS
*.CONNECT VSS VSS
*.CONNECT VDD VDD
M0_noxref VSS VDD VSS VSS nm1p2_svt_lp L=1e-07 W=1.205e-06
M1_noxref VSS VDD VSS VSS nm1p2_svt_lp L=1e-07 W=1.205e-06
M2_noxref VSS VDD VSS VSS nm1p2_svt_lp L=1e-07 W=1.205e-06
M3_noxref VSS VDD VSS VSS nm1p2_svt_lp L=1e-07 W=1.205e-06
M4_noxref VSS VDD VSS VSS nm1p2_svt_lp L=1e-07 W=1.205e-06
M5_noxref VSS VDD VSS VSS nm1p2_svt_lp L=1e-07 W=1.205e-06
M6_noxref VSS VDD VSS VSS nm1p2_svt_lp L=1e-07 W=1.205e-06
M7_noxref VSS VDD VSS VSS nm1p2_svt_lp L=1e-07 W=1.205e-06
M8_noxref VSS VDD VSS VSS nm1p2_svt_lp L=1e-07 W=1.205e-06
M9_noxref VSS VDD VSS VSS nm1p2_svt_lp L=1e-07 W=1.205e-06
M10_noxref VSS VDD VSS VSS nm1p2_svt_lp L=1e-07 W=1.205e-06
M11_noxref VSS VDD VSS VSS nm1p2_svt_lp L=1e-07 W=1.205e-06
M12_noxref VSS VDD VSS VSS nm1p2_svt_lp L=1e-07 W=1.205e-06
M13_noxref VSS VDD VSS VSS nm1p2_svt_lp L=1e-07 W=1.205e-06
M14_noxref VSS VDD VSS VSS nm1p2_svt_lp L=1e-07 W=1.205e-06
M15_noxref VSS VDD VSS VSS nm1p2_svt_lp L=1e-07 W=1.205e-06
.ENDS

.SUBCKT FILLCAPTAP65H9R VDD VSS
*.CONNECT VSS VSS
*.CONNECT VDD VDD
M0_noxref VSS VDD VSS VSS nm1p2_svt_lp L=1e-07 W=1.205e-06
M1_noxref VSS VDD VSS VSS nm1p2_svt_lp L=1e-07 W=1.205e-06
M2_noxref VSS VDD VSS VSS nm1p2_svt_lp L=1e-07 W=1.205e-06
M3_noxref VSS VDD VSS VSS nm1p2_svt_lp L=1e-07 W=1.205e-06
M4_noxref VSS VDD VSS VSS nm1p2_svt_lp L=1e-07 W=1.205e-06
M5_noxref VSS VDD VSS VSS nm1p2_svt_lp L=1e-07 W=1.205e-06
M6_noxref VSS VDD VSS VSS nm1p2_svt_lp L=1e-07 W=1.205e-06
M7_noxref VSS VDD VSS VSS nm1p2_svt_lp L=1e-07 W=1.205e-06
M8_noxref VSS VDD VSS VSS nm1p2_svt_lp L=1e-07 W=1.205e-06
M9_noxref VSS VDD VSS VSS nm1p2_svt_lp L=1e-07 W=1.205e-06
M10_noxref VSS VDD VSS VSS nm1p2_svt_lp L=1e-07 W=1.205e-06
M11_noxref VSS VDD VSS VSS nm1p2_svt_lp L=1e-07 W=1.205e-06
M12_noxref VSS VDD VSS VSS nm1p2_svt_lp L=1e-07 W=1.205e-06
M13_noxref VSS VDD VSS VSS nm1p2_svt_lp L=1e-07 W=1.205e-06
M14_noxref VSS VDD VSS VSS nm1p2_svt_lp L=1e-07 W=1.205e-06
M15_noxref VSS VDD VSS VSS nm1p2_svt_lp L=1e-07 W=1.205e-06
M16_noxref VSS VDD VSS VSS nm1p2_svt_lp L=1e-07 W=1.205e-06
M17_noxref VSS VDD VSS VSS nm1p2_svt_lp L=1e-07 W=1.205e-06
M18_noxref VSS VDD VSS VSS nm1p2_svt_lp L=1e-07 W=1.205e-06
M19_noxref VSS VDD VSS VSS nm1p2_svt_lp L=1e-07 W=1.205e-06
M20_noxref VSS VDD VSS VSS nm1p2_svt_lp L=1e-07 W=1.205e-06
M21_noxref VSS VDD VSS VSS nm1p2_svt_lp L=1e-07 W=1.205e-06
M22_noxref VSS VDD VSS VSS nm1p2_svt_lp L=1e-07 W=1.205e-06
M23_noxref VSS VDD VSS VSS nm1p2_svt_lp L=1e-07 W=1.205e-06
M24_noxref VSS VDD VSS VSS nm1p2_svt_lp L=1e-07 W=1.205e-06
M25_noxref VSS VDD VSS VSS nm1p2_svt_lp L=1e-07 W=1.205e-06
M26_noxref VSS VDD VSS VSS nm1p2_svt_lp L=1e-07 W=1.205e-06
M27_noxref VSS VDD VSS VSS nm1p2_svt_lp L=1e-07 W=1.205e-06
M28_noxref VSS VDD VSS VSS nm1p2_svt_lp L=1e-07 W=1.205e-06
M29_noxref VSS VDD VSS VSS nm1p2_svt_lp L=1e-07 W=1.205e-06
M30_noxref VSS VDD VSS VSS nm1p2_svt_lp L=1e-07 W=1.205e-06
M31_noxref VSS VDD VSS VSS nm1p2_svt_lp L=1e-07 W=1.205e-06
M32_noxref VSS VDD VSS VSS nm1p2_svt_lp L=1e-07 W=1.205e-06
M33_noxref VSS VDD VSS VSS nm1p2_svt_lp L=1e-07 W=1.205e-06
M34_noxref VSS VDD VSS VSS nm1p2_svt_lp L=1e-07 W=1.205e-06
M35_noxref VSS VDD VSS VSS nm1p2_svt_lp L=1e-07 W=1.205e-06
M36_noxref VSS VDD VSS VSS nm1p2_svt_lp L=1e-07 W=1.205e-06
M37_noxref VSS VDD VSS VSS nm1p2_svt_lp L=1e-07 W=1.205e-06
.ENDS

.SUBCKT FILLCAPTAP128H9R VDD VSS
*.CONNECT VSS VSS
*.CONNECT VDD VDD
M0_noxref VSS VDD VSS VSS nm1p2_svt_lp L=1e-07 W=1.205e-06
M1_noxref VSS VDD VSS VSS nm1p2_svt_lp L=1e-07 W=1.205e-06
M2_noxref VSS VDD VSS VSS nm1p2_svt_lp L=1e-07 W=1.205e-06
M3_noxref VSS VDD VSS VSS nm1p2_svt_lp L=1e-07 W=1.205e-06
M4_noxref VSS VDD VSS VSS nm1p2_svt_lp L=1e-07 W=1.205e-06
M5_noxref VSS VDD VSS VSS nm1p2_svt_lp L=1e-07 W=1.205e-06
M6_noxref VSS VDD VSS VSS nm1p2_svt_lp L=1e-07 W=1.205e-06
M7_noxref VSS VDD VSS VSS nm1p2_svt_lp L=1e-07 W=1.205e-06
M8_noxref VSS VDD VSS VSS nm1p2_svt_lp L=1e-07 W=1.205e-06
M9_noxref VSS VDD VSS VSS nm1p2_svt_lp L=1e-07 W=1.205e-06
M10_noxref VSS VDD VSS VSS nm1p2_svt_lp L=1e-07 W=1.205e-06
M11_noxref VSS VDD VSS VSS nm1p2_svt_lp L=1e-07 W=1.205e-06
M12_noxref VSS VDD VSS VSS nm1p2_svt_lp L=1e-07 W=1.205e-06
M13_noxref VSS VDD VSS VSS nm1p2_svt_lp L=1e-07 W=1.205e-06
M14_noxref VSS VDD VSS VSS nm1p2_svt_lp L=1e-07 W=1.205e-06
M15_noxref VSS VDD VSS VSS nm1p2_svt_lp L=1e-07 W=1.205e-06
M16_noxref VSS VDD VSS VSS nm1p2_svt_lp L=1e-07 W=1.205e-06
M17_noxref VSS VDD VSS VSS nm1p2_svt_lp L=1e-07 W=1.205e-06
M18_noxref VSS VDD VSS VSS nm1p2_svt_lp L=1e-07 W=1.205e-06
M19_noxref VSS VDD VSS VSS nm1p2_svt_lp L=1e-07 W=1.205e-06
M20_noxref VSS VDD VSS VSS nm1p2_svt_lp L=1e-07 W=1.205e-06
M21_noxref VSS VDD VSS VSS nm1p2_svt_lp L=1e-07 W=1.205e-06
M22_noxref VSS VDD VSS VSS nm1p2_svt_lp L=1e-07 W=1.205e-06
M23_noxref VSS VDD VSS VSS nm1p2_svt_lp L=1e-07 W=1.205e-06
M24_noxref VSS VDD VSS VSS nm1p2_svt_lp L=1e-07 W=1.205e-06
M25_noxref VSS VDD VSS VSS nm1p2_svt_lp L=1e-07 W=1.205e-06
M26_noxref VSS VDD VSS VSS nm1p2_svt_lp L=1e-07 W=1.205e-06
M27_noxref VSS VDD VSS VSS nm1p2_svt_lp L=1e-07 W=1.205e-06
M28_noxref VSS VDD VSS VSS nm1p2_svt_lp L=1e-07 W=1.205e-06
M29_noxref VSS VDD VSS VSS nm1p2_svt_lp L=1e-07 W=1.205e-06
M30_noxref VSS VDD VSS VSS nm1p2_svt_lp L=1e-07 W=1.205e-06
M31_noxref VSS VDD VSS VSS nm1p2_svt_lp L=1e-07 W=1.205e-06
M32_noxref VSS VDD VSS VSS nm1p2_svt_lp L=1e-07 W=1.205e-06
M33_noxref VSS VDD VSS VSS nm1p2_svt_lp L=1e-07 W=1.205e-06
M34_noxref VSS VDD VSS VSS nm1p2_svt_lp L=1e-07 W=1.205e-06
M35_noxref VSS VDD VSS VSS nm1p2_svt_lp L=1e-07 W=1.205e-06
M36_noxref VSS VDD VSS VSS nm1p2_svt_lp L=1e-07 W=1.205e-06
M37_noxref VSS VDD VSS VSS nm1p2_svt_lp L=1e-07 W=1.205e-06
M38_noxref VSS VDD VSS VSS nm1p2_svt_lp L=1e-07 W=1.205e-06
M39_noxref VSS VDD VSS VSS nm1p2_svt_lp L=1e-07 W=1.205e-06
M40_noxref VSS VDD VSS VSS nm1p2_svt_lp L=1e-07 W=1.205e-06
M41_noxref VSS VDD VSS VSS nm1p2_svt_lp L=1e-07 W=1.205e-06
M42_noxref VSS VDD VSS VSS nm1p2_svt_lp L=1e-07 W=1.205e-06
M43_noxref VSS VDD VSS VSS nm1p2_svt_lp L=1e-07 W=1.205e-06
M44_noxref VSS VDD VSS VSS nm1p2_svt_lp L=1e-07 W=1.205e-06
M45_noxref VSS VDD VSS VSS nm1p2_svt_lp L=1e-07 W=1.205e-06
M46_noxref VSS VDD VSS VSS nm1p2_svt_lp L=1e-07 W=1.205e-06
M47_noxref VSS VDD VSS VSS nm1p2_svt_lp L=1e-07 W=1.205e-06
M48_noxref VSS VDD VSS VSS nm1p2_svt_lp L=1e-07 W=1.205e-06
M49_noxref VSS VDD VSS VSS nm1p2_svt_lp L=1e-07 W=1.205e-06
M50_noxref VSS VDD VSS VSS nm1p2_svt_lp L=1e-07 W=1.205e-06
M51_noxref VSS VDD VSS VSS nm1p2_svt_lp L=1e-07 W=1.205e-06
M52_noxref VSS VDD VSS VSS nm1p2_svt_lp L=1e-07 W=1.205e-06
M53_noxref VSS VDD VSS VSS nm1p2_svt_lp L=1e-07 W=1.205e-06
M54_noxref VSS VDD VSS VSS nm1p2_svt_lp L=1e-07 W=1.205e-06
M55_noxref VSS VDD VSS VSS nm1p2_svt_lp L=1e-07 W=1.205e-06
M56_noxref VSS VDD VSS VSS nm1p2_svt_lp L=1e-07 W=1.205e-06
M57_noxref VSS VDD VSS VSS nm1p2_svt_lp L=1e-07 W=1.205e-06
M58_noxref VSS VDD VSS VSS nm1p2_svt_lp L=1e-07 W=1.205e-06
M59_noxref VSS VDD VSS VSS nm1p2_svt_lp L=1e-07 W=1.205e-06
M60_noxref VSS VDD VSS VSS nm1p2_svt_lp L=1e-07 W=1.205e-06
M61_noxref VSS VDD VSS VSS nm1p2_svt_lp L=1e-07 W=1.205e-06
M62_noxref VSS VDD VSS VSS nm1p2_svt_lp L=1e-07 W=1.205e-06
M63_noxref VSS VDD VSS VSS nm1p2_svt_lp L=1e-07 W=1.205e-06
M64_noxref VSS VDD VSS VSS nm1p2_svt_lp L=1e-07 W=1.205e-06
M65_noxref VSS VDD VSS VSS nm1p2_svt_lp L=1e-07 W=1.205e-06
M66_noxref VSS VDD VSS VSS nm1p2_svt_lp L=1e-07 W=1.205e-06
M67_noxref VSS VDD VSS VSS nm1p2_svt_lp L=1e-07 W=1.205e-06
M68_noxref VSS VDD VSS VSS nm1p2_svt_lp L=1e-07 W=1.205e-06
M69_noxref VSS VDD VSS VSS nm1p2_svt_lp L=1e-07 W=1.205e-06
M70_noxref VSS VDD VSS VSS nm1p2_svt_lp L=1e-07 W=1.205e-06
M71_noxref VSS VDD VSS VSS nm1p2_svt_lp L=1e-07 W=1.205e-06
M72_noxref VSS VDD VSS VSS nm1p2_svt_lp L=1e-07 W=1.205e-06
M73_noxref VSS VDD VSS VSS nm1p2_svt_lp L=1e-07 W=1.205e-06
M74_noxref VSS VDD VSS VSS nm1p2_svt_lp L=1e-07 W=1.205e-06
M75_noxref VSS VDD VSS VSS nm1p2_svt_lp L=1e-07 W=1.205e-06
M76_noxref VSS VDD VSS VSS nm1p2_svt_lp L=1e-07 W=1.205e-06
M77_noxref VSS VDD VSS VSS nm1p2_svt_lp L=1e-07 W=1.205e-06
M78_noxref VSS VDD VSS VSS nm1p2_svt_lp L=1e-07 W=1.205e-06
M79_noxref VSS VDD VSS VSS nm1p2_svt_lp L=1e-07 W=1.205e-06
.ENDS

.SUBCKT ENDCAP2H9R VDD VSS
*.CONNECT VSS VSS
*.CONNECT VDD VDD
.ENDS

.SUBCKT TIEHIX1H9R Y VDD VSS
MXNhi lo hi VSS VSS nm1p2_svt_lp L=6e-08 W=1.5e-07
MXNlo lo lo VSS VSS nm1p2_svt_lp L=6e-08 W=1.5e-07
MXPlo1 hi lo VDD VDD pm1p2_svt_lp L=6e-08 W=1.5e-07
MXPlo2 Y lo VDD VDD pm1p2_svt_lp L=6e-08 W=5.85e-07
.ENDS

.SUBCKT TIELOX1H9R Y VDD VSS
MXNhi1 lo hi VSS VSS nm1p2_svt_lp L=6e-08 W=1.5e-07
MXNhi2 Y hi VSS VSS nm1p2_svt_lp L=6e-08 W=4.2e-07
MXPlo hi lo VDD VDD pm1p2_svt_lp L=6e-08 W=1.5e-07
MXPhi hi hi VDD VDD pm1p2_svt_lp L=6e-08 W=1.5e-07
.ENDS

.SUBCKT ANT2H9R VDD VSS A
D_Diode_XD0 VSS A dio_1p2_np_pw_lp AREA=1.3095e-13 perim=1.51e-06
.ENDS

.SUBCKT DLY2X0P5H9R Y VDD VSS A
MI0_MXNA1 XI0_n1 A VSS VSS nm1p2_svt_lp L=6e-08 W=1.5e-07
MI0_MXNOE ny A XI0_n1 VSS nm1p2_svt_lp L=6e-08 W=1.5e-07
MXN0 VSS ny VSS VSS nm1p2_svt_lp L=6e-08 W=1.6e-07
MI1_MXNA1 Y ny VSS VSS nm1p2_svt_lp L=6e-08 W=2.05e-07
MI0_MXPOEN ny A XI0_p1 VDD pm1p2_svt_lp L=6e-08 W=2.1e-07
MI0_MXPA1 XI0_p1 A VDD VDD pm1p2_svt_lp L=6e-08 W=2.1e-07
MI1_MXPA1 Y ny VDD VDD pm1p2_svt_lp L=6e-08 W=2.85e-07
MXP0 VDD ny VDD VDD pm1p2_svt_lp L=6e-08 W=1.7e-07
.ENDS

.SUBCKT DLY2X1H9R Y VDD VSS A
MI0_MXNA1 XI0_n1 A VSS VSS nm1p2_svt_lp L=6e-08 W=1.8e-07
MI0_MXNOE ny A XI0_n1 VSS nm1p2_svt_lp L=6e-08 W=1.8e-07
MXN0 VSS ny VSS VSS nm1p2_svt_lp L=6e-08 W=1.8e-07
MI1_MXNA1 Y ny VSS VSS nm1p2_svt_lp L=6e-08 W=4.2e-07
MI0_MXPOEN ny A XI0_p1 VDD pm1p2_svt_lp L=6e-08 W=2.25e-07
MI0_MXPA1 XI0_p1 A VDD VDD pm1p2_svt_lp L=6e-08 W=2.25e-07
MXP0 VDD ny VDD VDD pm1p2_svt_lp L=6e-08 W=2.25e-07
MI1_MXPA1 Y ny VDD VDD pm1p2_svt_lp L=6e-08 W=5.85e-07
.ENDS

.SUBCKT DLY2X2H9R Y VDD VSS A
MI0_MXNOE ny A XI0_n1 VSS nm1p2_svt_lp L=6e-08 W=3.45e-07
MI0_MXNA1 XI0_n1 A VSS VSS nm1p2_svt_lp L=6e-08 W=3.45e-07
MXN0 VSS ny VSS VSS nm1p2_svt_lp L=6e-08 W=3.45e-07
MI1_MXNA1 Y ny VSS VSS nm1p2_svt_lp L=6e-08 W=4.2e-07
MI1_MXNA1_2 Y ny VSS VSS nm1p2_svt_lp L=6e-08 W=4.2e-07
MI0_MXPOEN ny A XI0_p1 VDD pm1p2_svt_lp L=6e-08 W=4.8e-07
MI0_MXPA1 XI0_p1 A VDD VDD pm1p2_svt_lp L=6e-08 W=4.8e-07
MXP0 VDD ny VDD VDD pm1p2_svt_lp L=6e-08 W=4.8e-07
MI1_MXPA1 Y ny VDD VDD pm1p2_svt_lp L=6e-08 W=5.85e-07
MI1_MXPA1_2 Y ny VDD VDD pm1p2_svt_lp L=6e-08 W=5.85e-07
.ENDS

.SUBCKT DLY2X4H9R Y VDD VSS A
MI0_MXNOE ny A XI0_n1 VSS nm1p2_svt_lp L=6e-08 W=4.2e-07
MI0_MXNA1 XI0_n1 A VSS VSS nm1p2_svt_lp L=6e-08 W=4.2e-07
MXN0 VSS ny VSS VSS nm1p2_svt_lp L=6e-08 W=4.2e-07
MI1_MXNA1 Y ny VSS VSS nm1p2_svt_lp L=6e-08 W=4.2e-07
MI1_MXNA1_2 Y ny VSS VSS nm1p2_svt_lp L=6e-08 W=4.2e-07
MI1_MXNA1_3 Y ny VSS VSS nm1p2_svt_lp L=6e-08 W=4.2e-07
MI1_MXNA1_4 Y ny VSS VSS nm1p2_svt_lp L=6e-08 W=4.2e-07
MI0_MXPOEN ny A XI0_p1 VDD pm1p2_svt_lp L=6e-08 W=5.85e-07
MI0_MXPA1 XI0_p1 A VDD VDD pm1p2_svt_lp L=6e-08 W=5.85e-07
MXP0 VDD ny VDD VDD pm1p2_svt_lp L=6e-08 W=5.85e-07
MI1_MXPA1 Y ny VDD VDD pm1p2_svt_lp L=6e-08 W=5.85e-07
MI1_MXPA1_2 Y ny VDD VDD pm1p2_svt_lp L=6e-08 W=5.85e-07
MI1_MXPA1_3 Y ny VDD VDD pm1p2_svt_lp L=6e-08 W=5.85e-07
MI1_MXPA1_4 Y ny VDD VDD pm1p2_svt_lp L=6e-08 W=5.85e-07
.ENDS

.SUBCKT DLY4X0P5H9R Y VDD VSS A
MI0_MXNA1 XI0_n1 A VSS VSS nm1p2_svt_lp L=6e-08 W=1.5e-07
MI0_MXNOE na A XI0_n1 VSS nm1p2_svt_lp L=6e-08 W=1.5e-07
MI1_MXNA1 XI1_n1 na VSS VSS nm1p2_svt_lp L=6e-08 W=1.5e-07
MI1_MXNOE ba na XI1_n1 VSS nm1p2_svt_lp L=6e-08 W=1.5e-07
MI2_MXNA1 XI2_n1 ba VSS VSS nm1p2_svt_lp L=6e-08 W=1.5e-07
MI2_MXNOE nba ba XI2_n1 VSS nm1p2_svt_lp L=6e-08 W=1.5e-07
MXN0 VSS nba VSS VSS nm1p2_svt_lp L=6e-08 W=1.6e-07
MI3_MXNA1 Y nba VSS VSS nm1p2_svt_lp L=6e-08 W=2.05e-07
MI0_MXPOEN na A XI0_p1 VDD pm1p2_svt_lp L=6e-08 W=2.1e-07
MI0_MXPA1 XI0_p1 A VDD VDD pm1p2_svt_lp L=6e-08 W=2.1e-07
MI1_MXPOEN ba na XI1_p1 VDD pm1p2_svt_lp L=6e-08 W=2.1e-07
MI1_MXPA1 XI1_p1 na VDD VDD pm1p2_svt_lp L=6e-08 W=2.1e-07
MI2_MXPOEN nba ba XI2_p1 VDD pm1p2_svt_lp L=6e-08 W=2.1e-07
MI2_MXPA1 XI2_p1 ba VDD VDD pm1p2_svt_lp L=6e-08 W=2.1e-07
MI3_MXPA1 Y nba VDD VDD pm1p2_svt_lp L=6e-08 W=2.85e-07
MXP0 VDD nba VDD VDD pm1p2_svt_lp L=6e-08 W=1.7e-07
.ENDS

.SUBCKT DLY4X1H9R Y VDD VSS A
MI0_MXNA1 XI0_n1 A VSS VSS nm1p2_svt_lp L=6e-08 W=1.5e-07
MI0_MXNOE na A XI0_n1 VSS nm1p2_svt_lp L=6e-08 W=1.5e-07
MI1_MXNA1 XI1_n1 na VSS VSS nm1p2_svt_lp L=6e-08 W=1.5e-07
MI1_MXNOE ba na XI1_n1 VSS nm1p2_svt_lp L=6e-08 W=1.5e-07
MI2_MXNA1 XI2_n1 ba VSS VSS nm1p2_svt_lp L=6e-08 W=1.8e-07
MI2_MXNOE nba ba XI2_n1 VSS nm1p2_svt_lp L=6e-08 W=1.8e-07
MXN0 VSS nba VSS VSS nm1p2_svt_lp L=6e-08 W=1.8e-07
MI3_MXNA1 Y nba VSS VSS nm1p2_svt_lp L=6e-08 W=4.2e-07
MI0_MXPOEN na A XI0_p1 VDD pm1p2_svt_lp L=6e-08 W=1.5e-07
MI0_MXPA1 XI0_p1 A VDD VDD pm1p2_svt_lp L=6e-08 W=1.5e-07
MI1_MXPOEN ba na XI1_p1 VDD pm1p2_svt_lp L=6e-08 W=1.5e-07
MI1_MXPA1 XI1_p1 na VDD VDD pm1p2_svt_lp L=6e-08 W=1.5e-07
MI2_MXPOEN nba ba XI2_p1 VDD pm1p2_svt_lp L=6e-08 W=2.25e-07
MI2_MXPA1 XI2_p1 ba VDD VDD pm1p2_svt_lp L=6e-08 W=2.25e-07
MXP0 VDD nba VDD VDD pm1p2_svt_lp L=6e-08 W=2.25e-07
MI3_MXPA1 Y nba VDD VDD pm1p2_svt_lp L=6e-08 W=5.85e-07
.ENDS

.SUBCKT DLY4X2H9R Y VDD VSS A
MI0_MXNOE na A XI0_n1 VSS nm1p2_svt_lp L=6e-08 W=1.5e-07
MI0_MXNA1 XI0_n1 A VSS VSS nm1p2_svt_lp L=6e-08 W=1.5e-07
MI1_MXNA1 XI1_n1 na VSS VSS nm1p2_svt_lp L=6e-08 W=1.5e-07
MI1_MXNOE ba na XI1_n1 VSS nm1p2_svt_lp L=6e-08 W=1.5e-07
MI2_MXNOE nba ba XI2_n1 VSS nm1p2_svt_lp L=6e-08 W=3.45e-07
MI2_MXNA1 XI2_n1 ba VSS VSS nm1p2_svt_lp L=6e-08 W=3.45e-07
MXN0 VSS nba VSS VSS nm1p2_svt_lp L=6e-08 W=3.45e-07
MI3_MXNA1 Y nba VSS VSS nm1p2_svt_lp L=6e-08 W=4.2e-07
MI3_MXNA1_2 Y nba VSS VSS nm1p2_svt_lp L=6e-08 W=4.2e-07
MI0_MXPOEN na A XI0_p1 VDD pm1p2_svt_lp L=6e-08 W=1.5e-07
MI0_MXPA1 XI0_p1 A VDD VDD pm1p2_svt_lp L=6e-08 W=1.5e-07
MI1_MXPA1 XI1_p1 na VDD VDD pm1p2_svt_lp L=6e-08 W=1.5e-07
MI1_MXPOEN ba na XI1_p1 VDD pm1p2_svt_lp L=6e-08 W=1.5e-07
MI2_MXPOEN nba ba XI2_p1 VDD pm1p2_svt_lp L=6e-08 W=4.8e-07
MI2_MXPA1 XI2_p1 ba VDD VDD pm1p2_svt_lp L=6e-08 W=4.8e-07
MXP0 VDD nba VDD VDD pm1p2_svt_lp L=6e-08 W=4.8e-07
MI3_MXPA1 Y nba VDD VDD pm1p2_svt_lp L=6e-08 W=5.85e-07
MI3_MXPA1_2 Y nba VDD VDD pm1p2_svt_lp L=6e-08 W=5.85e-07
.ENDS

.SUBCKT DLY4X4H9R Y VDD VSS A
MI0_MXNOE na A XI0_n1 VSS nm1p2_svt_lp L=6e-08 W=1.5e-07
MI0_MXNA1 XI0_n1 A VSS VSS nm1p2_svt_lp L=6e-08 W=1.5e-07
MI1_MXNA1 XI1_n1 na VSS VSS nm1p2_svt_lp L=6e-08 W=1.8e-07
MI1_MXNOE ba na XI1_n1 VSS nm1p2_svt_lp L=6e-08 W=1.8e-07
MI2_MXNOE nba ba XI2_n1 VSS nm1p2_svt_lp L=6e-08 W=4.2e-07
MI2_MXNA1 XI2_n1 ba VSS VSS nm1p2_svt_lp L=6e-08 W=4.2e-07
MXN0 VSS nba VSS VSS nm1p2_svt_lp L=6e-08 W=4.2e-07
MI3_MXNA1 Y nba VSS VSS nm1p2_svt_lp L=6e-08 W=4.2e-07
MI3_MXNA1_2 Y nba VSS VSS nm1p2_svt_lp L=6e-08 W=4.2e-07
MI3_MXNA1_3 Y nba VSS VSS nm1p2_svt_lp L=6e-08 W=4.2e-07
MI3_MXNA1_4 Y nba VSS VSS nm1p2_svt_lp L=6e-08 W=4.2e-07
MI0_MXPOEN na A XI0_p1 VDD pm1p2_svt_lp L=6e-08 W=1.5e-07
MI0_MXPA1 XI0_p1 A VDD VDD pm1p2_svt_lp L=6e-08 W=1.5e-07
MI1_MXPA1 XI1_p1 na VDD VDD pm1p2_svt_lp L=6e-08 W=2.5e-07
MI1_MXPOEN ba na XI1_p1 VDD pm1p2_svt_lp L=6e-08 W=2.5e-07
MI2_MXPOEN nba ba XI2_p1 VDD pm1p2_svt_lp L=6e-08 W=5.85e-07
MI2_MXPA1 XI2_p1 ba VDD VDD pm1p2_svt_lp L=6e-08 W=5.85e-07
MXP0 VDD nba VDD VDD pm1p2_svt_lp L=6e-08 W=5.85e-07
MI3_MXPA1 Y nba VDD VDD pm1p2_svt_lp L=6e-08 W=5.85e-07
MI3_MXPA1_2 Y nba VDD VDD pm1p2_svt_lp L=6e-08 W=5.85e-07
MI3_MXPA1_3 Y nba VDD VDD pm1p2_svt_lp L=6e-08 W=5.85e-07
MI3_MXPA1_4 Y nba VDD VDD pm1p2_svt_lp L=6e-08 W=5.85e-07
.ENDS

.SUBCKT NAND4BBXLH9R A1 A2 B1 B2 ZN VDD VSS
MM9 a2n A2 VSS VSS nm1p2_svt_lp W=200.00n L=60.00n
MM6 a1n A1 VSS VSS nm1p2_svt_lp W=200.00n L=60.00n
MM3 net031 B2 VSS VSS nm1p2_svt_lp W=200.00n L=60.00n
MM1 ZN a1n net18 VSS nm1p2_svt_lp W=200.00n L=60.00n
MM2 net039 B1 net031 VSS nm1p2_svt_lp W=200.00n L=60.00n
MMN1 net18 a2n net039 VSS nm1p2_svt_lp W=200.00n L=60.00n
MM8 a2n A2 VDD VDD pm1p2_svt_lp W=300.00n L=60.00n
MM7 a1n A1 VDD VDD pm1p2_svt_lp W=300.00n L=60.00n
MM4 ZN B2 VDD VDD pm1p2_svt_lp W=300.00n L=60.00n
MM5 ZN B1 VDD VDD pm1p2_svt_lp W=300.00n L=60.00n
MM0 ZN a2n VDD VDD pm1p2_svt_lp W=300.00n L=60.00n
MMP1 ZN a1n VDD VDD pm1p2_svt_lp W=300.00n L=60.00n
.ENDS

.SUBCKT NAND4BBX1H9R A1 A2 B1 B2 ZN VDD VSS
MM9 a2n A2 VSS VSS nm1p2_svt_lp W=200.00n L=60.00n
MM6 a1n A1 VSS VSS nm1p2_svt_lp W=200.00n L=60.00n
MM3 net031 B2 VSS VSS nm1p2_svt_lp W=290.00n L=60.00n
MM1 ZN a1n net18 VSS nm1p2_svt_lp W=290.00n L=60.00n
MM2 net039 B1 net031 VSS nm1p2_svt_lp W=290.00n L=60.00n
MMN1 net18 a2n net039 VSS nm1p2_svt_lp W=290.00n L=60.00n
MM8 a2n A2 VDD VDD pm1p2_svt_lp W=300.00n L=60.00n
MM7 a1n A1 VDD VDD pm1p2_svt_lp W=300.00n L=60.00n
MM4 ZN B2 VDD VDD pm1p2_svt_lp W=440.00n L=60.00n
MM5 ZN B1 VDD VDD pm1p2_svt_lp W=440.00n L=60.00n
MM0 ZN a2n VDD VDD pm1p2_svt_lp W=440.00n L=60.00n
MMP1 ZN a1n VDD VDD pm1p2_svt_lp W=440.00n L=60.00n
.ENDS

.SUBCKT NAND4BBX2H9R A1 A2 B1 B2 ZN VDD VSS
MM9 a2n A2 VSS VSS nm1p2_svt_lp W=200.00n L=60.00n
MM6 a1n A1 VSS VSS nm1p2_svt_lp W=200.00n L=60.00n
MM3 net031 B2 VSS VSS nm1p2_svt_lp W=430.00n L=60.00n
MM1 ZN a1n net18 VSS nm1p2_svt_lp W=430.00n L=60.00n
MM2 net039 B1 net031 VSS nm1p2_svt_lp W=430.00n L=60.00n
MMN1 net18 a2n net039 VSS nm1p2_svt_lp W=430.00n L=60.00n
MM8 a2n A2 VDD VDD pm1p2_svt_lp W=300.00n L=60.00n
MM7 a1n A1 VDD VDD pm1p2_svt_lp W=300.00n L=60.00n
MM4 ZN B2 VDD VDD pm1p2_svt_lp W=650.00n L=60.00n
MM5 ZN B1 VDD VDD pm1p2_svt_lp W=650.00n L=60.00n
MM0 ZN a2n VDD VDD pm1p2_svt_lp W=650.00n L=60.00n
MMP1 ZN a1n VDD VDD pm1p2_svt_lp W=650.00n L=60.00n
.ENDS

.SUBCKT NAND4BBX4H9R A1 A2 B1 B2 ZN VDD VSS
MM9 a2n A2 VSS VSS nm1p2_svt_lp W=350.00n L=60.00n
MM6 a1n A1 VSS VSS nm1p2_svt_lp W=350.00n L=60.00n
MM3 net031 B2 VSS VSS nm1p2_svt_lp W=860.00n L=60.00n
MM1 ZN a1n net18 VSS nm1p2_svt_lp W=860.00n L=60.00n
MM2 net039 B1 net031 VSS nm1p2_svt_lp W=860.00n L=60.00n
MMN1 net18 a2n net039 VSS nm1p2_svt_lp W=860.00n L=60.00n
MM8 a2n A2 VDD VDD pm1p2_svt_lp W=520.00n L=60.00n
MM7 a1n A1 VDD VDD pm1p2_svt_lp W=520.00n L=60.00n
MM4 ZN B2 VDD VDD pm1p2_svt_lp W=1.29u L=60.00n
MM5 ZN B1 VDD VDD pm1p2_svt_lp W=1.29u L=60.00n
MM0 ZN a2n VDD VDD pm1p2_svt_lp W=1.29u L=60.00n
MMP1 ZN a1n VDD VDD pm1p2_svt_lp W=1.29u L=60.00n
.ENDS

.SUBCKT NOR4X0P5H9R A1 A2 A3 A4 ZN VDD VSS
MM4 ZN A4 VSS VSS nm1p2_svt_lp W=200.00n L=60.00n
MM3 ZN A3 VSS VSS nm1p2_svt_lp W=200.00n L=60.00n
MM0 ZN A2 VSS VSS nm1p2_svt_lp W=200.00n L=60.00n
MMN1 ZN A1 VSS VSS nm1p2_svt_lp W=200.00n L=60.00n
MM5 net047 A4 VDD VDD pm1p2_svt_lp W=300.0n L=60.00n
MM2 net47 A3 net047 VDD pm1p2_svt_lp W=300.0n L=60.00n
MM1 ZN A1 net43 VDD pm1p2_svt_lp W=300.0n L=60.00n
MMP1 net43 A2 net47 VDD pm1p2_svt_lp W=300.0n L=60.00n
.ENDS

.SUBCKT NOR4X0P7H9R A1 A2 A3 A4 ZN VDD VSS
MM3 net13 A3 net9 VDD pm1p2_svt_lp W=320.00n L=60.00n
MM0 net17 A2 net13 VDD pm1p2_svt_lp W=320.00n L=60.00n
MM5 ZN A1 net17 VDD pm1p2_svt_lp W=320.00n L=60.00n
MM6 net9 A4 VDD VDD pm1p2_svt_lp W=320.00n L=60.00n
MM1 ZN A1 VSS VSS nm1p2_svt_lp W=180.00n L=60.00n
MM2 ZN A2 VSS VSS nm1p2_svt_lp W=180.00n L=60.00n
MM4 ZN A3 VSS VSS nm1p2_svt_lp W=180.00n L=60.00n
MM7 ZN A4 VSS VSS nm1p2_svt_lp W=180.00n L=60.00n
.ENDS

.SUBCKT NOR4X1H9R A1 A2 A3 A4 ZN VDD VSS
MM4 ZN A4 VSS VSS nm1p2_svt_lp W=290.00n L=60.00n
MM3 ZN A3 VSS VSS nm1p2_svt_lp W=290.00n L=60.00n
MM0 ZN A2 VSS VSS nm1p2_svt_lp W=290.00n L=60.00n
MMN1 ZN A1 VSS VSS nm1p2_svt_lp W=290.00n L=60.00n
MM5 net047 A4 VDD VDD pm1p2_svt_lp W=440.0n L=60.00n
MM2 net47 A3 net047 VDD pm1p2_svt_lp W=440.0n L=60.00n
MM1 ZN A1 net43 VDD pm1p2_svt_lp W=440.0n L=60.00n
MMP1 net43 A2 net47 VDD pm1p2_svt_lp W=440.0n L=60.00n
.ENDS

.SUBCKT NOR4X2H9R A1 A2 A3 A4 ZN VDD VSS
MM4 ZN A4 VSS VSS nm1p2_svt_lp W=430.00n L=60.00n
MM3 ZN A3 VSS VSS nm1p2_svt_lp W=430.00n L=60.00n
MM0 ZN A2 VSS VSS nm1p2_svt_lp W=430.00n L=60.00n
MMN1 ZN A1 VSS VSS nm1p2_svt_lp W=430.00n L=60.00n
MM5 net047 A4 VDD VDD pm1p2_svt_lp W=650.0n L=60.00n
MM2 net47 A3 net047 VDD pm1p2_svt_lp W=650.0n L=60.00n
MM1 ZN A1 net43 VDD pm1p2_svt_lp W=650.0n L=60.00n
MMP1 net43 A2 net47 VDD pm1p2_svt_lp W=650.0n L=60.00n
.ENDS

.SUBCKT NOR4X3H9R A1 A2 A3 A4 ZN VDD VSS
MM4 ZN A4 VSS VSS nm1p2_svt_lp W=650.00n L=60.00n
MM3 ZN A3 VSS VSS nm1p2_svt_lp W=650.00n L=60.00n
MM0 ZN A2 VSS VSS nm1p2_svt_lp W=650.00n L=60.00n
MMN1 ZN A1 VSS VSS nm1p2_svt_lp W=650.00n L=60.00n
MM5 net047 A4 VDD VDD pm1p2_svt_lp W=980.0n L=60.00n
MM2 net47 A3 net047 VDD pm1p2_svt_lp W=980.0n L=60.00n
MM1 ZN A1 net43 VDD pm1p2_svt_lp W=980.0n L=60.00n
MMP1 net43 A2 net47 VDD pm1p2_svt_lp W=980.0n L=60.00n
.ENDS

.SUBCKT NOR4X4H9R A1 A2 A3 A4 ZN VDD VSS
MM4 ZN A4 VSS VSS nm1p2_svt_lp W=860.00n L=60.00n
MM3 ZN A3 VSS VSS nm1p2_svt_lp W=860.00n L=60.00n
MM0 ZN A2 VSS VSS nm1p2_svt_lp W=860.00n L=60.00n
MMN1 ZN A1 VSS VSS nm1p2_svt_lp W=860.00n L=60.00n
MM5 net047 A4 VDD VDD pm1p2_svt_lp W=1.3u L=60.00n
MM2 net47 A3 net047 VDD pm1p2_svt_lp W=1.3u L=60.00n
MM1 ZN A1 net43 VDD pm1p2_svt_lp W=1.3u L=60.00n
MMP1 net43 A2 net47 VDD pm1p2_svt_lp W=1.3u L=60.00n
.ENDS

.SUBCKT NOR4X8H9R A1 A2 A3 A4 ZN VDD VSS
MM7 net033 net049 VSS VSS nm1p2_svt_lp W=680.00n L=60.00n
MM8 ZN net033 VSS VSS nm1p2_svt_lp W=1.72u L=60.00n
MM4 net049 A4 VSS VSS nm1p2_svt_lp W=270.00n L=60.00n
MM3 net049 A3 VSS VSS nm1p2_svt_lp W=270.00n L=60.00n
MM0 net049 A2 VSS VSS nm1p2_svt_lp W=270.00n L=60.00n
MMN1 net049 A1 VSS VSS nm1p2_svt_lp W=270.00n L=60.00n
MM6 net033 net049 VDD VDD pm1p2_svt_lp W=1.02u L=60.00n
MM9 ZN net033 VDD VDD pm1p2_svt_lp W=2.6u L=60.00n
MM5 net047 A4 VDD VDD pm1p2_svt_lp W=410.00n L=60.00n
MM2 net47 A3 net047 VDD pm1p2_svt_lp W=410.00n L=60.00n
MM1 net049 A1 net43 VDD pm1p2_svt_lp W=410.00n L=60.00n
MMP1 net43 A2 net47 VDD pm1p2_svt_lp W=410.00n L=60.00n
.ENDS

.SUBCKT AOI2BB1X0P5H9R A1 A2 B ZN VDD VSS
MM3 net24 A1 VSS VSS nm1p2_svt_lp W=200.00n L=60.00n
MM2 net24 A2 VSS VSS nm1p2_svt_lp W=200.00n L=60.00n
MM0 ZN B VSS VSS nm1p2_svt_lp W=200.00n L=60.00n
MMN1 ZN net24 VSS VSS nm1p2_svt_lp W=200.00n L=60.00n
MM4 net24 A1 net056 VDD pm1p2_svt_lp W=300.00n L=60.00n
MM5 net056 A2 VDD VDD pm1p2_svt_lp W=300.00n L=60.00n
MM1 ZN net24 net064 VDD pm1p2_svt_lp W=300.00n L=60.00n
MMP1 net064 B VDD VDD pm1p2_svt_lp W=300.00n L=60.00n
.ENDS

.SUBCKT AOI2BB1X1H9R A1 A2 B ZN VDD VSS
MM3 net24 A1 VSS VSS nm1p2_svt_lp W=200.00n L=60.00n
MM2 net24 A2 VSS VSS nm1p2_svt_lp W=200.00n L=60.00n
MM0 ZN B VSS VSS nm1p2_svt_lp W=290.00n L=60.00n
MMN1 ZN net24 VSS VSS nm1p2_svt_lp W=290.00n L=60.00n
MM4 net24 A1 net056 VDD pm1p2_svt_lp W=300.00n L=60.00n
MM5 net056 A2 VDD VDD pm1p2_svt_lp W=300.00n L=60.00n
MM1 ZN net24 net064 VDD pm1p2_svt_lp W=440.00n L=60.00n
MMP1 net064 B VDD VDD pm1p2_svt_lp W=440.00n L=60.00n
.ENDS

.SUBCKT AOI2BB1X2H9R A1 A2 B ZN VDD VSS
MM3 net24 A1 VSS VSS nm1p2_svt_lp W=200.00n L=60.00n
MM2 net24 A2 VSS VSS nm1p2_svt_lp W=200.00n L=60.00n
MM0 ZN B VSS VSS nm1p2_svt_lp W=430.00n L=60.00n
MMN1 ZN net24 VSS VSS nm1p2_svt_lp W=430.00n L=60.00n
MM4 net24 A1 net056 VDD pm1p2_svt_lp W=300.00n L=60.00n
MM5 net056 A2 VDD VDD pm1p2_svt_lp W=300.00n L=60.00n
MM1 ZN net24 net064 VDD pm1p2_svt_lp W=650.00n L=60.00n
MMP1 net064 B VDD VDD pm1p2_svt_lp W=650.00n L=60.00n
.ENDS

.SUBCKT AOI2BB1X4H9R A1 A2 B ZN VDD VSS
MM3 net24 A1 VSS VSS nm1p2_svt_lp W=350.00n L=60.00n
MM2 net24 A2 VSS VSS nm1p2_svt_lp W=350.00n L=60.00n
MM0 ZN B VSS VSS nm1p2_svt_lp W=720.00n L=60.00n
MMN1 ZN net24 VSS VSS nm1p2_svt_lp W=720.00n L=60.00n
MM4 net24 A1 net056 VDD pm1p2_svt_lp W=520.00n L=60.00n
MM5 net056 A2 VDD VDD pm1p2_svt_lp W=520.00n L=60.00n
MM1 ZN net24 net064 VDD pm1p2_svt_lp W=1.2u L=60.00n
MMP1 net064 B VDD VDD pm1p2_svt_lp W=1.2u L=60.00n
.ENDS

.SUBCKT AOI2BB2X0P5H9R A1 A2 B1 B2 ZN VDD VSS
MM3 net24 A1 VSS VSS nm1p2_svt_lp W=200.00n L=60.00n
MM2 net24 A2 VSS VSS nm1p2_svt_lp W=200.00n L=60.00n
MM0 ZN B1 net050 VSS nm1p2_svt_lp W=200.00n L=60.00n
MM7 net050 B2 VSS VSS nm1p2_svt_lp W=200.00n L=60.00n
MMN1 ZN net24 VSS VSS nm1p2_svt_lp W=200.00n L=60.00n
MM6 net061 B2 VDD VDD pm1p2_svt_lp W=300.00n L=60.00n
MM4 net24 A1 net074 VDD pm1p2_svt_lp W=300.00n L=60.00n
MM5 net074 A2 VDD VDD pm1p2_svt_lp W=300.00n L=60.00n
MM1 ZN net24 net061 VDD pm1p2_svt_lp W=300.00n L=60.00n
MMP1 net061 B1 VDD VDD pm1p2_svt_lp W=300.00n L=60.00n
.ENDS

.SUBCKT AOI2BB2X1H9R A1 A2 B1 B2 ZN VDD VSS
MM3 net24 A1 VSS VSS nm1p2_svt_lp W=200.00n L=60.00n
MM2 net24 A2 VSS VSS nm1p2_svt_lp W=200.00n L=60.00n
MM0 ZN B1 net050 VSS nm1p2_svt_lp W=290.00n L=60.00n
MM7 net050 B2 VSS VSS nm1p2_svt_lp W=290.00n L=60.00n
MMN1 ZN net24 VSS VSS nm1p2_svt_lp W=290.00n L=60.00n
MM6 net061 B2 VDD VDD pm1p2_svt_lp W=440.00n L=60.00n
MM4 net24 A1 net074 VDD pm1p2_svt_lp W=300.00n L=60.00n
MM5 net074 A2 VDD VDD pm1p2_svt_lp W=300.00n L=60.00n
MM1 ZN net24 net061 VDD pm1p2_svt_lp W=440.00n L=60.00n
MMP1 net061 B1 VDD VDD pm1p2_svt_lp W=440.00n L=60.00n
.ENDS

.SUBCKT AOI2BB2X2H9R A1 A2 B1 B2 ZN VDD VSS
MM3 net24 A1 VSS VSS nm1p2_svt_lp W=200.00n L=60.00n
MM2 net24 A2 VSS VSS nm1p2_svt_lp W=200.00n L=60.00n
MM0 ZN B1 net050 VSS nm1p2_svt_lp W=430.00n L=60.00n
MM7 net050 B2 VSS VSS nm1p2_svt_lp W=430.00n L=60.00n
MMN1 ZN net24 VSS VSS nm1p2_svt_lp W=430.00n L=60.00n
MM6 net061 B2 VDD VDD pm1p2_svt_lp W=650.00n L=60.00n
MM4 net24 A1 net074 VDD pm1p2_svt_lp W=300.00n L=60.00n
MM5 net074 A2 VDD VDD pm1p2_svt_lp W=300.00n L=60.00n
MM1 ZN net24 net061 VDD pm1p2_svt_lp W=650.00n L=60.00n
MMP1 net061 B1 VDD VDD pm1p2_svt_lp W=650.00n L=60.00n
.ENDS

.SUBCKT AOI2BB2X4H9R A1 A2 B1 B2 ZN VDD VSS
MM3 net24 A1 VSS VSS nm1p2_svt_lp W=350.00n L=60.00n
MM2 net24 A2 VSS VSS nm1p2_svt_lp W=350.00n L=60.00n
MM0 ZN B1 net050 VSS nm1p2_svt_lp W=860.00n L=60.00n
MM7 net050 B2 VSS VSS nm1p2_svt_lp W=860.00n L=60.00n
MMN1 ZN net24 VSS VSS nm1p2_svt_lp W=860.00n L=60.00n
MM6 net061 B2 VDD VDD pm1p2_svt_lp W=1.24u L=60.00n
MM4 net24 A1 net074 VDD pm1p2_svt_lp W=520.00n L=60.00n
MM5 net074 A2 VDD VDD pm1p2_svt_lp W=520.00n L=60.00n
MM1 ZN net24 net061 VDD pm1p2_svt_lp W=1.3u L=60.00n
MMP1 net061 B1 VDD VDD pm1p2_svt_lp W=1.24u L=60.00n
.ENDS

.SUBCKT AO211X0P5H9R A1 A2 B C Z VDD VSS
MM6 net1 B VSS VSS nm1p2_svt_lp W=200.00n L=60.00n
MM1 net1 A1 net4 VSS nm1p2_svt_lp W=200.00n L=60.00n
MM2 Z net1 VSS VSS nm1p2_svt_lp W=200.00n L=60.00n
MM4 net1 C VSS VSS nm1p2_svt_lp W=200.00n L=60.00n
MMN1 net4 A2 VSS VSS nm1p2_svt_lp W=200.00n L=60.00n
MM7 net3 A1 VDD VDD pm1p2_svt_lp W=300.00n L=60.00n
MM5 net3 A2 VDD VDD pm1p2_svt_lp W=300.00n L=60.00n
MM3 Z net1 VDD VDD pm1p2_svt_lp W=300.00n L=60.00n
MM0 net2 B net3 VDD pm1p2_svt_lp W=300.00n L=60.00n
MMP1 net1 C net2 VDD pm1p2_svt_lp W=300.00n L=60.00n
.ENDS

.SUBCKT AO211X1H9R A1 A2 B C Z VDD VSS
MM6 net1 B VSS VSS nm1p2_svt_lp W=200.00n L=60.00n
MM1 net1 A1 net4 VSS nm1p2_svt_lp W=200.00n L=60.00n
MM2 Z net1 VSS VSS nm1p2_svt_lp W=290.00n L=60.00n
MM4 net1 C VSS VSS nm1p2_svt_lp W=200.00n L=60.00n
MMN1 net4 A2 VSS VSS nm1p2_svt_lp W=200.00n L=60.00n
MM7 net3 A1 VDD VDD pm1p2_svt_lp W=300.00n L=60.00n
MM5 net3 A2 VDD VDD pm1p2_svt_lp W=300.00n L=60.00n
MM3 Z net1 VDD VDD pm1p2_svt_lp W=440.00n L=60.00n
MM0 net2 B net3 VDD pm1p2_svt_lp W=300.00n L=60.00n
MMP1 net1 C net2 VDD pm1p2_svt_lp W=300.00n L=60.00n
.ENDS

.SUBCKT AO211X2H9R A1 A2 B C Z VDD VSS
MM6 net1 B VSS VSS nm1p2_svt_lp W=200.00n L=60.00n
MM1 net1 A1 net4 VSS nm1p2_svt_lp W=200.00n L=60.00n
MM2 Z net1 VSS VSS nm1p2_svt_lp W=390.00n L=60.00n
MM4 net1 C VSS VSS nm1p2_svt_lp W=200.00n L=60.00n
MMN1 net4 A2 VSS VSS nm1p2_svt_lp W=200.00n L=60.00n
MM7 net3 A1 VDD VDD pm1p2_svt_lp W=300.00n L=60.00n
MM5 net3 A2 VDD VDD pm1p2_svt_lp W=300.00n L=60.00n
MM3 Z net1 VDD VDD pm1p2_svt_lp W=650.00n L=60.00n
MM0 net2 B net3 VDD pm1p2_svt_lp W=300.00n L=60.00n
MMP1 net1 C net2 VDD pm1p2_svt_lp W=300.00n L=60.00n
.ENDS

.SUBCKT AO211X4H9R A1 A2 B C Z VDD VSS
MM6 net1 B VSS VSS nm1p2_svt_lp W=350.00n L=60.00n
MM1 net1 A1 net4 VSS nm1p2_svt_lp W=350.00n L=60.00n
MM2 Z net1 VSS VSS nm1p2_svt_lp W=860.00n L=60.00n
MM4 net1 C VSS VSS nm1p2_svt_lp W=350.00n L=60.00n
MMN1 net4 A2 VSS VSS nm1p2_svt_lp W=350.00n L=60.00n
MM7 net3 A1 VDD VDD pm1p2_svt_lp W=520.00n L=60.00n
MM5 net3 A2 VDD VDD pm1p2_svt_lp W=520.00n L=60.00n
MM3 Z net1 VDD VDD pm1p2_svt_lp W=1.3u L=60.00n
MM0 net2 B net3 VDD pm1p2_svt_lp W=520.00n L=60.00n
MMP1 net1 C net2 VDD pm1p2_svt_lp W=520.00n L=60.00n
.ENDS

.SUBCKT AO221X0P5H9R A1 A2 B1 B2 C Z VDD VSS
MM6 N8 C VSS VSS nm1p2_svt_lp W=200.00n L=60.00n
MM9 N3 B2 VSS VSS nm1p2_svt_lp W=200.00n L=60.00n
MM1 N8 A1 N14 VSS nm1p2_svt_lp W=200.00n L=60.00n
MM2 Z N8 VSS VSS nm1p2_svt_lp W=200.00n L=60.00n
MM4 N8 B1 N3 VSS nm1p2_svt_lp W=200.00n L=60.00n
MMN1 N14 A2 VSS VSS nm1p2_svt_lp W=200.00n L=60.00n
MM8 N9 B1 N11 VDD pm1p2_svt_lp W=300.00n L=60.00n
MM7 N11 A1 VDD VDD pm1p2_svt_lp W=300.00n L=60.00n
MM5 N11 A2 VDD VDD pm1p2_svt_lp W=300.00n L=60.00n
MM3 Z N8 VDD VDD pm1p2_svt_lp W=300.00n L=60.00n
MM0 N9 B2 N11 VDD pm1p2_svt_lp W=300.00n L=60.00n
MMP1 N8 C N9 VDD pm1p2_svt_lp W=300.00n L=60.00n
.ENDS

.SUBCKT AO221X1H9R A1 A2 B1 B2 C Z VDD VSS
MM6 N8 C VSS VSS nm1p2_svt_lp W=200.00n L=60.00n
MM9 N3 B2 VSS VSS nm1p2_svt_lp W=200.00n L=60.00n
MM1 N8 A1 N14 VSS nm1p2_svt_lp W=200.00n L=60.00n
MM2 Z N8 VSS VSS nm1p2_svt_lp W=290.00n L=60.00n
MM4 N8 B1 N3 VSS nm1p2_svt_lp W=200.00n L=60.00n
MMN1 N14 A2 VSS VSS nm1p2_svt_lp W=200.00n L=60.00n
MM8 N9 B1 N11 VDD pm1p2_svt_lp W=300.00n L=60.00n
MM7 N11 A1 VDD VDD pm1p2_svt_lp W=300.00n L=60.00n
MM5 N11 A2 VDD VDD pm1p2_svt_lp W=300.00n L=60.00n
MM3 Z N8 VDD VDD pm1p2_svt_lp W=440.00n L=60.00n
MM0 N9 B2 N11 VDD pm1p2_svt_lp W=300.00n L=60.00n
MMP1 N8 C N9 VDD pm1p2_svt_lp W=300.00n L=60.00n
.ENDS

.SUBCKT AO221X2H9R A1 A2 B1 B2 C Z VDD VSS
MM6 N8 C VSS VSS nm1p2_svt_lp W=200.00n L=60.00n
MM9 N3 B2 VSS VSS nm1p2_svt_lp W=200.00n L=60.00n
MM1 N8 A1 N14 VSS nm1p2_svt_lp W=200.00n L=60.00n
MM2 Z N8 VSS VSS nm1p2_svt_lp W=430.00n L=60.00n
MM4 N8 B1 N3 VSS nm1p2_svt_lp W=200.00n L=60.00n
MMN1 N14 A2 VSS VSS nm1p2_svt_lp W=200.00n L=60.00n
MM8 N9 B1 N11 VDD pm1p2_svt_lp W=300.00n L=60.00n
MM7 N11 A1 VDD VDD pm1p2_svt_lp W=300.00n L=60.00n
MM5 N11 A2 VDD VDD pm1p2_svt_lp W=300.00n L=60.00n
MM3 Z N8 VDD VDD pm1p2_svt_lp W=650.00n L=60.00n
MM0 N9 B2 N11 VDD pm1p2_svt_lp W=300.00n L=60.00n
MMP1 N8 C N9 VDD pm1p2_svt_lp W=300.00n L=60.00n
.ENDS

.SUBCKT AO221X4H9R A1 A2 B1 B2 C Z VDD VSS
MM6 N8 C VSS VSS nm1p2_svt_lp W=350.00n L=60.00n
MM9 N3 B2 VSS VSS nm1p2_svt_lp W=350.00n L=60.00n
MM1 N8 A1 N14 VSS nm1p2_svt_lp W=350.00n L=60.00n
MM2 Z N8 VSS VSS nm1p2_svt_lp W=860.00n L=60.00n
MM4 N8 B1 N3 VSS nm1p2_svt_lp W=350.00n L=60.00n
MMN1 N14 A2 VSS VSS nm1p2_svt_lp W=350.00n L=60.00n
MM8 N9 B1 N11 VDD pm1p2_svt_lp W=520.00n L=60.00n
MM7 N11 A1 VDD VDD pm1p2_svt_lp W=520.00n L=60.00n
MM5 N11 A2 VDD VDD pm1p2_svt_lp W=520.00n L=60.00n
MM3 Z N8 VDD VDD pm1p2_svt_lp W=1.3u L=60.00n
MM0 N9 B2 N11 VDD pm1p2_svt_lp W=520.00n L=60.00n
MMP1 N8 C N9 VDD pm1p2_svt_lp W=520.00n L=60.00n
.ENDS

.SUBCKT AO222X0P5H9R A1 A2 B1 B2 C1 C2 Z VDD VSS
MM6 net3 C1 net4 VSS nm1p2_svt_lp W=200.00n L=60.00n
MM10 net4 C2 VSS VSS nm1p2_svt_lp W=200.00n L=60.00n
MM9 net5 B2 VSS VSS nm1p2_svt_lp W=200.00n L=60.00n
MM1 net3 A1 net6 VSS nm1p2_svt_lp W=200.00n L=60.00n
MM2 Z net3 VSS VSS nm1p2_svt_lp W=200.00n L=60.00n
MM4 net3 B1 net5 VSS nm1p2_svt_lp W=200.00n L=60.00n
MMN1 net6 A2 VSS VSS nm1p2_svt_lp W=200.00n L=60.00n
MM8 net2 B2 net1 VDD pm1p2_svt_lp W=300.00n L=60.00n
MM11 net3 C2 net2 VDD pm1p2_svt_lp W=300.00n L=60.00n
MM7 net1 A1 VDD VDD pm1p2_svt_lp W=300.00n L=60.00n
MM5 net1 A2 VDD VDD pm1p2_svt_lp W=300.00n L=60.00n
MM3 Z net3 VDD VDD pm1p2_svt_lp W=300.00n L=60.00n
MM0 net2 B1 net1 VDD pm1p2_svt_lp W=300.00n L=60.00n
MMP1 net3 C1 net2 VDD pm1p2_svt_lp W=300.00n L=60.00n
.ENDS

.SUBCKT AO222X1H9R A1 A2 B1 B2 C1 C2 Z VDD VSS
MM6 net3 C1 net4 VSS nm1p2_svt_lp W=200.00n L=60.00n
MM10 net4 C2 VSS VSS nm1p2_svt_lp W=200.00n L=60.00n
MM9 net5 B2 VSS VSS nm1p2_svt_lp W=200.00n L=60.00n
MM1 net3 A1 net6 VSS nm1p2_svt_lp W=200.00n L=60.00n
MM2 Z net3 VSS VSS nm1p2_svt_lp W=290.00n L=60.00n
MM4 net3 B1 net5 VSS nm1p2_svt_lp W=200.00n L=60.00n
MMN1 net6 A2 VSS VSS nm1p2_svt_lp W=200.00n L=60.00n
MM8 net2 B2 net1 VDD pm1p2_svt_lp W=300.00n L=60.00n
MM11 net3 C2 net2 VDD pm1p2_svt_lp W=300.00n L=60.00n
MM7 net1 A1 VDD VDD pm1p2_svt_lp W=300.00n L=60.00n
MM5 net1 A2 VDD VDD pm1p2_svt_lp W=300.00n L=60.00n
MM3 Z net3 VDD VDD pm1p2_svt_lp W=440.00n L=60.00n
MM0 net2 B1 net1 VDD pm1p2_svt_lp W=300.00n L=60.00n
MMP1 net3 C1 net2 VDD pm1p2_svt_lp W=300.00n L=60.00n
.ENDS

.SUBCKT AO222X2H9R A1 A2 B1 B2 C1 C2 Z VDD VSS
MM6 net3 C1 net4 VSS nm1p2_svt_lp W=200.00n L=60.00n
MM10 net4 C2 VSS VSS nm1p2_svt_lp W=200.00n L=60.00n
MM9 net5 B2 VSS VSS nm1p2_svt_lp W=200.00n L=60.00n
MM1 net3 A1 net6 VSS nm1p2_svt_lp W=200.00n L=60.00n
MM2 Z net3 VSS VSS nm1p2_svt_lp W=430.00n L=60.00n
MM4 net3 B1 net5 VSS nm1p2_svt_lp W=200.00n L=60.00n
MMN1 net6 A2 VSS VSS nm1p2_svt_lp W=200.00n L=60.00n
MM8 net2 B2 net1 VDD pm1p2_svt_lp W=300.00n L=60.00n
MM11 net3 C2 net2 VDD pm1p2_svt_lp W=300.00n L=60.00n
MM7 net1 A1 VDD VDD pm1p2_svt_lp W=300.00n L=60.00n
MM5 net1 A2 VDD VDD pm1p2_svt_lp W=300.00n L=60.00n
MM3 Z net3 VDD VDD pm1p2_svt_lp W=650.00n L=60.00n
MM0 net2 B1 net1 VDD pm1p2_svt_lp W=300.00n L=60.00n
MMP1 net3 C1 net2 VDD pm1p2_svt_lp W=300.00n L=60.00n
.ENDS

.SUBCKT AO222X4H9R A1 A2 B1 B2 C1 C2 Z VDD VSS
MM6 net3 C1 net4 VSS nm1p2_svt_lp W=350.00n L=60.00n
MM10 net4 C2 VSS VSS nm1p2_svt_lp W=350.00n L=60.00n
MM9 net5 B2 VSS VSS nm1p2_svt_lp W=350.00n L=60.00n
MM1 net3 A1 net6 VSS nm1p2_svt_lp W=350.00n L=60.00n
MM2 Z net3 VSS VSS nm1p2_svt_lp W=860.00n L=60.00n
MM4 net3 B1 net5 VSS nm1p2_svt_lp W=350.00n L=60.00n
MMN1 net6 A2 VSS VSS nm1p2_svt_lp W=350.00n L=60.00n
MM8 net2 B2 net1 VDD pm1p2_svt_lp W=520.00n L=60.00n
MM11 net3 C2 net2 VDD pm1p2_svt_lp W=520.00n L=60.00n
MM7 net1 A1 VDD VDD pm1p2_svt_lp W=520.00n L=60.00n
MM5 net1 A2 VDD VDD pm1p2_svt_lp W=520.00n L=60.00n
MM3 Z net3 VDD VDD pm1p2_svt_lp W=1.3u L=60.00n
MM0 net2 B1 net1 VDD pm1p2_svt_lp W=520.00n L=60.00n
MMP1 net3 C1 net2 VDD pm1p2_svt_lp W=520.00n L=60.00n
.ENDS

.SUBCKT AO31X0P5H9R A1 A2 A3 B Z VDD VSS
MM6 net2 B VSS VSS nm1p2_svt_lp W=200.00n L=60.00n
MM1 net2 A1 net3 VSS nm1p2_svt_lp W=200.00n L=60.00n
MM2 Z net2 VSS VSS nm1p2_svt_lp W=200.00n L=60.00n
MM9 net4 A3 VSS VSS nm1p2_svt_lp W=200.00n L=60.00n
MMN1 net3 A2 net4 VSS nm1p2_svt_lp W=200.00n L=60.00n
MM8 net1 A3 VDD VDD pm1p2_svt_lp W=300.00n L=60.00n
MM7 net1 A1 VDD VDD pm1p2_svt_lp W=300.00n L=60.00n
MM5 net1 A2 VDD VDD pm1p2_svt_lp W=300.00n L=60.00n
MM3 Z net2 VDD VDD pm1p2_svt_lp W=300.00n L=60.00n
MM0 net2 B net1 VDD pm1p2_svt_lp W=300.00n L=60.00n
.ENDS

.SUBCKT AO31X1H9R A1 A2 A3 B Z VDD VSS
MM6 net2 B VSS VSS nm1p2_svt_lp W=200.00n L=60.00n
MM1 net2 A1 net3 VSS nm1p2_svt_lp W=200.00n L=60.00n
MM2 Z net2 VSS VSS nm1p2_svt_lp W=290.00n L=60.00n
MM9 net4 A3 VSS VSS nm1p2_svt_lp W=200.00n L=60.00n
MMN1 net3 A2 net4 VSS nm1p2_svt_lp W=200.00n L=60.00n
MM8 net1 A3 VDD VDD pm1p2_svt_lp W=300.00n L=60.00n
MM7 net1 A1 VDD VDD pm1p2_svt_lp W=300.00n L=60.00n
MM5 net1 A2 VDD VDD pm1p2_svt_lp W=300.00n L=60.00n
MM3 Z net2 VDD VDD pm1p2_svt_lp W=440.00n L=60.00n
MM0 net2 B net1 VDD pm1p2_svt_lp W=300.00n L=60.00n
.ENDS

.SUBCKT AO31X2H9R A1 A2 A3 B Z VDD VSS
MM6 net2 B VSS VSS nm1p2_svt_lp W=200.00n L=60.00n
MM1 net2 A1 net3 VSS nm1p2_svt_lp W=200.00n L=60.00n
MM2 Z net2 VSS VSS nm1p2_svt_lp W=430.00n L=60.00n
MM9 net4 A3 VSS VSS nm1p2_svt_lp W=200.00n L=60.00n
MMN1 net3 A2 net4 VSS nm1p2_svt_lp W=200.00n L=60.00n
MM8 net1 A3 VDD VDD pm1p2_svt_lp W=300.00n L=60.00n
MM7 net1 A1 VDD VDD pm1p2_svt_lp W=300.00n L=60.00n
MM5 net1 A2 VDD VDD pm1p2_svt_lp W=300.00n L=60.00n
MM3 Z net2 VDD VDD pm1p2_svt_lp W=650.00n L=60.00n
MM0 net2 B net1 VDD pm1p2_svt_lp W=300.00n L=60.00n
.ENDS

.SUBCKT AO31X4H9R A1 A2 A3 B Z VDD VSS
MM6 net2 B VSS VSS nm1p2_svt_lp W=350.00n L=60.00n
MM1 net2 A1 net3 VSS nm1p2_svt_lp W=350.00n L=60.00n
MM2 Z net2 VSS VSS nm1p2_svt_lp W=860.00n L=60.00n
MM9 net4 A3 VSS VSS nm1p2_svt_lp W=350.00n L=60.00n
MMN1 net3 A2 net4 VSS nm1p2_svt_lp W=350.00n L=60.00n
MM8 net1 A3 VDD VDD pm1p2_svt_lp W=520.00n L=60.00n
MM7 net1 A1 VDD VDD pm1p2_svt_lp W=520.00n L=60.00n
MM5 net1 A2 VDD VDD pm1p2_svt_lp W=520.00n L=60.00n
MM3 Z net2 VDD VDD pm1p2_svt_lp W=1.3u L=60.00n
MM0 net2 B net1 VDD pm1p2_svt_lp W=520.00n L=60.00n
.ENDS

.SUBCKT AOI33X0P5H9R A1 A2 A3 B1 B2 B3 ZN VDD VSS
MM12 net_69 B3 VSS VSS nm1p2_svt_lp W=200.00n L=60.00n
MM6 ZN B1 net5 VSS nm1p2_svt_lp W=200.00n L=60.00n
MM1 ZN A1 net3 VSS nm1p2_svt_lp W=200.00n L=60.00n
MM9 net4 A3 VSS VSS nm1p2_svt_lp W=200.00n L=60.00n
MM11 net5 B2 net_69 VSS nm1p2_svt_lp W=200.00n L=60.00n
MMN1 net3 A2 net4 VSS nm1p2_svt_lp W=200.00n L=60.00n
MM8 net1 A3 VDD VDD pm1p2_svt_lp W=300.00n L=60.00n
MM10 ZN B2 net1 VDD pm1p2_svt_lp W=300.00n L=60.00n
MM7 net1 A1 VDD VDD pm1p2_svt_lp W=300.00n L=60.00n
MM5 net1 A2 VDD VDD pm1p2_svt_lp W=300.00n L=60.00n
MM13 ZN B3 net1 VDD pm1p2_svt_lp W=300.00n L=60.00n
MM0 ZN B1 net1 VDD pm1p2_svt_lp W=300.00n L=60.00n
.ENDS

.SUBCKT AOI33X1H9R A1 A2 A3 B1 B2 B3 ZN VDD VSS
MM12 net_69 B3 VSS VSS nm1p2_svt_lp W=290.00n L=60.00n
MM6 ZN B1 net5 VSS nm1p2_svt_lp W=290.00n L=60.00n
MM1 ZN A1 net3 VSS nm1p2_svt_lp W=290.00n L=60.00n
MM9 net4 A3 VSS VSS nm1p2_svt_lp W=290.00n L=60.00n
MM11 net5 B2 net_69 VSS nm1p2_svt_lp W=290.00n L=60.00n
MMN1 net3 A2 net4 VSS nm1p2_svt_lp W=290.00n L=60.00n
MM8 net1 A3 VDD VDD pm1p2_svt_lp W=440.00n L=60.00n
MM10 ZN B2 net1 VDD pm1p2_svt_lp W=440.00n L=60.00n
MM7 net1 A1 VDD VDD pm1p2_svt_lp W=440.00n L=60.00n
MM5 net1 A2 VDD VDD pm1p2_svt_lp W=440.00n L=60.00n
MM13 ZN B3 net1 VDD pm1p2_svt_lp W=440.00n L=60.00n
MM0 ZN B1 net1 VDD pm1p2_svt_lp W=440.00n L=60.00n
.ENDS

.SUBCKT AOI33X2H9R A1 A2 A3 B1 B2 B3 ZN VDD VSS
MM12 net_69 B3 VSS VSS nm1p2_svt_lp W=430.00n L=60.00n
MM6 ZN B1 net5 VSS nm1p2_svt_lp W=430.00n L=60.00n
MM1 ZN A1 net3 VSS nm1p2_svt_lp W=430.00n L=60.00n
MM9 net4 A3 VSS VSS nm1p2_svt_lp W=430.00n L=60.00n
MM11 net5 B2 net_69 VSS nm1p2_svt_lp W=430.00n L=60.00n
MMN1 net3 A2 net4 VSS nm1p2_svt_lp W=430.00n L=60.00n
MM8 net1 A3 VDD VDD pm1p2_svt_lp W=650.00n L=60.00n
MM10 ZN B2 net1 VDD pm1p2_svt_lp W=650.00n L=60.00n
MM7 net1 A1 VDD VDD pm1p2_svt_lp W=650.00n L=60.00n
MM5 net1 A2 VDD VDD pm1p2_svt_lp W=650.00n L=60.00n
MM13 ZN B3 net1 VDD pm1p2_svt_lp W=650.00n L=60.00n
MM0 ZN B1 net1 VDD pm1p2_svt_lp W=650.00n L=60.00n
.ENDS

.SUBCKT AOI33X4H9R A1 A2 A3 B1 B2 B3 ZN VDD VSS
MM14 net_068 net2 VSS VSS nm1p2_svt_lp W=350.00n L=60.00n
MM12 net_69 B3 VSS VSS nm1p2_svt_lp W=200.00n L=60.00n
MM6 net2 B1 net5 VSS nm1p2_svt_lp W=200.00n L=60.00n
MM1 net2 A1 net3 VSS nm1p2_svt_lp W=200.00n L=60.00n
MM2 ZN net_068 VSS VSS nm1p2_svt_lp W=860.00n L=60.00n
MM9 net4 A3 VSS VSS nm1p2_svt_lp W=200.00n L=60.00n
MM11 net5 B2 net_69 VSS nm1p2_svt_lp W=200.00n L=60.00n
MMN1 net3 A2 net4 VSS nm1p2_svt_lp W=200.00n L=60.00n
MM15 net_068 net2 VDD VDD pm1p2_svt_lp W=530.00n L=60.00n
MM8 net1 A3 VDD VDD pm1p2_svt_lp W=300.00n L=60.00n
MM10 net2 B2 net1 VDD pm1p2_svt_lp W=300.00n L=60.00n
MM7 net1 A1 VDD VDD pm1p2_svt_lp W=300.00n L=60.00n
MM5 net1 A2 VDD VDD pm1p2_svt_lp W=300.00n L=60.00n
MM3 ZN net_068 VDD VDD pm1p2_svt_lp W=1.3u L=60.00n
MM13 net2 B3 net1 VDD pm1p2_svt_lp W=300.00n L=60.00n
MM0 net2 B1 net1 VDD pm1p2_svt_lp W=300.00n L=60.00n
.ENDS

.SUBCKT AOA211X0P5H9R A1 A2 B C Z VDD VSS
MMN1 net4 A2 VSS VSS nm1p2_svt_lp W=180.00n L=60.00n
MM4 net_34 B VSS VSS nm1p2_svt_lp W=180.00n L=60.00n
MM2 Z net_38 VSS VSS nm1p2_svt_lp W=200.00n L=60.00n
MM1 net_34 A1 net4 VSS nm1p2_svt_lp W=180.00n L=60.00n
MM6 net_38 C net_34 VSS nm1p2_svt_lp W=180.00n L=60.00n
MMP1 net_38 C VDD VDD pm1p2_svt_lp W=200.00n L=60.00n
MM0 net_38 B net3 VDD pm1p2_svt_lp W=200.00n L=60.00n
MM3 Z net_38 VDD VDD pm1p2_svt_lp W=250.00n L=60.00n
MM5 net3 A2 VDD VDD pm1p2_svt_lp W=200.00n L=60.00n
MM7 net3 A1 VDD VDD pm1p2_svt_lp W=200.00n L=60.00n
.ENDS

.SUBCKT AOA211X1H9R A1 A2 B C Z VDD VSS
MM0 net_42 B net3 VDD pm1p2_svt_lp W=200.00n L=60.00n
MM7 net3 A1 VDD VDD pm1p2_svt_lp W=200.00n L=60.00n
MM5 net3 A2 VDD VDD pm1p2_svt_lp W=200.00n L=60.00n
MMP1 net_42 C VDD VDD pm1p2_svt_lp W=200.00n L=60.00n
MM3 Z net_42 VDD VDD pm1p2_svt_lp W=440.00n L=60.00n
MM1 net_26 A1 net4 VSS nm1p2_svt_lp W=180.00n L=60.00n
MMN1 net4 A2 VSS VSS nm1p2_svt_lp W=180.00n L=60.00n
MM4 net_26 B VSS VSS nm1p2_svt_lp W=180.00n L=60.00n
MM2 Z net_42 VSS VSS nm1p2_svt_lp W=350.00n L=60.00n
MM6 net_42 C net_26 VSS nm1p2_svt_lp W=180.00n L=60.00n
.ENDS

.SUBCKT AOA211X2H9R A1 A2 B C Z VDD VSS
MM0 net_42 B net3 VDD pm1p2_svt_lp W=220.00n L=60.00n
MM7 net3 A1 VDD VDD pm1p2_svt_lp W=220.00n L=60.00n
MM5 net3 A2 VDD VDD pm1p2_svt_lp W=220.00n L=60.00n
MMP1 net_42 C VDD VDD pm1p2_svt_lp W=220.00n L=60.00n
MM3 Z net_42 VDD VDD pm1p2_svt_lp W=540.00n L=60.00n
MM1 net_26 A1 net4 VSS nm1p2_svt_lp W=180.00n L=60.00n
MMN1 net4 A2 VSS VSS nm1p2_svt_lp W=180.00n L=60.00n
MM4 net_26 B VSS VSS nm1p2_svt_lp W=180.00n L=60.00n
MM2 Z net_42 VSS VSS nm1p2_svt_lp W=430.00n L=60.00n
MM6 net_42 C net_26 VSS nm1p2_svt_lp W=180.00n L=60.00n
.ENDS

.SUBCKT AOA211X4H9R A1 A2 B C Z VDD VSS
MM0 net_42 B net3 VDD pm1p2_svt_lp W=440.00n L=60.00n
MM7 net3 A1 VDD VDD pm1p2_svt_lp W=440.00n L=60.00n
MM5 net3 A2 VDD VDD pm1p2_svt_lp W=440.00n L=60.00n
MMP1 net_42 C VDD VDD pm1p2_svt_lp W=440.00n L=60.00n
MM3 Z net_42 VDD VDD pm1p2_svt_lp W=1.08u L=60.00n
MM1 net_26 A1 net4 VSS nm1p2_svt_lp W=350.00n L=60.00n
MMN1 net4 A2 VSS VSS nm1p2_svt_lp W=350.00n L=60.00n
MM4 net_26 B VSS VSS nm1p2_svt_lp W=350.00n L=60.00n
MM2 Z net_42 VSS VSS nm1p2_svt_lp W=860.00n L=60.00n
MM6 net_42 C net_26 VSS nm1p2_svt_lp W=350.00n L=60.00n
.ENDS

.SUBCKT AOAI211X0P5H9R A1 A2 B C ZN VDD VSS
MM7 net3 A1 VDD VDD pm1p2_svt_lp W=250.00n L=60.00n
MM5 net3 A2 VDD VDD pm1p2_svt_lp W=250.00n L=60.00n
MM0 ZN B net3 VDD pm1p2_svt_lp W=250.00n L=60.00n
MMP1 ZN C VDD VDD pm1p2_svt_lp W=250.00n L=60.00n
MM6 ZN C net_26 VSS nm1p2_svt_lp W=200.00n L=60.00n
MM1 net_26 A1 net4 VSS nm1p2_svt_lp W=200.00n L=60.00n
MM4 net_26 B VSS VSS nm1p2_svt_lp W=200.00n L=60.00n
MMN1 net4 A2 VSS VSS nm1p2_svt_lp W=200.00n L=60.00n
.ENDS

.SUBCKT AOAI211X1H9R A1 A2 B C ZN VDD VSS
MMN1 net4 A2 VSS VSS nm1p2_svt_lp W=350.00n L=60.00n
MM4 net_14 B VSS VSS nm1p2_svt_lp W=350.00n L=60.00n
MM1 net_14 A1 net4 VSS nm1p2_svt_lp W=350.00n L=60.00n
MM6 ZN C net_14 VSS nm1p2_svt_lp W=350.00n L=60.00n
MMP1 ZN C VDD VDD pm1p2_svt_lp W=440.00n L=60.00n
MM0 ZN B net3 VDD pm1p2_svt_lp W=440.00n L=60.00n
MM5 net3 A2 VDD VDD pm1p2_svt_lp W=440.00n L=60.00n
MM7 net3 A1 VDD VDD pm1p2_svt_lp W=440.00n L=60.00n
.ENDS

.SUBCKT AOAI211X2H9R A1 A2 B C ZN VDD VSS
MMN1 net4 A2 VSS VSS nm1p2_svt_lp W=430.00n L=60.00n
MM4 net_14 B VSS VSS nm1p2_svt_lp W=430.00n L=60.00n
MM1 net_14 A1 net4 VSS nm1p2_svt_lp W=430.00n L=60.00n
MM6 ZN C net_14 VSS nm1p2_svt_lp W=430.00n L=60.00n
MMP1 ZN C VDD VDD pm1p2_svt_lp W=540.00n L=60.00n
MM0 ZN B net3 VDD pm1p2_svt_lp W=540.00n L=60.00n
MM5 net3 A2 VDD VDD pm1p2_svt_lp W=540.00n L=60.00n
MM7 net3 A1 VDD VDD pm1p2_svt_lp W=540.00n L=60.00n
.ENDS

.SUBCKT AOAI211X4H9R A1 A2 B C ZN VDD VSS
MMN1 net4 A2 VSS VSS nm1p2_svt_lp W=860.00n L=60.00n
MM4 net_14 B VSS VSS nm1p2_svt_lp W=860.00n L=60.00n
MM1 net_14 A1 net4 VSS nm1p2_svt_lp W=860.00n L=60.00n
MM6 ZN C net_14 VSS nm1p2_svt_lp W=860.00n L=60.00n
MMP1 ZN C VDD VDD pm1p2_svt_lp W=1.08u L=60.00n
MM0 ZN B net3 VDD pm1p2_svt_lp W=1.08u L=60.00n
MM5 net3 A2 VDD VDD pm1p2_svt_lp W=1.08u L=60.00n
MM7 net3 A1 VDD VDD pm1p2_svt_lp W=1.08u L=60.00n
.ENDS

.SUBCKT MAOI222X0P5H9R A B C ZN VDD VSS
MM6 ZN C net4 VSS nm1p2_svt_lp W=200.00n L=60.00n
MM10 net4 B VSS VSS nm1p2_svt_lp W=200.00n L=60.00n
MM9 net5 C VSS VSS nm1p2_svt_lp W=200.00n L=60.00n
MM1 ZN A net6 VSS nm1p2_svt_lp W=200.00n L=60.00n
MM4 ZN A net5 VSS nm1p2_svt_lp W=200.00n L=60.00n
MMN1 net6 B VSS VSS nm1p2_svt_lp W=200.00n L=60.00n
MM8 net2 C net1 VDD pm1p2_svt_lp W=300.0n L=60.00n
MM11 ZN B net2 VDD pm1p2_svt_lp W=300.0n L=60.00n
MM7 net1 B VDD VDD pm1p2_svt_lp W=300.0n L=60.00n
MM5 net1 C VDD VDD pm1p2_svt_lp W=300.0n L=60.00n
MM0 net2 A net1 VDD pm1p2_svt_lp W=300.0n L=60.00n
MMP1 ZN A net2 VDD pm1p2_svt_lp W=300.0n L=60.00n
.ENDS

.SUBCKT MAOI222X1H9R A B C ZN VDD VSS
MM6 ZN C net4 VSS nm1p2_svt_lp W=290.00n L=60.00n
MM10 net4 B VSS VSS nm1p2_svt_lp W=290.00n L=60.00n
MM9 net5 C VSS VSS nm1p2_svt_lp W=290.00n L=60.00n
MM1 ZN A net6 VSS nm1p2_svt_lp W=290.00n L=60.00n
MM4 ZN A net5 VSS nm1p2_svt_lp W=290.00n L=60.00n
MMN1 net6 B VSS VSS nm1p2_svt_lp W=290.00n L=60.00n
MM8 net2 C net1 VDD pm1p2_svt_lp W=440.0n L=60.00n
MM11 ZN B net2 VDD pm1p2_svt_lp W=440.0n L=60.00n
MM7 net1 B VDD VDD pm1p2_svt_lp W=440.0n L=60.00n
MM5 net1 C VDD VDD pm1p2_svt_lp W=440.0n L=60.00n
MM0 net2 A net1 VDD pm1p2_svt_lp W=440.0n L=60.00n
MMP1 ZN A net2 VDD pm1p2_svt_lp W=440.0n L=60.00n
.ENDS

.SUBCKT MAOI222X2H9R A B C ZN VDD VSS
MM6 ZN C net4 VSS nm1p2_svt_lp W=430.00n L=60.00n
MM10 net4 B VSS VSS nm1p2_svt_lp W=430.00n L=60.00n
MM9 net5 C VSS VSS nm1p2_svt_lp W=430.00n L=60.00n
MM1 ZN A net6 VSS nm1p2_svt_lp W=430.00n L=60.00n
MM4 ZN A net5 VSS nm1p2_svt_lp W=430.00n L=60.00n
MMN1 net6 B VSS VSS nm1p2_svt_lp W=430.00n L=60.00n
MM8 net2 C net1 VDD pm1p2_svt_lp W=650.0n L=60.00n
MM11 ZN B net2 VDD pm1p2_svt_lp W=650.0n L=60.00n
MM7 net1 B VDD VDD pm1p2_svt_lp W=650.0n L=60.00n
MM5 net1 C VDD VDD pm1p2_svt_lp W=650.0n L=60.00n
MM0 net2 A net1 VDD pm1p2_svt_lp W=650.0n L=60.00n
MMP1 ZN A net2 VDD pm1p2_svt_lp W=650.0n L=60.00n
.ENDS

.SUBCKT MAOI222X4H9R A B C ZN VDD VSS
MM6 ZN B net4 VSS nm1p2_svt_lp W=860.00n L=60.00n
MM10 net4 C VSS VSS nm1p2_svt_lp W=860.00n L=60.00n
MM9 net5 C VSS VSS nm1p2_svt_lp W=860.00n L=60.00n
MM1 ZN A net6 VSS nm1p2_svt_lp W=860.00n L=60.00n
MM4 ZN A net5 VSS nm1p2_svt_lp W=860.00n L=60.00n
MMN1 net6 B VSS VSS nm1p2_svt_lp W=860.00n L=60.00n
MM8 net2 C net1 VDD pm1p2_svt_lp W=1.3u L=60.00n
MM11 ZN B net2 VDD pm1p2_svt_lp W=1.3u L=60.00n
MM7 net1 B VDD VDD pm1p2_svt_lp W=1.3u L=60.00n
MM5 net1 C VDD VDD pm1p2_svt_lp W=1.3u L=60.00n
MM0 net2 A net1 VDD pm1p2_svt_lp W=1.28u L=60.00n
MMP1 ZN A net2 VDD pm1p2_svt_lp W=1.3u L=60.00n
.ENDS

.SUBCKT OAI2BB1X0P5H9R A1 A2 B ZN VDD VSS
MM2 ZN net038 net030 VSS nm1p2_svt_lp W=200.00n L=60.00n
MM3 net030 B VSS VSS nm1p2_svt_lp W=200.00n L=60.00n
MM1 net038 A1 net18 VSS nm1p2_svt_lp W=200.00n L=60.00n
MMN1 net18 A2 VSS VSS nm1p2_svt_lp W=200.00n L=60.00n
MM4 ZN B VDD VDD pm1p2_svt_lp W=300.00n L=60.00n
MM5 ZN net038 VDD VDD pm1p2_svt_lp W=300.00n L=60.00n
MM0 net038 A2 VDD VDD pm1p2_svt_lp W=300.00n L=60.00n
MMP1 net038 A1 VDD VDD pm1p2_svt_lp W=300.00n L=60.00n
.ENDS

.SUBCKT OAI2BB1X1H9R A1 A2 B ZN VDD VSS
MM2 ZN net038 net030 VSS nm1p2_svt_lp W=290.00n L=60.00n
MM3 net030 B VSS VSS nm1p2_svt_lp W=290.00n L=60.00n
MM1 net038 A1 net18 VSS nm1p2_svt_lp W=200.00n L=60.00n
MMN1 net18 A2 VSS VSS nm1p2_svt_lp W=200.00n L=60.00n
MM4 ZN B VDD VDD pm1p2_svt_lp W=440.00n L=60.00n
MM5 ZN net038 VDD VDD pm1p2_svt_lp W=440.00n L=60.00n
MM0 net038 A2 VDD VDD pm1p2_svt_lp W=300.00n L=60.00n
MMP1 net038 A1 VDD VDD pm1p2_svt_lp W=300.00n L=60.00n
.ENDS

.SUBCKT OAI2BB1X2H9R A1 A2 B ZN VDD VSS
MM2 ZN net038 net030 VSS nm1p2_svt_lp W=430.00n L=60.00n
MM3 net030 B VSS VSS nm1p2_svt_lp W=430.00n L=60.00n
MM1 net038 A1 net18 VSS nm1p2_svt_lp W=200.00n L=60.00n
MMN1 net18 A2 VSS VSS nm1p2_svt_lp W=200.00n L=60.00n
MM4 ZN B VDD VDD pm1p2_svt_lp W=650.00n L=60.00n
MM5 ZN net038 VDD VDD pm1p2_svt_lp W=650.00n L=60.00n
MM0 net038 A2 VDD VDD pm1p2_svt_lp W=300.00n L=60.00n
MMP1 net038 A1 VDD VDD pm1p2_svt_lp W=300.00n L=60.00n
.ENDS

.SUBCKT OAI2BB1X4H9R A1 A2 B ZN VDD VSS
MM2 ZN net038 net030 VSS nm1p2_svt_lp W=860.00n L=60.00n
MM3 net030 B VSS VSS nm1p2_svt_lp W=860.00n L=60.00n
MM1 net038 A1 net18 VSS nm1p2_svt_lp W=350.00n L=60.00n
MMN1 net18 A2 VSS VSS nm1p2_svt_lp W=350.00n L=60.00n
MM4 ZN B VDD VDD pm1p2_svt_lp W=1.3u L=60.00n
MM5 ZN net038 VDD VDD pm1p2_svt_lp W=1.3u L=60.00n
MM0 net038 A2 VDD VDD pm1p2_svt_lp W=520.00n L=60.00n
MMP1 net038 A1 VDD VDD pm1p2_svt_lp W=520.00n L=60.00n
.ENDS

.SUBCKT OAI2BB2X0P5H9R A1 A2 B1 B2 ZN VDD VSS
MM6 net030 B2 VSS VSS nm1p2_svt_lp W=200.00n L=60.00n
MM2 ZN net038 net030 VSS nm1p2_svt_lp W=200.00n L=60.00n
MM3 net030 B1 VSS VSS nm1p2_svt_lp W=200.00n L=60.00n
MM1 net038 A1 net18 VSS nm1p2_svt_lp W=200.00n L=60.00n
MMN1 net18 A2 VSS VSS nm1p2_svt_lp W=200.00n L=60.00n
MM4 ZN B1 net063 VDD pm1p2_svt_lp W=300.00n L=60.00n
MM5 ZN net038 VDD VDD pm1p2_svt_lp W=300.00n L=60.00n
MM7 net063 B2 VDD VDD pm1p2_svt_lp W=300.00n L=60.00n
MM0 net038 A2 VDD VDD pm1p2_svt_lp W=300.00n L=60.00n
MMP1 net038 A1 VDD VDD pm1p2_svt_lp W=300.00n L=60.00n
.ENDS

.SUBCKT OAI2BB2X1H9R A1 A2 B1 B2 ZN VDD VSS
MM6 net030 B2 VSS VSS nm1p2_svt_lp W=290.00n L=60.00n
MM2 ZN net038 net030 VSS nm1p2_svt_lp W=290.00n L=60.00n
MM3 net030 B1 VSS VSS nm1p2_svt_lp W=290.00n L=60.00n
MM1 net038 A1 net18 VSS nm1p2_svt_lp W=200.00n L=60.00n
MMN1 net18 A2 VSS VSS nm1p2_svt_lp W=200.00n L=60.00n
MM4 ZN B1 net063 VDD pm1p2_svt_lp W=440.00n L=60.00n
MM5 ZN net038 VDD VDD pm1p2_svt_lp W=440.00n L=60.00n
MM7 net063 B2 VDD VDD pm1p2_svt_lp W=440.00n L=60.00n
MM0 net038 A2 VDD VDD pm1p2_svt_lp W=300.00n L=60.00n
MMP1 net038 A1 VDD VDD pm1p2_svt_lp W=300.00n L=60.00n
.ENDS

.SUBCKT OAI2BB2X2H9R A1 A2 B1 B2 ZN VDD VSS
MM6 net030 B2 VSS VSS nm1p2_svt_lp W=430.00n L=60.00n
MM2 ZN net038 net030 VSS nm1p2_svt_lp W=430.00n L=60.00n
MM3 net030 B1 VSS VSS nm1p2_svt_lp W=430.00n L=60.00n
MM1 net038 A1 net18 VSS nm1p2_svt_lp W=200.00n L=60.00n
MMN1 net18 A2 VSS VSS nm1p2_svt_lp W=200.00n L=60.00n
MM4 ZN B1 net063 VDD pm1p2_svt_lp W=650.00n L=60.00n
MM5 ZN net038 VDD VDD pm1p2_svt_lp W=650.00n L=60.00n
MM7 net063 B2 VDD VDD pm1p2_svt_lp W=650.00n L=60.00n
MM0 net038 A2 VDD VDD pm1p2_svt_lp W=300.00n L=60.00n
MMP1 net038 A1 VDD VDD pm1p2_svt_lp W=300.00n L=60.00n
.ENDS

.SUBCKT OAI2BB2X4H9R A1 A2 B1 B2 ZN VDD VSS
MM6 net030 B2 VSS VSS nm1p2_svt_lp W=860.00n L=60.00n
MM2 ZN net038 net030 VSS nm1p2_svt_lp W=860.00n L=60.00n
MM3 net030 B1 VSS VSS nm1p2_svt_lp W=860.00n L=60.00n
MM1 net038 A1 net18 VSS nm1p2_svt_lp W=350.00n L=60.00n
MMN1 net18 A2 VSS VSS nm1p2_svt_lp W=350.00n L=60.00n
MM4 ZN B1 net063 VDD pm1p2_svt_lp W=1.3u L=60.00n
MM5 ZN net038 VDD VDD pm1p2_svt_lp W=1.3u L=60.00n
MM7 net063 B2 VDD VDD pm1p2_svt_lp W=1.3u L=60.00n
MM0 net038 A2 VDD VDD pm1p2_svt_lp W=520.00n L=60.00n
MMP1 net038 A1 VDD VDD pm1p2_svt_lp W=520.00n L=60.00n
.ENDS

.SUBCKT OA221X0P5H9R A1 A2 B1 B2 C Z VDD VSS
MM9 net18 B2 net030 VSS nm1p2_svt_lp W=200.00n L=60.00n
MM7 Z net064 VSS VSS nm1p2_svt_lp W=200.00n L=60.00n
MM2 net18 B1 net030 VSS nm1p2_svt_lp W=200.00n L=60.00n
MM3 net030 C VSS VSS nm1p2_svt_lp W=200.00n L=60.00n
MM1 net064 A1 net18 VSS nm1p2_svt_lp W=200.00n L=60.00n
MMN1 net064 A2 net18 VSS nm1p2_svt_lp W=200.00n L=60.00n
MM8 net071 B2 VDD VDD pm1p2_svt_lp W=300.00n L=60.00n
MM6 Z net064 VDD VDD pm1p2_svt_lp W=300.00n L=60.00n
MM4 net064 B1 net071 VDD pm1p2_svt_lp W=300.00n L=60.00n
MM5 net064 C VDD VDD pm1p2_svt_lp W=300.00n L=60.00n
MM0 net067 A2 VDD VDD pm1p2_svt_lp W=300.00n L=60.00n
MMP1 net064 A1 net067 VDD pm1p2_svt_lp W=300.00n L=60.00n
.ENDS

.SUBCKT OA221X1H9R A1 A2 B1 B2 C Z VDD VSS
MM9 net18 B2 net030 VSS nm1p2_svt_lp W=200.00n L=60.00n
MM7 Z net064 VSS VSS nm1p2_svt_lp W=290.00n L=60.00n
MM2 net18 B1 net030 VSS nm1p2_svt_lp W=200.00n L=60.00n
MM3 net030 C VSS VSS nm1p2_svt_lp W=200.00n L=60.00n
MM1 net064 A1 net18 VSS nm1p2_svt_lp W=200.00n L=60.00n
MMN1 net064 A2 net18 VSS nm1p2_svt_lp W=200.00n L=60.00n
MM8 net071 B2 VDD VDD pm1p2_svt_lp W=300.00n L=60.00n
MM6 Z net064 VDD VDD pm1p2_svt_lp W=440.00n L=60.00n
MM4 net064 B1 net071 VDD pm1p2_svt_lp W=300.00n L=60.00n
MM5 net064 C VDD VDD pm1p2_svt_lp W=300.00n L=60.00n
MM0 net067 A2 VDD VDD pm1p2_svt_lp W=300.00n L=60.00n
MMP1 net064 A1 net067 VDD pm1p2_svt_lp W=300.00n L=60.00n
.ENDS

.SUBCKT OA221X2H9R A1 A2 B1 B2 C Z VDD VSS
MM9 net18 B2 net030 VSS nm1p2_svt_lp W=200.00n L=60.00n
MM7 Z net064 VSS VSS nm1p2_svt_lp W=430.00n L=60.00n
MM2 net18 B1 net030 VSS nm1p2_svt_lp W=200.00n L=60.00n
MM3 net030 C VSS VSS nm1p2_svt_lp W=200.00n L=60.00n
MM1 net064 A1 net18 VSS nm1p2_svt_lp W=200.00n L=60.00n
MMN1 net064 A2 net18 VSS nm1p2_svt_lp W=200.00n L=60.00n
MM8 net071 B2 VDD VDD pm1p2_svt_lp W=300.00n L=60.00n
MM6 Z net064 VDD VDD pm1p2_svt_lp W=650.00n L=60.00n
MM4 net064 B1 net071 VDD pm1p2_svt_lp W=300.00n L=60.00n
MM5 net064 C VDD VDD pm1p2_svt_lp W=300.00n L=60.00n
MM0 net067 A2 VDD VDD pm1p2_svt_lp W=300.00n L=60.00n
MMP1 net064 A1 net067 VDD pm1p2_svt_lp W=300.00n L=60.00n
.ENDS

.SUBCKT OA221X4H9R A1 A2 B1 B2 C Z VDD VSS
MM9 net18 B2 net030 VSS nm1p2_svt_lp W=350.00n L=60.00n
MM7 Z net064 VSS VSS nm1p2_svt_lp W=860.00n L=60.00n
MM2 net18 B1 net030 VSS nm1p2_svt_lp W=350.00n L=60.00n
MM3 net030 C VSS VSS nm1p2_svt_lp W=350.00n L=60.00n
MM1 net064 A1 net18 VSS nm1p2_svt_lp W=350.00n L=60.00n
MMN1 net064 A2 net18 VSS nm1p2_svt_lp W=350.00n L=60.00n
MM8 net071 B2 VDD VDD pm1p2_svt_lp W=520.00n L=60.00n
MM6 Z net064 VDD VDD pm1p2_svt_lp W=1.3u L=60.00n
MM4 net064 B1 net071 VDD pm1p2_svt_lp W=520.00n L=60.00n
MM5 net064 C VDD VDD pm1p2_svt_lp W=520.00n L=60.00n
MM0 net067 A2 VDD VDD pm1p2_svt_lp W=520.00n L=60.00n
MMP1 net064 A1 net067 VDD pm1p2_svt_lp W=520.00n L=60.00n
.ENDS

.SUBCKT OA222X0P5H9R A1 A2 B1 B2 C1 C2 Z VDD VSS
MM12 net030 B2 VSS VSS nm1p2_svt_lp W=200.00n L=60.00n
MM9 net18 C2 net030 VSS nm1p2_svt_lp W=200.00n L=60.00n
MM7 Z net064 VSS VSS nm1p2_svt_lp W=200.00n L=60.00n
MM2 net18 C1 net030 VSS nm1p2_svt_lp W=200.00n L=60.00n
MM3 net030 B1 VSS VSS nm1p2_svt_lp W=200.00n L=60.00n
MM1 net064 A1 net18 VSS nm1p2_svt_lp W=200.00n L=60.00n
MMN1 net064 A2 net18 VSS nm1p2_svt_lp W=200.00n L=60.00n
MM8 net071 B2 VDD VDD pm1p2_svt_lp W=300.00n L=60.00n
MM10 net073 C2 VDD VDD pm1p2_svt_lp W=300.00n L=60.00n
MM11 net064 C1 net073 VDD pm1p2_svt_lp W=300.00n L=60.00n
MM6 Z net064 VDD VDD pm1p2_svt_lp W=300.00n L=60.00n
MM4 net064 B1 net071 VDD pm1p2_svt_lp W=300.00n L=60.00n
MM0 net067 A2 VDD VDD pm1p2_svt_lp W=300.00n L=60.00n
MMP1 net064 A1 net067 VDD pm1p2_svt_lp W=300.00n L=60.00n
.ENDS

.SUBCKT OA222X1H9R A1 A2 B1 B2 C1 C2 Z VDD VSS
MM12 net030 B2 VSS VSS nm1p2_svt_lp W=200.00n L=60.00n
MM9 net18 C2 net030 VSS nm1p2_svt_lp W=200.00n L=60.00n
MM7 Z net064 VSS VSS nm1p2_svt_lp W=290.00n L=60.00n
MM2 net18 C1 net030 VSS nm1p2_svt_lp W=200.00n L=60.00n
MM3 net030 B1 VSS VSS nm1p2_svt_lp W=200.00n L=60.00n
MM1 net064 A1 net18 VSS nm1p2_svt_lp W=200.00n L=60.00n
MMN1 net064 A2 net18 VSS nm1p2_svt_lp W=200.00n L=60.00n
MM8 net071 B2 VDD VDD pm1p2_svt_lp W=300.00n L=60.00n
MM10 net073 C2 VDD VDD pm1p2_svt_lp W=300.00n L=60.00n
MM11 net064 C1 net073 VDD pm1p2_svt_lp W=300.00n L=60.00n
MM6 Z net064 VDD VDD pm1p2_svt_lp W=440.00n L=60.00n
MM4 net064 B1 net071 VDD pm1p2_svt_lp W=300.00n L=60.00n
MM0 net067 A2 VDD VDD pm1p2_svt_lp W=300.00n L=60.00n
MMP1 net064 A1 net067 VDD pm1p2_svt_lp W=300.00n L=60.00n
.ENDS

.SUBCKT OA222X2H9R A1 A2 B1 B2 C1 C2 Z VDD VSS
MM12 net030 B2 VSS VSS nm1p2_svt_lp W=200.00n L=60.00n
MM9 net18 C2 net030 VSS nm1p2_svt_lp W=200.00n L=60.00n
MM7 Z net064 VSS VSS nm1p2_svt_lp W=430.00n L=60.00n
MM2 net18 C1 net030 VSS nm1p2_svt_lp W=200.00n L=60.00n
MM3 net030 B1 VSS VSS nm1p2_svt_lp W=200.00n L=60.00n
MM1 net064 A1 net18 VSS nm1p2_svt_lp W=200.00n L=60.00n
MMN1 net064 A2 net18 VSS nm1p2_svt_lp W=200.00n L=60.00n
MM8 net071 B2 VDD VDD pm1p2_svt_lp W=300.00n L=60.00n
MM10 net073 C2 VDD VDD pm1p2_svt_lp W=300.00n L=60.00n
MM11 net064 C1 net073 VDD pm1p2_svt_lp W=300.00n L=60.00n
MM6 Z net064 VDD VDD pm1p2_svt_lp W=650.00n L=60.00n
MM4 net064 B1 net071 VDD pm1p2_svt_lp W=300.00n L=60.00n
MM0 net067 A2 VDD VDD pm1p2_svt_lp W=300.00n L=60.00n
MMP1 net064 A1 net067 VDD pm1p2_svt_lp W=300.00n L=60.00n
.ENDS

.SUBCKT OA222X4H9R A1 A2 B1 B2 C1 C2 Z VDD VSS
MM12 net030 B2 VSS VSS nm1p2_svt_lp W=350.00n L=60.00n
MM9 net18 C2 net030 VSS nm1p2_svt_lp W=350.00n L=60.00n
MM7 Z net064 VSS VSS nm1p2_svt_lp W=860.00n L=60.00n
MM2 net18 C1 net030 VSS nm1p2_svt_lp W=350.00n L=60.00n
MM3 net030 B1 VSS VSS nm1p2_svt_lp W=350.00n L=60.00n
MM1 net064 A1 net18 VSS nm1p2_svt_lp W=350.00n L=60.00n
MMN1 net064 A2 net18 VSS nm1p2_svt_lp W=350.00n L=60.00n
MM8 net071 B2 VDD VDD pm1p2_svt_lp W=520.00n L=60.00n
MM10 net073 C2 VDD VDD pm1p2_svt_lp W=520.00n L=60.00n
MM11 net064 C1 net073 VDD pm1p2_svt_lp W=520.00n L=60.00n
MM6 Z net064 VDD VDD pm1p2_svt_lp W=1.3u L=60.00n
MM4 net064 B1 net071 VDD pm1p2_svt_lp W=520.00n L=60.00n
MM0 net067 A2 VDD VDD pm1p2_svt_lp W=520.00n L=60.00n
MMP1 net064 A1 net067 VDD pm1p2_svt_lp W=520.00n L=60.00n
.ENDS

.SUBCKT OA31X0P5H9R A1 A2 A3 B Z VDD VSS
MM7 Z net064 VSS VSS nm1p2_svt_lp W=200.00n L=60.00n
MM2 net041 B VSS VSS nm1p2_svt_lp W=200.00n L=60.00n
MM9 net064 A3 net041 VSS nm1p2_svt_lp W=200.00n L=60.00n
MM1 net064 A1 net041 VSS nm1p2_svt_lp W=200.00n L=60.00n
MMN1 net064 A2 net041 VSS nm1p2_svt_lp W=200.00n L=60.00n
MM6 Z net064 VDD VDD pm1p2_svt_lp W=300.00n L=60.00n
MM4 net064 B VDD VDD pm1p2_svt_lp W=300.00n L=60.00n
MM8 net065 A3 VDD VDD pm1p2_svt_lp W=300.00n L=60.00n
MM0 net067 A2 net065 VDD pm1p2_svt_lp W=300.00n L=60.00n
MMP1 net064 A1 net067 VDD pm1p2_svt_lp W=300.00n L=60.00n
.ENDS

.SUBCKT OA31X1H9R A1 A2 A3 B Z VDD VSS
MM7 Z net064 VSS VSS nm1p2_svt_lp W=290.0n L=60.00n
MM2 net041 B VSS VSS nm1p2_svt_lp W=200.00n L=60.00n
MM9 net064 A3 net041 VSS nm1p2_svt_lp W=200.00n L=60.00n
MM1 net064 A1 net041 VSS nm1p2_svt_lp W=200.00n L=60.00n
MMN1 net064 A2 net041 VSS nm1p2_svt_lp W=200.00n L=60.00n
MM6 Z net064 VDD VDD pm1p2_svt_lp W=440.00n L=60.00n
MM4 net064 B VDD VDD pm1p2_svt_lp W=300.00n L=60.00n
MM8 net065 A3 VDD VDD pm1p2_svt_lp W=300.00n L=60.00n
MM0 net067 A2 net065 VDD pm1p2_svt_lp W=300.00n L=60.00n
MMP1 net064 A1 net067 VDD pm1p2_svt_lp W=300.00n L=60.00n
.ENDS

.SUBCKT OA31X2H9R A1 A2 A3 B Z VDD VSS
MM7 Z net064 VSS VSS nm1p2_svt_lp W=430.0n L=60.00n
MM2 net041 B VSS VSS nm1p2_svt_lp W=200.00n L=60.00n
MM9 net064 A3 net041 VSS nm1p2_svt_lp W=200.00n L=60.00n
MM1 net064 A1 net041 VSS nm1p2_svt_lp W=200.00n L=60.00n
MMN1 net064 A2 net041 VSS nm1p2_svt_lp W=200.00n L=60.00n
MM6 Z net064 VDD VDD pm1p2_svt_lp W=650.00n L=60.00n
MM4 net064 B VDD VDD pm1p2_svt_lp W=300.00n L=60.00n
MM8 net065 A3 VDD VDD pm1p2_svt_lp W=300.00n L=60.00n
MM0 net067 A2 net065 VDD pm1p2_svt_lp W=300.00n L=60.00n
MMP1 net064 A1 net067 VDD pm1p2_svt_lp W=300.00n L=60.00n
.ENDS

.SUBCKT OA31X4H9R A1 A2 A3 B Z VDD VSS
MM7 Z net064 VSS VSS nm1p2_svt_lp W=860.00n L=60.00n
MM2 net041 B VSS VSS nm1p2_svt_lp W=350.00n L=60.00n
MM9 net064 A3 net041 VSS nm1p2_svt_lp W=350.00n L=60.00n
MM1 net064 A1 net041 VSS nm1p2_svt_lp W=350.00n L=60.00n
MMN1 net064 A2 net041 VSS nm1p2_svt_lp W=350.00n L=60.00n
MM6 Z net064 VDD VDD pm1p2_svt_lp W=1.3u L=60.00n
MM4 net064 B VDD VDD pm1p2_svt_lp W=520.00n L=60.00n
MM8 net065 A3 VDD VDD pm1p2_svt_lp W=520.00n L=60.00n
MM0 net067 A2 net065 VDD pm1p2_svt_lp W=520.00n L=60.00n
MMP1 net064 A1 net067 VDD pm1p2_svt_lp W=520.00n L=60.00n
.ENDS

.SUBCKT OAI32X0P5H9R A1 A2 A3 B1 B2 ZN VDD VSS
MM11 net041 B2 VSS VSS nm1p2_svt_lp W=200.00n L=60.00n
MM2 net041 B1 VSS VSS nm1p2_svt_lp W=200.00n L=60.00n
MM9 ZN A3 net041 VSS nm1p2_svt_lp W=200.00n L=60.00n
MM1 ZN A1 net041 VSS nm1p2_svt_lp W=200.00n L=60.00n
MMN1 ZN A2 net041 VSS nm1p2_svt_lp W=200.00n L=60.00n
MM4 ZN B1 net071 VDD pm1p2_svt_lp W=300.0n L=60.00n
MM8 net065 A3 VDD VDD pm1p2_svt_lp W=300.0n L=60.00n
MM10 net071 B2 VDD VDD pm1p2_svt_lp W=300.0n L=60.00n
MM0 net067 A2 net065 VDD pm1p2_svt_lp W=300.0n L=60.00n
MMP1 ZN A1 net067 VDD pm1p2_svt_lp W=300.0n L=60.00n
.ENDS

.SUBCKT OAI32X1H9R A1 A2 A3 B1 B2 ZN VDD VSS
MM11 net041 B2 VSS VSS nm1p2_svt_lp W=290.00n L=60.00n
MM2 net041 B1 VSS VSS nm1p2_svt_lp W=290.00n L=60.00n
MM9 ZN A3 net041 VSS nm1p2_svt_lp W=290.00n L=60.00n
MM1 ZN A1 net041 VSS nm1p2_svt_lp W=290.00n L=60.00n
MMN1 ZN A2 net041 VSS nm1p2_svt_lp W=290.00n L=60.00n
MM4 ZN B1 net071 VDD pm1p2_svt_lp W=440.00n L=60.00n
MM8 net065 A3 VDD VDD pm1p2_svt_lp W=440.00n L=60.00n
MM10 net071 B2 VDD VDD pm1p2_svt_lp W=440.00n L=60.00n
MM0 net067 A2 net065 VDD pm1p2_svt_lp W=440.00n L=60.00n
MMP1 ZN A1 net067 VDD pm1p2_svt_lp W=440.00n L=60.00n
.ENDS

.SUBCKT OAI32X2H9R A1 A2 A3 B1 B2 ZN VDD VSS
MM11 net041 B2 VSS VSS nm1p2_svt_lp W=430.00n L=60.00n
MM2 net041 B1 VSS VSS nm1p2_svt_lp W=430.00n L=60.00n
MM9 ZN A3 net041 VSS nm1p2_svt_lp W=430.00n L=60.00n
MM1 ZN A1 net041 VSS nm1p2_svt_lp W=430.00n L=60.00n
MMN1 ZN A2 net041 VSS nm1p2_svt_lp W=430.00n L=60.00n
MM4 ZN B1 net071 VDD pm1p2_svt_lp W=650.00n L=60.00n
MM8 net065 A3 VDD VDD pm1p2_svt_lp W=650.00n L=60.00n
MM10 net071 B2 VDD VDD pm1p2_svt_lp W=650.00n L=60.00n
MM0 net067 A2 net065 VDD pm1p2_svt_lp W=650.00n L=60.00n
MMP1 ZN A1 net067 VDD pm1p2_svt_lp W=650.00n L=60.00n
.ENDS

.SUBCKT OAI32X4H9R A1 A2 A3 B1 B2 ZN VDD VSS
MM11 net041 B2 VSS VSS nm1p2_svt_lp W=200.00n L=60.00n
MM12 net064 net0104 VSS VSS nm1p2_svt_lp W=350.00n L=60.00n
MM7 ZN net064 VSS VSS nm1p2_svt_lp W=860.00n L=60.00n
MM2 net041 B1 VSS VSS nm1p2_svt_lp W=200.00n L=60.00n
MM9 net0104 A3 net041 VSS nm1p2_svt_lp W=200.00n L=60.00n
MM1 net0104 A1 net041 VSS nm1p2_svt_lp W=200.00n L=60.00n
MMN1 net0104 A2 net041 VSS nm1p2_svt_lp W=200.00n L=60.00n
MM13 net064 net0104 VDD VDD pm1p2_svt_lp W=530.00n L=60.00n
MM6 ZN net064 VDD VDD pm1p2_svt_lp W=1.3u L=60.00n
MM4 net0104 B1 net071 VDD pm1p2_svt_lp W=300.00n L=60.00n
MM8 net065 A3 VDD VDD pm1p2_svt_lp W=300.00n L=60.00n
MM10 net071 B2 VDD VDD pm1p2_svt_lp W=300.00n L=60.00n
MM0 net067 A2 net065 VDD pm1p2_svt_lp W=300.00n L=60.00n
MMP1 net0104 A1 net067 VDD pm1p2_svt_lp W=300.00n L=60.00n
.ENDS

.SUBCKT OAI33X0P5H9R A1 A2 A3 B1 B2 B3 ZN VDD VSS
MM11 net041 A2 VSS VSS nm1p2_svt_lp W=200.00n L=60.00n
MM2 net041 A1 VSS VSS nm1p2_svt_lp W=200.00n L=60.00n
MM9 ZN B3 net041 VSS nm1p2_svt_lp W=200.00n L=60.00n
MM1 ZN B1 net041 VSS nm1p2_svt_lp W=200.00n L=60.00n
MM13 net041 A3 VSS VSS nm1p2_svt_lp W=200.00n L=60.00n
MMN1 ZN B2 net041 VSS nm1p2_svt_lp W=200.00n L=60.00n
MM12 net076 B3 VDD VDD pm1p2_svt_lp W=300.0n L=60.00n
MM4 ZN B1 net071 VDD pm1p2_svt_lp W=300.0n L=60.00n
MM8 net065 A3 VDD VDD pm1p2_svt_lp W=300.0n L=60.00n
MM10 net071 B2 net076 VDD pm1p2_svt_lp W=300.0n L=60.00n
MM0 net067 A2 net065 VDD pm1p2_svt_lp W=300.0n L=60.00n
MMP1 ZN A1 net067 VDD pm1p2_svt_lp W=300.0n L=60.00n
.ENDS

.SUBCKT OAI33X1H9R A1 A2 A3 B1 B2 B3 ZN VDD VSS
MM11 net041 A2 VSS VSS nm1p2_svt_lp W=290.00n L=60.00n
MM2 net041 A1 VSS VSS nm1p2_svt_lp W=290.00n L=60.00n
MM9 ZN B3 net041 VSS nm1p2_svt_lp W=290.00n L=60.00n
MM1 ZN B1 net041 VSS nm1p2_svt_lp W=290.00n L=60.00n
MM13 net041 A3 VSS VSS nm1p2_svt_lp W=290.00n L=60.00n
MMN1 ZN B2 net041 VSS nm1p2_svt_lp W=290.00n L=60.00n
MM12 net076 B3 VDD VDD pm1p2_svt_lp W=440.0n L=60.00n
MM4 ZN B1 net071 VDD pm1p2_svt_lp W=440.0n L=60.00n
MM8 net065 A3 VDD VDD pm1p2_svt_lp W=440.0n L=60.00n
MM10 net071 B2 net076 VDD pm1p2_svt_lp W=440.0n L=60.00n
MM0 net067 A2 net065 VDD pm1p2_svt_lp W=440.0n L=60.00n
MMP1 ZN A1 net067 VDD pm1p2_svt_lp W=440.0n L=60.00n
.ENDS

.SUBCKT OAI33X2H9R A1 A2 A3 B1 B2 B3 ZN VDD VSS
MM11 net041 A2 VSS VSS nm1p2_svt_lp W=430.00n L=60.00n
MM2 net041 A1 VSS VSS nm1p2_svt_lp W=430.00n L=60.00n
MM9 ZN B3 net041 VSS nm1p2_svt_lp W=430.00n L=60.00n
MM1 ZN B1 net041 VSS nm1p2_svt_lp W=430.00n L=60.00n
MM13 net041 A3 VSS VSS nm1p2_svt_lp W=430.00n L=60.00n
MMN1 ZN B2 net041 VSS nm1p2_svt_lp W=430.00n L=60.00n
MM12 net076 B3 VDD VDD pm1p2_svt_lp W=650.0n L=60.00n
MM4 ZN B1 net071 VDD pm1p2_svt_lp W=650.0n L=60.00n
MM8 net065 A3 VDD VDD pm1p2_svt_lp W=650.0n L=60.00n
MM10 net071 B2 net076 VDD pm1p2_svt_lp W=650.0n L=60.00n
MM0 net067 A2 net065 VDD pm1p2_svt_lp W=650.0n L=60.00n
MMP1 ZN A1 net067 VDD pm1p2_svt_lp W=650.0n L=60.00n
.ENDS

.SUBCKT OAI33X4H9R A1 A2 A3 B1 B2 B3 ZN VDD VSS
MM11 net041 B2 net077 VSS nm1p2_svt_lp W=200.0n L=60.00n
MM7 ZN net064 VSS VSS nm1p2_svt_lp W=860.00n L=60.00n
MM14 net064 net041 VSS VSS nm1p2_svt_lp W=350.00n L=60.00n
MM2 net041 B1 net077 VSS nm1p2_svt_lp W=200.0n L=60.00n
MM9 net077 A3 VSS VSS nm1p2_svt_lp W=200.0n L=60.00n
MM1 net077 A1 VSS VSS nm1p2_svt_lp W=200.0n L=60.00n
MM13 net041 B3 net077 VSS nm1p2_svt_lp W=200.0n L=60.00n
MMN1 net077 A2 VSS VSS nm1p2_svt_lp W=200.0n L=60.00n
MM12 net076 B3 VDD VDD pm1p2_svt_lp W=300.00n L=60.00n
MM15 net064 net041 VDD VDD pm1p2_svt_lp W=530.00n L=60.00n
MM6 ZN net064 VDD VDD pm1p2_svt_lp W=1.3u L=60.00n
MM4 net041 B1 net071 VDD pm1p2_svt_lp W=300.00n L=60.00n
MM8 net065 A3 VDD VDD pm1p2_svt_lp W=300.00n L=60.00n
MM10 net071 B2 net076 VDD pm1p2_svt_lp W=300.00n L=60.00n
MM0 net067 A2 net065 VDD pm1p2_svt_lp W=300.00n L=60.00n
MMP1 net041 A1 net067 VDD pm1p2_svt_lp W=300.00n L=60.00n
.ENDS

.SUBCKT OAO211X0P5H9R A1 A2 B C Z VDD VSS
MM7 Z net18 VSS VSS nm1p2_svt_lp W=200.00n L=60.00n
MMN1 net14 A2 VSS VSS nm1p2_svt_lp W=180.00n L=60.00n
MM1 net14 A1 VSS VSS nm1p2_svt_lp W=180.00n L=60.00n
MM2 net18 B net14 VSS nm1p2_svt_lp W=180.00n L=60.00n
MM5 net18 C VSS VSS nm1p2_svt_lp W=180.00n L=60.00n
MM6 Z net18 VDD VDD pm1p2_svt_lp W=250.00n L=60.00n
MMP1 net30 A1 net33 VDD pm1p2_svt_lp W=200.00n L=60.00n
MM0 net33 A2 VDD VDD pm1p2_svt_lp W=200.00n L=60.00n
MM4 net30 B VDD VDD pm1p2_svt_lp W=200.00n L=60.00n
MM3 net18 C net30 VDD pm1p2_svt_lp W=200.00n L=60.00n
.ENDS

.SUBCKT OAO211X1H9R A1 A2 B C Z VDD VSS
MM6 Z net30 VDD VDD pm1p2_svt_lp W=440.00n L=60.00n
MMP1 net18 A1 net21 VDD pm1p2_svt_lp W=200.00n L=60.00n
MM0 net21 A2 VDD VDD pm1p2_svt_lp W=200.00n L=60.00n
MM4 net18 B VDD VDD pm1p2_svt_lp W=200.00n L=60.00n
MM3 net30 C net18 VDD pm1p2_svt_lp W=200.00n L=60.00n
MM7 Z net30 VSS VSS nm1p2_svt_lp W=350.00n L=60.00n
MMN1 net34 A2 VSS VSS nm1p2_svt_lp W=180.00n L=60.00n
MM1 net34 A1 VSS VSS nm1p2_svt_lp W=180.00n L=60.00n
MM2 net30 B net34 VSS nm1p2_svt_lp W=180.00n L=60.00n
MM5 net30 C VSS VSS nm1p2_svt_lp W=180.00n L=60.00n
.ENDS

.SUBCKT OAO211X2H9R A1 A2 B C Z VDD VSS
MM3 net30 C net18 VDD pm1p2_svt_lp W=220.00n L=60.00n
MM4 net18 B VDD VDD pm1p2_svt_lp W=220.00n L=60.00n
MM0 net21 A2 VDD VDD pm1p2_svt_lp W=220.00n L=60.00n
MMP1 net18 A1 net21 VDD pm1p2_svt_lp W=220.00n L=60.00n
MM6 Z net30 VDD VDD pm1p2_svt_lp W=540.00n L=60.00n
MM5 net30 C VSS VSS nm1p2_svt_lp W=180.00n L=60.00n
MM2 net30 B net34 VSS nm1p2_svt_lp W=180.00n L=60.00n
MM1 net34 A1 VSS VSS nm1p2_svt_lp W=180.00n L=60.00n
MMN1 net34 A2 VSS VSS nm1p2_svt_lp W=180.00n L=60.00n
MM7 Z net30 VSS VSS nm1p2_svt_lp W=430.00n L=60.00n
.ENDS

.SUBCKT OAO211X4H9R A1 A2 B C Z VDD VSS
MM3 net30 C net18 VDD pm1p2_svt_lp W=440.00n L=60.00n
MM4 net18 B VDD VDD pm1p2_svt_lp W=440.00n L=60.00n
MM0 net21 A2 VDD VDD pm1p2_svt_lp W=440.00n L=60.00n
MMP1 net18 A1 net21 VDD pm1p2_svt_lp W=440.00n L=60.00n
MM6 Z net30 VDD VDD pm1p2_svt_lp W=1.08u L=60.00n
MM5 net30 C VSS VSS nm1p2_svt_lp W=350.00n L=60.00n
MM2 net30 B net34 VSS nm1p2_svt_lp W=350.00n L=60.00n
MM1 net34 A1 VSS VSS nm1p2_svt_lp W=350.00n L=60.00n
MMN1 net34 A2 VSS VSS nm1p2_svt_lp W=350.00n L=60.00n
MM7 Z net30 VSS VSS nm1p2_svt_lp W=860.00n L=60.00n
.ENDS

.SUBCKT OAOI211X0P5H9R A1 A2 B C ZN VDD VSS
MM3 ZN C net18 VDD pm1p2_svt_lp W=250.00n L=60.00n
MM4 net18 B VDD VDD pm1p2_svt_lp W=250.00n L=60.00n
MM0 net21 A2 VDD VDD pm1p2_svt_lp W=250.00n L=60.00n
MMP1 net18 A1 net21 VDD pm1p2_svt_lp W=250.00n L=60.00n
MM5 ZN C VSS VSS nm1p2_svt_lp W=200.00n L=60.00n
MM2 ZN B net30 VSS nm1p2_svt_lp W=200.00n L=60.00n
MM1 net30 A1 VSS VSS nm1p2_svt_lp W=200.00n L=60.00n
MMN1 net30 A2 VSS VSS nm1p2_svt_lp W=200.00n L=60.00n
.ENDS

.SUBCKT OAOI211X1H9R A1 A2 B C ZN VDD VSS
MMN1 net10 A2 VSS VSS nm1p2_svt_lp W=350.00n L=60.00n
MM1 net10 A1 VSS VSS nm1p2_svt_lp W=350.00n L=60.00n
MM2 ZN B net10 VSS nm1p2_svt_lp W=350.00n L=60.00n
MM5 ZN C VSS VSS nm1p2_svt_lp W=350.00n L=60.00n
MMP1 net22 A1 net25 VDD pm1p2_svt_lp W=440.00n L=60.00n
MM0 net25 A2 VDD VDD pm1p2_svt_lp W=440.00n L=60.00n
MM4 net22 B VDD VDD pm1p2_svt_lp W=440.00n L=60.00n
MM3 ZN C net22 VDD pm1p2_svt_lp W=440.00n L=60.00n
.ENDS

.SUBCKT OAOI211X2H9R A1 A2 B C ZN VDD VSS
MMN1 net10 A2 VSS VSS nm1p2_svt_lp W=430.00n L=60.00n
MM1 net10 A1 VSS VSS nm1p2_svt_lp W=430.00n L=60.00n
MM2 ZN B net10 VSS nm1p2_svt_lp W=430.00n L=60.00n
MM5 ZN C VSS VSS nm1p2_svt_lp W=430.00n L=60.00n
MMP1 net22 A1 net25 VDD pm1p2_svt_lp W=540.00n L=60.00n
MM0 net25 A2 VDD VDD pm1p2_svt_lp W=540.00n L=60.00n
MM4 net22 B VDD VDD pm1p2_svt_lp W=540.00n L=60.00n
MM3 ZN C net22 VDD pm1p2_svt_lp W=540.00n L=60.00n
.ENDS

.SUBCKT OAOI211X4H9R A1 A2 B C ZN VDD VSS
MMN1 net10 A2 VSS VSS nm1p2_svt_lp W=860.00n L=60.00n
MM1 net10 A1 VSS VSS nm1p2_svt_lp W=860.00n L=60.00n
MM2 ZN B net10 VSS nm1p2_svt_lp W=860.00n L=60.00n
MM5 ZN C VSS VSS nm1p2_svt_lp W=860.00n L=60.00n
MMP1 net22 A1 net25 VDD pm1p2_svt_lp W=1.08u L=60.00n
MM0 net25 A2 VDD VDD pm1p2_svt_lp W=1.08u L=60.00n
MM4 net22 B VDD VDD pm1p2_svt_lp W=1.08u L=60.00n
MM3 ZN C net22 VDD pm1p2_svt_lp W=1.08u L=60.00n
.ENDS

.SUBCKT LATHSRX1H9R D E Q QN RDN SDN VDD VSS
MM48 s SDN VSS VSS nm1p2_svt_lp W=200.00n L=60.00n
MM46 Q pm VSS VSS nm1p2_svt_lp W=290.00n L=60.00n
MM51 pm s VSS VSS nm1p2_svt_lp W=250.00n L=60.00n
MM44 net_0104 D VSS VSS nm1p2_svt_lp W=330.00n L=60.00n
MM42 VSS net_0154 net_0119 VSS nm1p2_svt_lp W=200.00n L=60.00n
MM30 cn c VSS VSS nm1p2_svt_lp W=260.00n L=60.00n
MM27 c E VSS VSS nm1p2_svt_lp W=200.00n L=60.00n
MM19 QN net_0154 VSS VSS nm1p2_svt_lp W=290.00n L=60.00n
MM12 net52 c pm VSS nm1p2_svt_lp W=200.00n L=60.00n
MM11 net_0119 RDN net52 VSS nm1p2_svt_lp W=200.00n L=60.00n
MM9 pm cn net69 VSS nm1p2_svt_lp W=330.00n L=60.00n
MM7 net69 RDN net_0104 VSS nm1p2_svt_lp W=330.00n L=60.00n
MM0 net_0154 pm VSS VSS nm1p2_svt_lp W=240.00n L=60.00n
MM50 net0292 s net128 VDD pm1p2_svt_lp W=440.00n L=60.00n
MM52 pm s net0252 VDD pm1p2_svt_lp W=300.00n L=60.00n
MM49 s SDN VDD VDD pm1p2_svt_lp W=300.00n L=60.00n
MM43 net0252 RDN VDD VDD pm1p2_svt_lp W=300.00n L=60.00n
MM53 net117 s net0285 VDD pm1p2_svt_lp W=300.00n L=60.00n
MM29 cn c VDD VDD pm1p2_svt_lp W=390.00n L=60.00n
MM28 c E VDD VDD pm1p2_svt_lp W=300.00n L=60.00n
MM20 QN net_0154 VDD VDD pm1p2_svt_lp W=440.00n L=60.00n
MM47 Q pm VDD VDD pm1p2_svt_lp W=440.00n L=60.00n
MM14 net0285 cn pm VDD pm1p2_svt_lp W=300.00n L=60.00n
MM13 VDD net_0154 net117 VDD pm1p2_svt_lp W=300.00n L=60.00n
MM10 pm c net0292 VDD pm1p2_svt_lp W=440.00n L=60.00n
MM8 net128 D VDD VDD pm1p2_svt_lp W=440.00n L=60.00n
MM1 net_0154 pm VDD VDD pm1p2_svt_lp W=360.00n L=60.00n
.ENDS

.SUBCKT LATHSRX2H9R D E Q QN RDN SDN VDD VSS
MM48 s SDN VSS VSS nm1p2_svt_lp W=200.00n L=60.00n
MM46 Q pm VSS VSS nm1p2_svt_lp W=430.00n L=60.00n
MM51 pm s VSS VSS nm1p2_svt_lp W=250.00n L=60.00n
MM44 net_0104 D VSS VSS nm1p2_svt_lp W=430.00n L=60.00n
MM42 VSS net_0154 net_0119 VSS nm1p2_svt_lp W=200.00n L=60.00n
MM30 cn c VSS VSS nm1p2_svt_lp W=380.00n L=60.00n
MM27 c E VSS VSS nm1p2_svt_lp W=290.00n L=60.00n
MM19 QN net_0154 VSS VSS nm1p2_svt_lp W=430.00n L=60.00n
MM12 net52 c pm VSS nm1p2_svt_lp W=200.00n L=60.00n
MM11 net_0119 RDN net52 VSS nm1p2_svt_lp W=200.00n L=60.00n
MM9 pm cn net69 VSS nm1p2_svt_lp W=430.00n L=60.00n
MM7 net69 RDN net_0104 VSS nm1p2_svt_lp W=430.00n L=60.00n
MM0 net_0154 pm VSS VSS nm1p2_svt_lp W=290.00n L=60.00n
MM50 net0292 s net128 VDD pm1p2_svt_lp W=600.00n L=60.00n
MM52 pm s net0252 VDD pm1p2_svt_lp W=300.00n L=60.00n
MM49 s SDN VDD VDD pm1p2_svt_lp W=300.00n L=60.00n
MM43 net0252 RDN VDD VDD pm1p2_svt_lp W=300.00n L=60.00n
MM53 net117 s net0285 VDD pm1p2_svt_lp W=300.00n L=60.00n
MM29 cn c VDD VDD pm1p2_svt_lp W=570.00n L=60.00n
MM28 c E VDD VDD pm1p2_svt_lp W=440.00n L=60.00n
MM20 QN net_0154 VDD VDD pm1p2_svt_lp W=440.00n L=60.00n
MM47 Q pm VDD VDD pm1p2_svt_lp W=650.00n L=60.00n
MM14 net0285 cn pm VDD pm1p2_svt_lp W=300.00n L=60.00n
MM13 VDD net_0154 net117 VDD pm1p2_svt_lp W=300.00n L=60.00n
MM10 pm c net0292 VDD pm1p2_svt_lp W=600.00n L=60.00n
MM8 net128 D VDD VDD pm1p2_svt_lp W=600.00n L=60.00n
MM1 net_0154 pm VDD VDD pm1p2_svt_lp W=440.00n L=60.00n
.ENDS

.SUBCKT LATHSRX4H9R D E Q QN RDN SDN VDD VSS
MM48 s SDN VSS VSS nm1p2_svt_lp W=200.00n L=60.00n
MM46 Q pm VSS VSS nm1p2_svt_lp W=860.00n L=60.00n
MM51 pm s VSS VSS nm1p2_svt_lp W=240.00n L=60.00n
MM44 net_0104 D VSS VSS nm1p2_svt_lp W=430.00n L=60.00n
MM42 VSS net_0154 net_0119 VSS nm1p2_svt_lp W=200.00n L=60.00n
MM30 cn c VSS VSS nm1p2_svt_lp W=430.00n L=60.00n
MM27 c E VSS VSS nm1p2_svt_lp W=200.00n L=60.00n
MM19 QN net_0154 VSS VSS nm1p2_svt_lp W=860.00n L=60.00n
MM12 net52 c pm VSS nm1p2_svt_lp W=200.00n L=60.00n
MM11 net_0119 RDN net52 VSS nm1p2_svt_lp W=200.00n L=60.00n
MM9 pm cn net69 VSS nm1p2_svt_lp W=430.00n L=60.00n
MM7 net69 RDN net_0104 VSS nm1p2_svt_lp W=430.00n L=60.00n
MM0 net_0154 pm VSS VSS nm1p2_svt_lp W=360.00n L=60.00n
MM50 net0292 s net128 VDD pm1p2_svt_lp W=650.00n L=60.00n
MM52 pm s net0252 VDD pm1p2_svt_lp W=300.00n L=60.00n
MM49 s SDN VDD VDD pm1p2_svt_lp W=300.00n L=60.00n
MM43 net0252 RDN VDD VDD pm1p2_svt_lp W=300.00n L=60.00n
MM53 net117 s net0285 VDD pm1p2_svt_lp W=300.00n L=60.00n
MM29 cn c VDD VDD pm1p2_svt_lp W=640.00n L=60.00n
MM28 c E VDD VDD pm1p2_svt_lp W=300.00n L=60.00n
MM20 QN net_0154 VDD VDD pm1p2_svt_lp W=1.3u L=60.00n
MM47 Q pm VDD VDD pm1p2_svt_lp W=1.3u L=60.00n
MM14 net0285 cn pm VDD pm1p2_svt_lp W=300.00n L=60.00n
MM13 VDD net_0154 net117 VDD pm1p2_svt_lp W=300.00n L=60.00n
MM10 pm c net0292 VDD pm1p2_svt_lp W=640.00n L=60.00n
MM8 net128 D VDD VDD pm1p2_svt_lp W=650.00n L=60.00n
MM1 net_0154 pm VDD VDD pm1p2_svt_lp W=510.00n L=60.00n
.ENDS

.SUBCKT LATLSRX1H9R D EN Q QN RDN SDN VDD VSS
MM48 s SDN VSS VSS nm1p2_svt_lp W=200.00n L=60.00n
MM46 Q pm VSS VSS nm1p2_svt_lp W=290.00n L=60.00n
MM51 pm s VSS VSS nm1p2_svt_lp W=250.00n L=60.00n
MM44 net_0104 D VSS VSS nm1p2_svt_lp W=330.00n L=60.00n
MM42 VSS net_0154 net_0119 VSS nm1p2_svt_lp W=200.00n L=60.00n
MM30 cn c VSS VSS nm1p2_svt_lp W=260.00n L=60.00n
MM27 c EN VSS VSS nm1p2_svt_lp W=200.00n L=60.00n
MM19 QN net_0154 VSS VSS nm1p2_svt_lp W=290.00n L=60.00n
MM12 net52 cn pm VSS nm1p2_svt_lp W=200.00n L=60.00n
MM11 net_0119 RDN net52 VSS nm1p2_svt_lp W=200.00n L=60.00n
MM9 pm c net69 VSS nm1p2_svt_lp W=330.00n L=60.00n
MM7 net69 RDN net_0104 VSS nm1p2_svt_lp W=330.00n L=60.00n
MM0 net_0154 pm VSS VSS nm1p2_svt_lp W=240.00n L=60.00n
MM50 net0292 s net128 VDD pm1p2_svt_lp W=440.00n L=60.00n
MM52 pm s net0252 VDD pm1p2_svt_lp W=300.00n L=60.00n
MM49 s SDN VDD VDD pm1p2_svt_lp W=300.00n L=60.00n
MM43 net0252 RDN VDD VDD pm1p2_svt_lp W=300.00n L=60.00n
MM53 net117 s net0285 VDD pm1p2_svt_lp W=300.00n L=60.00n
MM29 cn c VDD VDD pm1p2_svt_lp W=390.00n L=60.00n
MM28 c EN VDD VDD pm1p2_svt_lp W=300.00n L=60.00n
MM20 QN net_0154 VDD VDD pm1p2_svt_lp W=440.00n L=60.00n
MM47 Q pm VDD VDD pm1p2_svt_lp W=440.00n L=60.00n
MM14 net0285 c pm VDD pm1p2_svt_lp W=300.00n L=60.00n
MM13 VDD net_0154 net117 VDD pm1p2_svt_lp W=300.00n L=60.00n
MM10 pm cn net0292 VDD pm1p2_svt_lp W=440.00n L=60.00n
MM8 net128 D VDD VDD pm1p2_svt_lp W=440.00n L=60.00n
MM1 net_0154 pm VDD VDD pm1p2_svt_lp W=360.00n L=60.00n
.ENDS

.SUBCKT LATLSRX2H9R D EN Q QN RDN SDN VDD VSS
MM48 s SDN VSS VSS nm1p2_svt_lp W=200.00n L=60.00n
MM46 Q pm VSS VSS nm1p2_svt_lp W=430.00n L=60.00n
MM51 pm s VSS VSS nm1p2_svt_lp W=200.00n L=60.00n
MM44 net_0104 D VSS VSS nm1p2_svt_lp W=430.00n L=60.00n
MM42 VSS net_0154 net_0119 VSS nm1p2_svt_lp W=200.00n L=60.00n
MM30 cn c VSS VSS nm1p2_svt_lp W=380.00n L=60.00n
MM27 c EN VSS VSS nm1p2_svt_lp W=290.00n L=60.00n
MM19 QN net_0154 VSS VSS nm1p2_svt_lp W=430.00n L=60.00n
MM12 net52 cn pm VSS nm1p2_svt_lp W=200.00n L=60.00n
MM11 net_0119 RDN net52 VSS nm1p2_svt_lp W=200.00n L=60.00n
MM9 pm c net69 VSS nm1p2_svt_lp W=430.00n L=60.00n
MM7 net69 RDN net_0104 VSS nm1p2_svt_lp W=380.00n L=60.00n
MM0 net_0154 pm VSS VSS nm1p2_svt_lp W=290.00n L=60.00n
MM50 net0292 s net128 VDD pm1p2_svt_lp W=550.00n L=60.00n
MM52 pm s net0252 VDD pm1p2_svt_lp W=300.00n L=60.00n
MM49 s SDN VDD VDD pm1p2_svt_lp W=300.00n L=60.00n
MM43 net0252 RDN VDD VDD pm1p2_svt_lp W=250.00n L=60.00n
MM53 net117 s net0285 VDD pm1p2_svt_lp W=300.00n L=60.00n
MM29 cn c VDD VDD pm1p2_svt_lp W=570.00n L=60.00n
MM28 c EN VDD VDD pm1p2_svt_lp W=440.00n L=60.00n
MM20 QN net_0154 VDD VDD pm1p2_svt_lp W=650.00n L=60.00n
MM47 Q pm VDD VDD pm1p2_svt_lp W=650.00n L=60.00n
MM14 net0285 c pm VDD pm1p2_svt_lp W=300.00n L=60.00n
MM13 VDD net_0154 net117 VDD pm1p2_svt_lp W=300.00n L=60.00n
MM10 pm cn net0292 VDD pm1p2_svt_lp W=600.00n L=60.00n
MM8 net128 D VDD VDD pm1p2_svt_lp W=600.00n L=60.00n
MM1 net_0154 pm VDD VDD pm1p2_svt_lp W=440.00n L=60.00n
.ENDS

.SUBCKT LATLSRX4H9R D EN Q QN RDN SDN VDD VSS
MM48 s SDN VSS VSS nm1p2_svt_lp W=200.00n L=60.00n
MM46 Q net0145 VSS VSS nm1p2_svt_lp W=860.00n L=60.00n
MM51 net0145 s VSS VSS nm1p2_svt_lp W=200.00n L=60.00n
MM44 net_0104 D VSS VSS nm1p2_svt_lp W=360.00n L=60.00n
MM42 VSS net_0154 net_0119 VSS nm1p2_svt_lp W=200.00n L=60.00n
MM30 cn c VSS VSS nm1p2_svt_lp W=430.00n L=60.00n
MM27 c EN VSS VSS nm1p2_svt_lp W=200.00n L=60.00n
MM19 QN net_0154 VSS VSS nm1p2_svt_lp W=860.00n L=60.00n
MM12 net52 cn net0145 VSS nm1p2_svt_lp W=200.00n L=60.00n
MM11 net_0119 RDN net52 VSS nm1p2_svt_lp W=200.00n L=60.00n
MM9 net0145 c net69 VSS nm1p2_svt_lp W=420.00n L=60.00n
MM7 net69 RDN net_0104 VSS nm1p2_svt_lp W=420.00n L=60.00n
MM0 net_0154 net0145 VSS VSS nm1p2_svt_lp W=360.00n L=60.00n
MM50 net0292 s net128 VDD pm1p2_svt_lp W=600.00n L=60.00n
MM52 net0145 s net0252 VDD pm1p2_svt_lp W=290.00n L=60.00n
MM49 s SDN VDD VDD pm1p2_svt_lp W=300.00n L=60.00n
MM43 net0252 RDN VDD VDD pm1p2_svt_lp W=290.00n L=60.00n
MM53 net117 s net0285 VDD pm1p2_svt_lp W=300.00n L=60.00n
MM29 cn c VDD VDD pm1p2_svt_lp W=640.00n L=60.00n
MM28 c EN VDD VDD pm1p2_svt_lp W=300.00n L=60.00n
MM20 QN net_0154 VDD VDD pm1p2_svt_lp W=1.3u L=60.00n
MM47 Q net0145 VDD VDD pm1p2_svt_lp W=1.3u L=60.00n
MM14 net0285 c net0145 VDD pm1p2_svt_lp W=300.00n L=60.00n
MM13 VDD net_0154 net117 VDD pm1p2_svt_lp W=300.00n L=60.00n
MM10 net0145 cn net0292 VDD pm1p2_svt_lp W=605.00n L=60.00n
MM8 net128 D VDD VDD pm1p2_svt_lp W=550.00n L=60.00n
MM1 net_0154 net0145 VDD VDD pm1p2_svt_lp W=510.00n L=60.00n
.ENDS

.SUBCKT DFFX1H9R CK D Q QN VDD VSS
MM42 QN s VSS VSS nm1p2_svt_lp W=290.00n L=60.00n
MM39 net43 c net_099 VSS nm1p2_svt_lp W=290.00n L=60.00n
MM40 net_099 m VSS VSS nm1p2_svt_lp W=290.00n L=60.00n
MM30 c cn VSS VSS nm1p2_svt_lp W=290.00n L=60.00n
MM27 cn CK VSS VSS nm1p2_svt_lp W=200.00n L=60.00n
MM24 net48 cn net43 VSS nm1p2_svt_lp W=200.00n L=60.00n
MM23 VSS s net48 VSS nm1p2_svt_lp W=200.00n L=60.00n
MM19 Q net43 VSS VSS nm1p2_svt_lp W=290.00n L=60.00n
MM17 s net43 VSS VSS nm1p2_svt_lp W=200.00n L=60.00n
MM12 net52 c pm VSS nm1p2_svt_lp W=200.00n L=60.00n
MM11 VSS m net52 VSS nm1p2_svt_lp W=200.00n L=60.00n
MM9 pm cn net69 VSS nm1p2_svt_lp W=200.00n L=60.00n
MM7 net69 D VSS VSS nm1p2_svt_lp W=200.00n L=60.00n
MM0 m pm VSS VSS nm1p2_svt_lp W=290.00n L=60.00n
MM43 QN s VDD VDD pm1p2_svt_lp W=440.00n L=60.00n
MM38 net43 cn net_0158 VDD pm1p2_svt_lp W=440.00n L=60.00n
MM41 net_0158 m VDD VDD pm1p2_svt_lp W=440.00n L=60.00n
MM29 c cn VDD VDD pm1p2_svt_lp W=440.00n L=60.00n
MM28 cn CK VDD VDD pm1p2_svt_lp W=300.00n L=60.00n
MM26 VDD s net109 VDD pm1p2_svt_lp W=300.00n L=60.00n
MM25 net109 c net43 VDD pm1p2_svt_lp W=300.00n L=60.00n
MM20 Q net43 VDD VDD pm1p2_svt_lp W=440.00n L=60.00n
MM18 s net43 VDD VDD pm1p2_svt_lp W=300.00n L=60.00n
MM14 net117 cn pm VDD pm1p2_svt_lp W=300.00n L=60.00n
MM13 VDD m net117 VDD pm1p2_svt_lp W=300.00n L=60.00n
MM10 pm c net128 VDD pm1p2_svt_lp W=300.00n L=60.00n
MM8 net128 D VDD VDD pm1p2_svt_lp W=300.00n L=60.00n
MM1 m pm VDD VDD pm1p2_svt_lp W=440.00n L=60.00n
.ENDS

.SUBCKT DFFX2H9R CK D Q QN VDD VSS
MM42 QN s VSS VSS nm1p2_svt_lp W=430.00n L=60.00n
MM39 net43 c net_099 VSS nm1p2_svt_lp W=430.00n L=60.00n
MM40 net_099 m VSS VSS nm1p2_svt_lp W=430.00n L=60.00n
MM30 c cn VSS VSS nm1p2_svt_lp W=430.00n L=60.00n
MM27 cn CK VSS VSS nm1p2_svt_lp W=200.00n L=60.00n
MM24 net48 cn net43 VSS nm1p2_svt_lp W=200.00n L=60.00n
MM23 VSS s net48 VSS nm1p2_svt_lp W=200.00n L=60.00n
MM19 Q net43 VSS VSS nm1p2_svt_lp W=430.00n L=60.00n
MM17 s net43 VSS VSS nm1p2_svt_lp W=290.00n L=60.00n
MM12 net52 c pm VSS nm1p2_svt_lp W=200.00n L=60.00n
MM11 VSS m net52 VSS nm1p2_svt_lp W=200.00n L=60.00n
MM9 pm cn net69 VSS nm1p2_svt_lp W=200.00n L=60.00n
MM7 net69 D VSS VSS nm1p2_svt_lp W=200.00n L=60.00n
MM0 m pm VSS VSS nm1p2_svt_lp W=290.00n L=60.00n
MM43 QN s VDD VDD pm1p2_svt_lp W=650.00n L=60.00n
MM38 net43 cn net_0158 VDD pm1p2_svt_lp W=640.00n L=60.00n
MM41 net_0158 m VDD VDD pm1p2_svt_lp W=640.00n L=60.00n
MM29 c cn VDD VDD pm1p2_svt_lp W=650.00n L=60.00n
MM28 cn CK VDD VDD pm1p2_svt_lp W=300.00n L=60.00n
MM26 VDD s net109 VDD pm1p2_svt_lp W=300.00n L=60.00n
MM25 net109 c net43 VDD pm1p2_svt_lp W=300.00n L=60.00n
MM20 Q net43 VDD VDD pm1p2_svt_lp W=650.00n L=60.00n
MM18 s net43 VDD VDD pm1p2_svt_lp W=440.00n L=60.00n
MM14 net117 cn pm VDD pm1p2_svt_lp W=300.00n L=60.00n
MM13 VDD m net117 VDD pm1p2_svt_lp W=300.00n L=60.00n
MM10 pm c net128 VDD pm1p2_svt_lp W=300.00n L=60.00n
MM8 net128 D VDD VDD pm1p2_svt_lp W=300.00n L=60.00n
MM1 m pm VDD VDD pm1p2_svt_lp W=440.00n L=60.00n
.ENDS

.SUBCKT DFFX4H9R CK D Q QN VDD VSS
MM42 QN s VSS VSS nm1p2_svt_lp W=430.00n L=60.00n m=2
MM39 net43 c net_099 VSS nm1p2_svt_lp W=300.00n L=60.00n m=2
MM40 net_099 m VSS VSS nm1p2_svt_lp W=300.00n L=60.00n m=2
MM30 c cn VSS VSS nm1p2_svt_lp W=430.00n L=60.00n
MM27 cn CK VSS VSS nm1p2_svt_lp W=290.00n L=60.00n
MM24 net48 cn net43 VSS nm1p2_svt_lp W=200.00n L=60.00n
MM23 VSS s net48 VSS nm1p2_svt_lp W=200.00n L=60.00n
MM19 Q net43 VSS VSS nm1p2_svt_lp W=430.00n L=60.00n m=2
MM17 s net43 VSS VSS nm1p2_svt_lp W=430.00n L=60.00n
MM12 net52 c pm VSS nm1p2_svt_lp W=200.00n L=60.00n
MM11 VSS m net52 VSS nm1p2_svt_lp W=200.00n L=60.00n
MM9 pm cn net69 VSS nm1p2_svt_lp W=200.00n L=60.00n
MM7 net69 D VSS VSS nm1p2_svt_lp W=200.00n L=60.00n
MM0 m pm VSS VSS nm1p2_svt_lp W=290.00n L=60.00n
MM43 QN s VDD VDD pm1p2_svt_lp W=650.00n L=60.00n m=2
MM38 net43 cn net_0158 VDD pm1p2_svt_lp W=450.00n L=60.00n m=2
MM41 net_0158 m VDD VDD pm1p2_svt_lp W=450.00n L=60.00n m=2
MM29 c cn VDD VDD pm1p2_svt_lp W=650.00n L=60.00n
MM28 cn CK VDD VDD pm1p2_svt_lp W=440.00n L=60.00n
MM26 VDD s net109 VDD pm1p2_svt_lp W=300.00n L=60.00n
MM25 net109 c net43 VDD pm1p2_svt_lp W=300.00n L=60.00n
MM20 Q net43 VDD VDD pm1p2_svt_lp W=650.00n L=60.00n m=2
MM18 s net43 VDD VDD pm1p2_svt_lp W=650.00n L=60.00n
MM14 net117 cn pm VDD pm1p2_svt_lp W=300.00n L=60.00n
MM13 VDD m net117 VDD pm1p2_svt_lp W=300.00n L=60.00n
MM10 pm c net128 VDD pm1p2_svt_lp W=300.00n L=60.00n
MM8 net128 D VDD VDD pm1p2_svt_lp W=300.00n L=60.00n
MM1 m pm VDD VDD pm1p2_svt_lp W=440.00n L=60.00n
.ENDS

.SUBCKT DFFNX1H9R CKN D Q QN VDD VSS
MM42 QN s VSS VSS nm1p2_svt_lp W=290.00n L=60.00n
MM39 net43 c net_099 VSS nm1p2_svt_lp W=200.00n L=60.00n
MM40 net_099 m VSS VSS nm1p2_svt_lp W=200.00n L=60.00n
MM30 cn c VSS VSS nm1p2_svt_lp W=200.00n L=60.00n
MM27 c CKN VSS VSS nm1p2_svt_lp W=200.00n L=60.00n
MM24 net48 cn net43 VSS nm1p2_svt_lp W=200.00n L=60.00n
MM23 VSS s net48 VSS nm1p2_svt_lp W=200.00n L=60.00n
MM19 Q net43 VSS VSS nm1p2_svt_lp W=290.00n L=60.00n
MM17 s net43 VSS VSS nm1p2_svt_lp W=290.00n L=60.00n
MM12 net52 c pm VSS nm1p2_svt_lp W=200.00n L=60.00n
MM11 VSS m net52 VSS nm1p2_svt_lp W=200.00n L=60.00n
MM9 pm cn net69 VSS nm1p2_svt_lp W=200.00n L=60.00n
MM7 net69 D VSS VSS nm1p2_svt_lp W=200.00n L=60.00n
MM0 m pm VSS VSS nm1p2_svt_lp W=200.00n L=60.00n
MM43 QN s VDD VDD pm1p2_svt_lp W=440.00n L=60.00n
MM38 net43 cn net_0158 VDD pm1p2_svt_lp W=440.00n L=60.00n
MM41 net_0158 m VDD VDD pm1p2_svt_lp W=440.00n L=60.00n
MM29 cn c VDD VDD pm1p2_svt_lp W=300.00n L=60.00n
MM28 c CKN VDD VDD pm1p2_svt_lp W=300.00n L=60.00n
MM26 VDD s net109 VDD pm1p2_svt_lp W=300.00n L=60.00n
MM25 net109 c net43 VDD pm1p2_svt_lp W=300.00n L=60.00n
MM20 Q net43 VDD VDD pm1p2_svt_lp W=440.00n L=60.00n
MM18 s net43 VDD VDD pm1p2_svt_lp W=300.00n L=60.00n
MM14 net117 cn pm VDD pm1p2_svt_lp W=300.00n L=60.00n
MM13 VDD m net117 VDD pm1p2_svt_lp W=300.00n L=60.00n
MM10 pm c net128 VDD pm1p2_svt_lp W=440.00n L=60.00n
MM8 net128 D VDD VDD pm1p2_svt_lp W=440.00n L=60.00n
MM1 m pm VDD VDD pm1p2_svt_lp W=300.00n L=60.00n
.ENDS

.SUBCKT DFFNX2H9R CKN D Q QN VDD VSS
MM42 QN s VSS VSS nm1p2_svt_lp W=430.00n L=60.00n
MM39 net43 c net_099 VSS nm1p2_svt_lp W=230.00n L=60.00n
MM40 net_099 m VSS VSS nm1p2_svt_lp W=230.00n L=60.00n
MM30 cn c VSS VSS nm1p2_svt_lp W=290.00n L=60.00n
MM27 c CKN VSS VSS nm1p2_svt_lp W=200.00n L=60.00n
MM24 net48 cn net43 VSS nm1p2_svt_lp W=200.00n L=60.00n
MM23 VSS s net48 VSS nm1p2_svt_lp W=200.00n L=60.00n
MM19 Q net43 VSS VSS nm1p2_svt_lp W=430.00n L=60.00n
MM17 s net43 VSS VSS nm1p2_svt_lp W=260.00n L=60.00n
MM12 net52 c pm VSS nm1p2_svt_lp W=200.00n L=60.00n
MM11 VSS m net52 VSS nm1p2_svt_lp W=200.00n L=60.00n
MM9 pm cn net69 VSS nm1p2_svt_lp W=200.00n L=60.00n
MM7 net69 D VSS VSS nm1p2_svt_lp W=200.00n L=60.00n
MM0 m pm VSS VSS nm1p2_svt_lp W=200.00n L=60.00n
MM43 QN s VDD VDD pm1p2_svt_lp W=650.00n L=60.00n
MM38 net43 cn net_0158 VDD pm1p2_svt_lp W=650.00n L=60.00n
MM41 net_0158 m VDD VDD pm1p2_svt_lp W=650.00n L=60.00n
MM29 cn c VDD VDD pm1p2_svt_lp W=440.00n L=60.00n
MM28 c CKN VDD VDD pm1p2_svt_lp W=300.00n L=60.00n
MM26 VDD s net109 VDD pm1p2_svt_lp W=300.00n L=60.00n
MM25 net109 c net43 VDD pm1p2_svt_lp W=300.00n L=60.00n
MM20 Q net43 VDD VDD pm1p2_svt_lp W=650.00n L=60.00n
MM18 s net43 VDD VDD pm1p2_svt_lp W=480.00n L=60.00n
MM14 net117 cn pm VDD pm1p2_svt_lp W=300.00n L=60.00n
MM13 VDD m net117 VDD pm1p2_svt_lp W=300.00n L=60.00n
MM10 pm c net128 VDD pm1p2_svt_lp W=440.00n L=60.00n
MM8 net128 D VDD VDD pm1p2_svt_lp W=440.00n L=60.00n
MM1 m pm VDD VDD pm1p2_svt_lp W=300.00n L=60.00n
.ENDS

.SUBCKT DFFNX4H9R CKN D Q QN VDD VSS
MM42 QN s VSS VSS nm1p2_svt_lp W=430.00n L=60.00n m=2
MM39 net43 c net_099 VSS nm1p2_svt_lp W=400.00n L=60.00n
MM40 net_099 m VSS VSS nm1p2_svt_lp W=400.00n L=60.00n
MM30 cn c VSS VSS nm1p2_svt_lp W=430.00n L=60.00n
MM27 c CKN VSS VSS nm1p2_svt_lp W=290.00n L=60.00n
MM24 net48 cn net43 VSS nm1p2_svt_lp W=200.00n L=60.00n
MM23 VSS s net48 VSS nm1p2_svt_lp W=200.00n L=60.00n
MM19 Q net43 VSS VSS nm1p2_svt_lp W=430.00n L=60.00n m=2
MM17 s net43 VSS VSS nm1p2_svt_lp W=400.00n L=60.00n
MM12 net52 c pm VSS nm1p2_svt_lp W=200.00n L=60.00n
MM11 VSS m net52 VSS nm1p2_svt_lp W=200.00n L=60.00n
MM9 pm cn net69 VSS nm1p2_svt_lp W=200.00n L=60.00n
MM7 net69 D VSS VSS nm1p2_svt_lp W=200.00n L=60.00n
MM0 m pm VSS VSS nm1p2_svt_lp W=200.00n L=60.00n
MM43 QN s VDD VDD pm1p2_svt_lp W=650.00n L=60.00n m=2
MM38 net43 cn net_0158 VDD pm1p2_svt_lp W=450.00n L=60.00n m=2
MM41 net_0158 m VDD VDD pm1p2_svt_lp W=450.00n L=60.00n m=2
MM29 cn c VDD VDD pm1p2_svt_lp W=650.00n L=60.00n
MM28 c CKN VDD VDD pm1p2_svt_lp W=440.00n L=60.00n
MM26 VDD s net109 VDD pm1p2_svt_lp W=300.00n L=60.00n
MM25 net109 c net43 VDD pm1p2_svt_lp W=300.00n L=60.00n
MM20 Q net43 VDD VDD pm1p2_svt_lp W=650.00n L=60.00n m=2
MM18 s net43 VDD VDD pm1p2_svt_lp W=600.00n L=60.00n
MM14 net117 cn pm VDD pm1p2_svt_lp W=300.00n L=60.00n
MM13 VDD m net117 VDD pm1p2_svt_lp W=300.00n L=60.00n
MM10 pm c net128 VDD pm1p2_svt_lp W=440.00n L=60.00n
MM8 net128 D VDD VDD pm1p2_svt_lp W=440.00n L=60.00n
MM1 m pm VDD VDD pm1p2_svt_lp W=300.00n L=60.00n
.ENDS

.SUBCKT DFFRX1H9R CK D Q QN RDN VDD VSS
MM45 QN net43 VSS VSS nm1p2_svt_lp W=290.00n L=60.00n
MM3 net_0154 c net43 VSS nm1p2_svt_lp W=290.00n L=60.00n
MM44 net_0104 RDN VSS VSS nm1p2_svt_lp W=290.00n L=60.00n
MM42 VSS RDN net_0119 VSS nm1p2_svt_lp W=200.00n L=60.00n
MM39 s net43 net_099 VSS nm1p2_svt_lp W=290.00n L=60.00n
MM40 net_099 RDN VSS VSS nm1p2_svt_lp W=290.00n L=60.00n
MM30 c cn VSS VSS nm1p2_svt_lp W=200.00n L=60.00n
MM27 cn CK VSS VSS nm1p2_svt_lp W=200.00n L=60.00n
MM24 net48 cn net43 VSS nm1p2_svt_lp W=200.00n L=60.00n
MM23 VSS s net48 VSS nm1p2_svt_lp W=200.00n L=60.00n
MM19 Q s VSS VSS nm1p2_svt_lp W=290.00n L=60.00n
MM12 net52 c pm VSS nm1p2_svt_lp W=200.00n L=60.00n
MM11 net_0119 net_0154 net52 VSS nm1p2_svt_lp W=200.00n L=60.00n
MM9 pm cn net69 VSS nm1p2_svt_lp W=290.00n L=60.00n
MM7 net69 D net_0104 VSS nm1p2_svt_lp W=290.00n L=60.00n
MM0 net_0154 pm VSS VSS nm1p2_svt_lp W=290.00n L=60.00n
MM46 QN net43 VDD VDD pm1p2_svt_lp W=440.00n L=60.00n
MM43 pm RDN VDD VDD pm1p2_svt_lp W=300.00n L=60.00n
MM38 s net43 VDD VDD pm1p2_svt_lp W=300.00n L=60.00n
MM41 s RDN VDD VDD pm1p2_svt_lp W=300.00n L=60.00n
MM29 c cn VDD VDD pm1p2_svt_lp W=300.00n L=60.00n
MM28 cn CK VDD VDD pm1p2_svt_lp W=300.00n L=60.00n
MM26 VDD s net109 VDD pm1p2_svt_lp W=300.00n L=60.00n
MM25 net109 c net43 VDD pm1p2_svt_lp W=300.00n L=60.00n
MM20 Q s VDD VDD pm1p2_svt_lp W=440.00n L=60.00n
MM4 net_0154 cn net43 VDD pm1p2_svt_lp W=440.00n L=60.00n
MM14 net117 cn pm VDD pm1p2_svt_lp W=300.00n L=60.00n
MM13 VDD net_0154 net117 VDD pm1p2_svt_lp W=300.00n L=60.00n
MM10 pm c net128 VDD pm1p2_svt_lp W=300.00n L=60.00n
MM8 net128 D VDD VDD pm1p2_svt_lp W=300.00n L=60.00n
MM1 net_0154 pm VDD VDD pm1p2_svt_lp W=440.00n L=60.00n
.ENDS

.SUBCKT DFFRX2H9R CK D Q QN RDN VDD VSS
MM45 QN net43 VSS VSS nm1p2_svt_lp W=430.00n L=60.00n
MM3 net_0154 c net43 VSS nm1p2_svt_lp W=340.00n L=60.00n
MM44 net_0104 RDN VSS VSS nm1p2_svt_lp W=320.00n L=60.00n
MM42 VSS RDN net_0119 VSS nm1p2_svt_lp W=200.00n L=60.00n
MM39 s net43 net_099 VSS nm1p2_svt_lp W=390.00n L=60.00n
MM40 net_099 RDN VSS VSS nm1p2_svt_lp W=390.00n L=60.00n
MM30 c cn VSS VSS nm1p2_svt_lp W=200.00n L=60.00n
MM27 cn CK VSS VSS nm1p2_svt_lp W=200.00n L=60.00n
MM24 net48 cn net43 VSS nm1p2_svt_lp W=200.00n L=60.00n
MM23 VSS s net48 VSS nm1p2_svt_lp W=200.00n L=60.00n
MM19 Q s VSS VSS nm1p2_svt_lp W=430.00n L=60.00n
MM12 net52 c pm VSS nm1p2_svt_lp W=200.00n L=60.00n
MM11 net_0119 net_0154 net52 VSS nm1p2_svt_lp W=200.00n L=60.00n
MM9 pm cn net69 VSS nm1p2_svt_lp W=320.00n L=60.00n
MM7 net69 D net_0104 VSS nm1p2_svt_lp W=320.00n L=60.00n
MM0 net_0154 pm VSS VSS nm1p2_svt_lp W=340.00n L=60.00n
MM46 QN net43 VDD VDD pm1p2_svt_lp W=650.00n L=60.00n
MM43 pm RDN VDD VDD pm1p2_svt_lp W=300.00n L=60.00n
MM38 s net43 VDD VDD pm1p2_svt_lp W=400.00n L=60.00n
MM41 s RDN VDD VDD pm1p2_svt_lp W=300.00n L=60.00n
MM29 c cn VDD VDD pm1p2_svt_lp W=300.00n L=60.00n
MM28 cn CK VDD VDD pm1p2_svt_lp W=300.00n L=60.00n
MM26 VDD s net109 VDD pm1p2_svt_lp W=300.00n L=60.00n
MM25 net109 c net43 VDD pm1p2_svt_lp W=300.00n L=60.00n
MM20 Q s VDD VDD pm1p2_svt_lp W=650.00n L=60.00n
MM4 net_0154 cn net43 VDD pm1p2_svt_lp W=530.00n L=60.00n
MM14 net117 cn pm VDD pm1p2_svt_lp W=300.00n L=60.00n
MM13 VDD net_0154 net117 VDD pm1p2_svt_lp W=300.00n L=60.00n
MM10 pm c net128 VDD pm1p2_svt_lp W=300.00n L=60.00n
MM8 net128 D VDD VDD pm1p2_svt_lp W=300.00n L=60.00n
MM1 net_0154 pm VDD VDD pm1p2_svt_lp W=530.00n L=60.00n
.ENDS

.SUBCKT DFFRX4H9R CK D Q QN RDN VDD VSS
MM45 QN net43 VSS VSS nm1p2_svt_lp W=430.00n L=60.00n m=2
MM3 net_0154 c net43 VSS nm1p2_svt_lp W=340.00n L=60.00n
MM44 net_0104 RDN VSS VSS nm1p2_svt_lp W=430.00n L=60.00n
MM42 VSS RDN net_0119 VSS nm1p2_svt_lp W=200.00n L=60.00n
MM39 s net43 net_099 VSS nm1p2_svt_lp W=330.00n L=60.00n m=2
MM40 net_099 RDN VSS VSS nm1p2_svt_lp W=330.00n L=60.00n m=2
MM30 c cn VSS VSS nm1p2_svt_lp W=430.00n L=60.00n
MM27 cn CK VSS VSS nm1p2_svt_lp W=290.00n L=60.00n
MM24 net48 cn net43 VSS nm1p2_svt_lp W=200.00n L=60.00n
MM23 VSS s net48 VSS nm1p2_svt_lp W=200.00n L=60.00n
MM19 Q s VSS VSS nm1p2_svt_lp W=430.00n L=60.00n m=2
MM12 net52 c pm VSS nm1p2_svt_lp W=200.00n L=60.00n
MM11 net_0119 net_0154 net52 VSS nm1p2_svt_lp W=200.00n L=60.00n
MM9 pm cn net69 VSS nm1p2_svt_lp W=430.00n L=60.00n
MM7 net69 D net_0104 VSS nm1p2_svt_lp W=430.00n L=60.00n
MM0 net_0154 pm VSS VSS nm1p2_svt_lp W=340.00n L=60.00n
MM46 QN net43 VDD VDD pm1p2_svt_lp W=650.00n L=60.00n m=2
MM43 pm RDN VDD VDD pm1p2_svt_lp W=300.00n L=60.00n
MM38 s net43 VDD VDD pm1p2_svt_lp W=550.00n L=60.00n
MM41 s RDN VDD VDD pm1p2_svt_lp W=300.00n L=60.00n
MM29 c cn VDD VDD pm1p2_svt_lp W=650.00n L=60.00n
MM28 cn CK VDD VDD pm1p2_svt_lp W=440.00n L=60.00n
MM26 VDD s net109 VDD pm1p2_svt_lp W=300.00n L=60.00n
MM25 net109 c net43 VDD pm1p2_svt_lp W=300.00n L=60.00n
MM20 Q s VDD VDD pm1p2_svt_lp W=650.00n L=60.00n m=2
MM4 net_0154 cn net43 VDD pm1p2_svt_lp W=530.00n L=60.00n
MM14 net117 cn pm VDD pm1p2_svt_lp W=300.00n L=60.00n
MM13 VDD net_0154 net117 VDD pm1p2_svt_lp W=300.00n L=60.00n
MM10 pm c net128 VDD pm1p2_svt_lp W=400.00n L=60.00n
MM8 net128 D VDD VDD pm1p2_svt_lp W=400.00n L=60.00n
MM1 net_0154 pm VDD VDD pm1p2_svt_lp W=530.00n L=60.00n
.ENDS

.SUBCKT DFFRQX1H9R CK D Q RDN VDD VSS
MM3 net_0154 c net43 VSS nm1p2_svt_lp W=290.00n L=60.00n
MM44 net_0104 RDN VSS VSS nm1p2_svt_lp W=290.00n L=60.00n
MM42 VSS RDN net_0119 VSS nm1p2_svt_lp W=200.00n L=60.00n
MM39 s net43 net_099 VSS nm1p2_svt_lp W=290.00n L=60.00n
MM40 net_099 RDN VSS VSS nm1p2_svt_lp W=290.00n L=60.00n
MM30 c cn VSS VSS nm1p2_svt_lp W=200.00n L=60.00n
MM27 cn CK VSS VSS nm1p2_svt_lp W=200.00n L=60.00n
MM24 net48 cn net43 VSS nm1p2_svt_lp W=200.00n L=60.00n
MM23 VSS s net48 VSS nm1p2_svt_lp W=200.00n L=60.00n
MM19 Q s VSS VSS nm1p2_svt_lp W=290.00n L=60.00n
MM12 net52 c pm VSS nm1p2_svt_lp W=200.00n L=60.00n
MM11 net_0119 net_0154 net52 VSS nm1p2_svt_lp W=200.00n L=60.00n
MM9 pm cn net69 VSS nm1p2_svt_lp W=290.00n L=60.00n
MM7 net69 D net_0104 VSS nm1p2_svt_lp W=290.00n L=60.00n
MM0 net_0154 pm VSS VSS nm1p2_svt_lp W=290.00n L=60.00n
MM43 pm RDN VDD VDD pm1p2_svt_lp W=300.00n L=60.00n
MM38 s net43 VDD VDD pm1p2_svt_lp W=300.00n L=60.00n
MM41 s RDN VDD VDD pm1p2_svt_lp W=300.00n L=60.00n
MM29 c cn VDD VDD pm1p2_svt_lp W=300.00n L=60.00n
MM28 cn CK VDD VDD pm1p2_svt_lp W=300.00n L=60.00n
MM26 VDD s net109 VDD pm1p2_svt_lp W=300.00n L=60.00n
MM25 net109 c net43 VDD pm1p2_svt_lp W=300.00n L=60.00n
MM20 Q s VDD VDD pm1p2_svt_lp W=440.00n L=60.00n
MM4 net_0154 cn net43 VDD pm1p2_svt_lp W=440.00n L=60.00n
MM14 net117 cn pm VDD pm1p2_svt_lp W=300.00n L=60.00n
MM13 VDD net_0154 net117 VDD pm1p2_svt_lp W=300.00n L=60.00n
MM10 pm c net128 VDD pm1p2_svt_lp W=300.00n L=60.00n
MM8 net128 D VDD VDD pm1p2_svt_lp W=300.00n L=60.00n
MM1 net_0154 pm VDD VDD pm1p2_svt_lp W=440.00n L=60.00n
.ENDS

.SUBCKT DFFRQX2H9R CK D Q RDN VDD VSS
MM3 net_0154 c net43 VSS nm1p2_svt_lp W=340.00n L=60.00n
MM44 net_0104 RDN VSS VSS nm1p2_svt_lp W=320.00n L=60.00n
MM42 VSS RDN net_0119 VSS nm1p2_svt_lp W=200.00n L=60.00n
MM39 s net43 net_099 VSS nm1p2_svt_lp W=390.00n L=60.00n
MM40 net_099 RDN VSS VSS nm1p2_svt_lp W=390.00n L=60.00n
MM30 c cn VSS VSS nm1p2_svt_lp W=200.00n L=60.00n
MM27 cn CK VSS VSS nm1p2_svt_lp W=200.00n L=60.00n
MM24 net48 cn net43 VSS nm1p2_svt_lp W=200.00n L=60.00n
MM23 VSS s net48 VSS nm1p2_svt_lp W=200.00n L=60.00n
MM19 Q s VSS VSS nm1p2_svt_lp W=430.00n L=60.00n
MM12 net52 c pm VSS nm1p2_svt_lp W=200.00n L=60.00n
MM11 net_0119 net_0154 net52 VSS nm1p2_svt_lp W=200.00n L=60.00n
MM9 pm cn net69 VSS nm1p2_svt_lp W=320.00n L=60.00n
MM7 net69 D net_0104 VSS nm1p2_svt_lp W=320.00n L=60.00n
MM0 net_0154 pm VSS VSS nm1p2_svt_lp W=340.00n L=60.00n
MM43 pm RDN VDD VDD pm1p2_svt_lp W=300.00n L=60.00n
MM38 s net43 VDD VDD pm1p2_svt_lp W=400.00n L=60.00n
MM41 s RDN VDD VDD pm1p2_svt_lp W=300.00n L=60.00n
MM29 c cn VDD VDD pm1p2_svt_lp W=300.00n L=60.00n
MM28 cn CK VDD VDD pm1p2_svt_lp W=300.00n L=60.00n
MM26 VDD s net109 VDD pm1p2_svt_lp W=300.00n L=60.00n
MM25 net109 c net43 VDD pm1p2_svt_lp W=300.00n L=60.00n
MM20 Q s VDD VDD pm1p2_svt_lp W=650.00n L=60.00n
MM4 net_0154 cn net43 VDD pm1p2_svt_lp W=530.00n L=60.00n
MM14 net117 cn pm VDD pm1p2_svt_lp W=300.00n L=60.00n
MM13 VDD net_0154 net117 VDD pm1p2_svt_lp W=300.00n L=60.00n
MM10 pm c net128 VDD pm1p2_svt_lp W=300.00n L=60.00n
MM8 net128 D VDD VDD pm1p2_svt_lp W=300.00n L=60.00n
MM1 net_0154 pm VDD VDD pm1p2_svt_lp W=530.00n L=60.00n
.ENDS

.SUBCKT DFFRQX4H9R CK D Q RDN VDD VSS
MM3 net_0154 c net43 VSS nm1p2_svt_lp W=340.00n L=60.00n
MM44 net_0104 RDN VSS VSS nm1p2_svt_lp W=430.00n L=60.00n
MM42 VSS RDN net_0119 VSS nm1p2_svt_lp W=200.00n L=60.00n
MM39 s net43 net_099 VSS nm1p2_svt_lp W=330.00n L=60.00n m=2
MM40 net_099 RDN VSS VSS nm1p2_svt_lp W=330.00n L=60.00n m=2
MM30 c cn VSS VSS nm1p2_svt_lp W=430.00n L=60.00n
MM27 cn CK VSS VSS nm1p2_svt_lp W=290.00n L=60.00n
MM24 net48 cn net43 VSS nm1p2_svt_lp W=200.00n L=60.00n
MM23 VSS s net48 VSS nm1p2_svt_lp W=200.00n L=60.00n
MM19 Q s VSS VSS nm1p2_svt_lp W=430.00n L=60.00n m=2
MM12 net52 c pm VSS nm1p2_svt_lp W=200.00n L=60.00n
MM11 net_0119 net_0154 net52 VSS nm1p2_svt_lp W=200.00n L=60.00n
MM9 pm cn net69 VSS nm1p2_svt_lp W=430.00n L=60.00n
MM7 net69 D net_0104 VSS nm1p2_svt_lp W=430.00n L=60.00n
MM0 net_0154 pm VSS VSS nm1p2_svt_lp W=340.00n L=60.00n
MM43 pm RDN VDD VDD pm1p2_svt_lp W=300.00n L=60.00n
MM38 s net43 VDD VDD pm1p2_svt_lp W=550.00n L=60.00n
MM41 s RDN VDD VDD pm1p2_svt_lp W=300.00n L=60.00n
MM29 c cn VDD VDD pm1p2_svt_lp W=650.00n L=60.00n
MM28 cn CK VDD VDD pm1p2_svt_lp W=440.00n L=60.00n
MM26 VDD s net109 VDD pm1p2_svt_lp W=300.00n L=60.00n
MM25 net109 c net43 VDD pm1p2_svt_lp W=300.00n L=60.00n
MM20 Q s VDD VDD pm1p2_svt_lp W=650.00n L=60.00n m=2
MM4 net_0154 cn net43 VDD pm1p2_svt_lp W=530.00n L=60.00n
MM14 net117 cn pm VDD pm1p2_svt_lp W=300.00n L=60.00n
MM13 VDD net_0154 net117 VDD pm1p2_svt_lp W=300.00n L=60.00n
MM10 pm c net128 VDD pm1p2_svt_lp W=400.00n L=60.00n
MM8 net128 D VDD VDD pm1p2_svt_lp W=400.00n L=60.00n
MM1 net_0154 pm VDD VDD pm1p2_svt_lp W=530.00n L=60.00n
.ENDS

.SUBCKT DFFNRX1H9R CKN D Q QN RDN VDD VSS
MM45 QN net43 VSS VSS nm1p2_svt_lp W=290.00n L=60.00n
MM3 net_0154 c net43 VSS nm1p2_svt_lp W=200.00n L=60.00n
MM44 net_0104 RDN VSS VSS nm1p2_svt_lp W=200.00n L=60.00n
MM42 VSS RDN net_0119 VSS nm1p2_svt_lp W=200.00n L=60.00n
MM39 s net43 net_099 VSS nm1p2_svt_lp W=290.00n L=60.00n
MM40 net_099 RDN VSS VSS nm1p2_svt_lp W=290.00n L=60.00n
MM30 cn c VSS VSS nm1p2_svt_lp W=200.00n L=60.00n
MM27 c CKN VSS VSS nm1p2_svt_lp W=200.00n L=60.00n
MM24 net48 cn net43 VSS nm1p2_svt_lp W=200.00n L=60.00n
MM23 VSS s net48 VSS nm1p2_svt_lp W=200.00n L=60.00n
MM19 Q s VSS VSS nm1p2_svt_lp W=290.00n L=60.00n
MM12 net52 c pm VSS nm1p2_svt_lp W=200.00n L=60.00n
MM11 net_0119 net_0154 net52 VSS nm1p2_svt_lp W=200.00n L=60.00n
MM9 pm cn net69 VSS nm1p2_svt_lp W=200.00n L=60.00n
MM7 net69 D net_0104 VSS nm1p2_svt_lp W=200.00n L=60.00n
MM0 net_0154 pm VSS VSS nm1p2_svt_lp W=200.00n L=60.00n
MM46 QN net43 VDD VDD pm1p2_svt_lp W=440.00n L=60.00n
MM43 pm RDN VDD VDD pm1p2_svt_lp W=300.00n L=60.00n
MM38 s net43 VDD VDD pm1p2_svt_lp W=300.00n L=60.00n
MM41 s RDN VDD VDD pm1p2_svt_lp W=300.00n L=60.00n
MM29 cn c VDD VDD pm1p2_svt_lp W=300.00n L=60.00n
MM28 c CKN VDD VDD pm1p2_svt_lp W=300.00n L=60.00n
MM26 VDD s net109 VDD pm1p2_svt_lp W=300.00n L=60.00n
MM25 net109 c net43 VDD pm1p2_svt_lp W=300.00n L=60.00n
MM20 Q s VDD VDD pm1p2_svt_lp W=440.00n L=60.00n
MM4 net_0154 cn net43 VDD pm1p2_svt_lp W=300.00n L=60.00n
MM14 net117 cn pm VDD pm1p2_svt_lp W=300.00n L=60.00n
MM13 VDD net_0154 net117 VDD pm1p2_svt_lp W=300.00n L=60.00n
MM10 pm c net128 VDD pm1p2_svt_lp W=300.00n L=60.00n
MM8 net128 D VDD VDD pm1p2_svt_lp W=300.00n L=60.00n
MM1 net_0154 pm VDD VDD pm1p2_svt_lp W=440.00n L=60.00n
.ENDS

.SUBCKT DFFNRX2H9R CKN D Q QN RDN VDD VSS
MM45 QN net43 VSS VSS nm1p2_svt_lp W=430.00n L=60.00n
MM3 net_0154 c net43 VSS nm1p2_svt_lp W=200.00n L=60.00n
MM44 net_0104 RDN VSS VSS nm1p2_svt_lp W=200.00n L=60.00n
MM42 VSS RDN net_0119 VSS nm1p2_svt_lp W=200.00n L=60.00n
MM39 s net43 net_099 VSS nm1p2_svt_lp W=300.00n L=60.00n
MM40 net_099 RDN VSS VSS nm1p2_svt_lp W=300.00n L=60.00n
MM30 cn c VSS VSS nm1p2_svt_lp W=200.00n L=60.00n
MM27 c CKN VSS VSS nm1p2_svt_lp W=200.00n L=60.00n
MM24 net48 cn net43 VSS nm1p2_svt_lp W=200.00n L=60.00n
MM23 VSS s net48 VSS nm1p2_svt_lp W=200.00n L=60.00n
MM19 Q s VSS VSS nm1p2_svt_lp W=430.00n L=60.00n
MM12 net52 c pm VSS nm1p2_svt_lp W=200.00n L=60.00n
MM11 net_0119 net_0154 net52 VSS nm1p2_svt_lp W=200.00n L=60.00n
MM9 pm cn net69 VSS nm1p2_svt_lp W=200.00n L=60.00n
MM7 net69 D net_0104 VSS nm1p2_svt_lp W=200.00n L=60.00n
MM0 net_0154 pm VSS VSS nm1p2_svt_lp W=200.00n L=60.00n
MM46 QN net43 VDD VDD pm1p2_svt_lp W=650.00n L=60.00n
MM43 pm RDN VDD VDD pm1p2_svt_lp W=300.00n L=60.00n
MM38 s net43 VDD VDD pm1p2_svt_lp W=300.00n L=60.00n
MM41 s RDN VDD VDD pm1p2_svt_lp W=300.00n L=60.00n
MM29 cn c VDD VDD pm1p2_svt_lp W=300.00n L=60.00n
MM28 c CKN VDD VDD pm1p2_svt_lp W=300.00n L=60.00n
MM26 VDD s net109 VDD pm1p2_svt_lp W=300.00n L=60.00n
MM25 net109 c net43 VDD pm1p2_svt_lp W=300.00n L=60.00n
MM20 Q s VDD VDD pm1p2_svt_lp W=650.00n L=60.00n
MM4 net_0154 cn net43 VDD pm1p2_svt_lp W=530.00n L=60.00n
MM14 net117 cn pm VDD pm1p2_svt_lp W=300.00n L=60.00n
MM13 VDD net_0154 net117 VDD pm1p2_svt_lp W=300.00n L=60.00n
MM10 pm c net128 VDD pm1p2_svt_lp W=300.00n L=60.00n
MM8 net128 D VDD VDD pm1p2_svt_lp W=300.00n L=60.00n
MM1 net_0154 pm VDD VDD pm1p2_svt_lp W=530.00n L=60.00n
.ENDS

.SUBCKT DFFNRX4H9R CKN D Q QN RDN VDD VSS
MM45 QN net43 VSS VSS nm1p2_svt_lp W=430.00n L=60.00n m=2
MM3 net_0154 c net43 VSS nm1p2_svt_lp W=360.00n L=60.00n
MM44 net_0104 RDN VSS VSS nm1p2_svt_lp W=200.00n L=60.00n
MM42 VSS RDN net_0119 VSS nm1p2_svt_lp W=190.00n L=60.00n
MM39 s net43 net_099 VSS nm1p2_svt_lp W=280.00n L=60.00n m=2
MM40 net_099 RDN VSS VSS nm1p2_svt_lp W=280.00n L=60.00n m=2
MM30 cn c VSS VSS nm1p2_svt_lp W=430.00n L=60.00n
MM27 c CKN VSS VSS nm1p2_svt_lp W=430.00n L=60.00n
MM24 net48 cn net43 VSS nm1p2_svt_lp W=200.00n L=60.00n
MM23 VSS s net48 VSS nm1p2_svt_lp W=200.00n L=60.00n
MM19 Q s VSS VSS nm1p2_svt_lp W=430.00n L=60.00n m=2
MM12 net52 c pm VSS nm1p2_svt_lp W=190.00n L=60.00n
MM11 net_0119 net_0154 net52 VSS nm1p2_svt_lp W=190.00n L=60.00n
MM9 pm cn net69 VSS nm1p2_svt_lp W=200.00n L=60.00n
MM7 net69 D net_0104 VSS nm1p2_svt_lp W=200.00n L=60.00n
MM0 net_0154 pm VSS VSS nm1p2_svt_lp W=260.00n L=60.00n
MM46 QN net43 VDD VDD pm1p2_svt_lp W=650.00n L=60.00n m=2
MM43 pm RDN VDD VDD pm1p2_svt_lp W=300.00n L=60.00n
MM38 s net43 VDD VDD pm1p2_svt_lp W=560n L=60.00n
MM41 s RDN VDD VDD pm1p2_svt_lp W=300.00n L=60.00n
MM29 cn c VDD VDD pm1p2_svt_lp W=650.00n L=60.00n
MM28 c CKN VDD VDD pm1p2_svt_lp W=650.00n L=60.00n
MM26 VDD s net109 VDD pm1p2_svt_lp W=300.00n L=60.00n
MM25 net109 c net43 VDD pm1p2_svt_lp W=300.00n L=60.00n
MM20 Q s VDD VDD pm1p2_svt_lp W=650.00n L=60.00n m=2
MM4 net_0154 cn net43 VDD pm1p2_svt_lp W=530.00n L=60.00n
MM14 net117 cn pm VDD pm1p2_svt_lp W=300.00n L=60.00n
MM13 VDD net_0154 net117 VDD pm1p2_svt_lp W=300.00n L=60.00n
MM10 pm c net128 VDD pm1p2_svt_lp W=300.00n L=60.00n
MM8 net128 D VDD VDD pm1p2_svt_lp W=300.00n L=60.00n
MM1 net_0154 pm VDD VDD pm1p2_svt_lp W=610.00n L=60.00n
.ENDS

.SUBCKT DFFTRX1H9R CK D Q QN RN VDD VSS
MM39 QN net43 VSS VSS nm1p2_svt_lp W=290.00n L=60.00n
MM3 m c net43 VSS nm1p2_svt_lp W=340.00n L=60.00n
MM30 c cn VSS VSS nm1p2_svt_lp W=300.00n L=60.00n
MM27 cn CK VSS VSS nm1p2_svt_lp W=300.00n L=60.00n
MM38 net_0162 RN VSS VSS nm1p2_svt_lp W=250.00n L=60.00n
MM24 net48 cn net43 VSS nm1p2_svt_lp W=200.00n L=60.00n
MM23 VSS s net48 VSS nm1p2_svt_lp W=200.00n L=60.00n
MM19 Q s VSS VSS nm1p2_svt_lp W=290.00n L=60.00n
MM17 s net43 VSS VSS nm1p2_svt_lp W=260.00n L=60.00n
MM12 net52 c pm VSS nm1p2_svt_lp W=200.00n L=60.00n
MM11 VSS m net52 VSS nm1p2_svt_lp W=200.00n L=60.00n
MM9 pm cn net69 VSS nm1p2_svt_lp W=250.00n L=60.00n
MM7 net69 D net_0162 VSS nm1p2_svt_lp W=250.00n L=60.00n
MM0 m pm VSS VSS nm1p2_svt_lp W=340.00n L=60.00n
MM40 QN net43 VDD VDD pm1p2_svt_lp W=440.00n L=60.00n
MM4 m cn net43 VDD pm1p2_svt_lp W=500.00n L=60.00n
MM29 c cn VDD VDD pm1p2_svt_lp W=450.00n L=60.00n
MM28 cn CK VDD VDD pm1p2_svt_lp W=450.00n L=60.00n
MM37 net128 RN VDD VDD pm1p2_svt_lp W=300.00n L=60.00n
MM26 VDD s net109 VDD pm1p2_svt_lp W=300.00n L=60.00n
MM25 net109 c net43 VDD pm1p2_svt_lp W=300.00n L=60.00n
MM20 Q s VDD VDD pm1p2_svt_lp W=440.00n L=60.00n
MM18 s net43 VDD VDD pm1p2_svt_lp W=390.00n L=60.00n
MM14 net117 cn pm VDD pm1p2_svt_lp W=300.00n L=60.00n
MM13 VDD m net117 VDD pm1p2_svt_lp W=300.00n L=60.00n
MM10 pm c net128 VDD pm1p2_svt_lp W=330.00n L=60.00n
MM8 net128 D VDD VDD pm1p2_svt_lp W=330.00n L=60.00n
MM1 m pm VDD VDD pm1p2_svt_lp W=500.00n L=60.00n
.ENDS

.SUBCKT DFFTRX2H9R CK D Q QN RN VDD VSS
MM39 QN net43 VSS VSS nm1p2_svt_lp W=430.00n L=60.00n
MM3 m c net43 VSS nm1p2_svt_lp W=360.00n L=60.00n
MM30 c cn VSS VSS nm1p2_svt_lp W=340.00n L=60.00n
MM27 cn CK VSS VSS nm1p2_svt_lp W=340.00n L=60.00n
MM38 net_0162 RN VSS VSS nm1p2_svt_lp W=340.00n L=60.00n
MM24 net48 cn net43 VSS nm1p2_svt_lp W=200.00n L=60.00n
MM23 VSS s net48 VSS nm1p2_svt_lp W=200.00n L=60.00n
MM19 Q s VSS VSS nm1p2_svt_lp W=430.00n L=60.00n
MM17 s net43 VSS VSS nm1p2_svt_lp W=300.00n L=60.00n
MM12 net52 c pm VSS nm1p2_svt_lp W=200.00n L=60.00n
MM11 VSS m net52 VSS nm1p2_svt_lp W=200.00n L=60.00n
MM9 pm cn net69 VSS nm1p2_svt_lp W=340.00n L=60.00n
MM7 net69 D net_0162 VSS nm1p2_svt_lp W=340.00n L=60.00n
MM0 m pm VSS VSS nm1p2_svt_lp W=350.00n L=60.00n
MM40 QN net43 VDD VDD pm1p2_svt_lp W=650.00n L=60.00n
MM4 m cn net43 VDD pm1p2_svt_lp W=540.00n L=60.00n
MM29 c cn VDD VDD pm1p2_svt_lp W=500.00n L=60.00n
MM28 cn CK VDD VDD pm1p2_svt_lp W=500.00n L=60.00n
MM37 net128 RN VDD VDD pm1p2_svt_lp W=300.00n L=60.00n
MM26 VDD s net109 VDD pm1p2_svt_lp W=300.00n L=60.00n
MM25 net109 c net43 VDD pm1p2_svt_lp W=300.00n L=60.00n
MM20 Q s VDD VDD pm1p2_svt_lp W=650.00n L=60.00n
MM18 s net43 VDD VDD pm1p2_svt_lp W=450.00n L=60.00n
MM14 net117 cn pm VDD pm1p2_svt_lp W=300.00n L=60.00n
MM13 VDD m net117 VDD pm1p2_svt_lp W=300.00n L=60.00n
MM10 pm c net128 VDD pm1p2_svt_lp W=440.00n L=60.00n
MM8 net128 D VDD VDD pm1p2_svt_lp W=440.00n L=60.00n
MM1 m pm VDD VDD pm1p2_svt_lp W=540.00n L=60.00n
.ENDS

.SUBCKT DFFTRX4H9R CK D Q QN RN VDD VSS
MM39 QN net43 VSS VSS nm1p2_svt_lp W=860.00n L=60.00n
MM3 m c net43 VSS nm1p2_svt_lp W=390.00n L=60.00n
MM30 c cn VSS VSS nm1p2_svt_lp W=290.00n L=60.00n
MM27 cn CK VSS VSS nm1p2_svt_lp W=360.00n L=60.00n
MM38 net_0162 RN VSS VSS nm1p2_svt_lp W=340.00n L=60.00n
MM24 net48 cn net43 VSS nm1p2_svt_lp W=200.00n L=60.00n
MM23 VSS s net48 VSS nm1p2_svt_lp W=200.00n L=60.00n
MM19 Q s VSS VSS nm1p2_svt_lp W=860.00n L=60.00n
MM17 s net43 VSS VSS nm1p2_svt_lp W=360.00n L=60.00n
MM12 net52 c pm VSS nm1p2_svt_lp W=300.00n L=60.00n
MM11 VSS m net52 VSS nm1p2_svt_lp W=300.00n L=60.00n
MM9 pm cn net69 VSS nm1p2_svt_lp W=340.00n L=60.00n
MM7 net69 D net_0162 VSS nm1p2_svt_lp W=340.00n L=60.00n
MM0 m pm VSS VSS nm1p2_svt_lp W=390.00n L=60.00n
MM40 QN net43 VDD VDD pm1p2_svt_lp W=1.3u L=60.00n
MM4 m cn net43 VDD pm1p2_svt_lp W=580.00n L=60.00n
MM29 c cn VDD VDD pm1p2_svt_lp W=440.0n L=60.00n
MM28 cn CK VDD VDD pm1p2_svt_lp W=540.0n L=60.00n
MM37 net128 RN VDD VDD pm1p2_svt_lp W=300.00n L=60.00n
MM26 VDD s net109 VDD pm1p2_svt_lp W=300.00n L=60.00n
MM25 net109 c net43 VDD pm1p2_svt_lp W=300.00n L=60.00n
MM20 Q s VDD VDD pm1p2_svt_lp W=1.3u L=60.00n
MM18 s net43 VDD VDD pm1p2_svt_lp W=540.00n L=60.00n
MM14 net117 cn pm VDD pm1p2_svt_lp W=450.00n L=60.00n
MM13 VDD m net117 VDD pm1p2_svt_lp W=450.00n L=60.00n
MM10 pm c net128 VDD pm1p2_svt_lp W=440.00n L=60.00n
MM8 net128 D VDD VDD pm1p2_svt_lp W=440.00n L=60.00n
MM1 m pm VDD VDD pm1p2_svt_lp W=580.00n L=60.00n
.ENDS

.SUBCKT DFFTRQX1H9R CK D Q RN VDD VSS
MM3 m c net43 VSS nm1p2_svt_lp W=340.00n L=60.00n
MM30 c cn VSS VSS nm1p2_svt_lp W=300.00n L=60.00n
MM27 cn CK VSS VSS nm1p2_svt_lp W=300.00n L=60.00n
MM38 net_0162 RN VSS VSS nm1p2_svt_lp W=250.00n L=60.00n
MM24 net48 cn net43 VSS nm1p2_svt_lp W=200.00n L=60.00n
MM23 VSS s net48 VSS nm1p2_svt_lp W=200.00n L=60.00n
MM19 Q s VSS VSS nm1p2_svt_lp W=290.00n L=60.00n
MM17 s net43 VSS VSS nm1p2_svt_lp W=260.00n L=60.00n
MM12 net52 c pm VSS nm1p2_svt_lp W=300.00n L=60.00n
MM11 VSS m net52 VSS nm1p2_svt_lp W=300.00n L=60.00n
MM9 pm cn net69 VSS nm1p2_svt_lp W=250.00n L=60.00n
MM7 net69 D net_0162 VSS nm1p2_svt_lp W=250.00n L=60.00n
MM0 m pm VSS VSS nm1p2_svt_lp W=340.00n L=60.00n
MM4 m cn net43 VDD pm1p2_svt_lp W=500.00n L=60.00n
MM29 c cn VDD VDD pm1p2_svt_lp W=450.00n L=60.00n
MM28 cn CK VDD VDD pm1p2_svt_lp W=450.00n L=60.00n
MM37 net128 RN VDD VDD pm1p2_svt_lp W=300.00n L=60.00n
MM26 VDD s net109 VDD pm1p2_svt_lp W=300.00n L=60.00n
MM25 net109 c net43 VDD pm1p2_svt_lp W=300.00n L=60.00n
MM20 Q s VDD VDD pm1p2_svt_lp W=440.00n L=60.00n
MM18 s net43 VDD VDD pm1p2_svt_lp W=390.00n L=60.00n
MM14 net117 cn pm VDD pm1p2_svt_lp W=450.00n L=60.00n
MM13 VDD m net117 VDD pm1p2_svt_lp W=450.00n L=60.00n
MM10 pm c net128 VDD pm1p2_svt_lp W=330.00n L=60.00n
MM8 net128 D VDD VDD pm1p2_svt_lp W=330.00n L=60.00n
MM1 m pm VDD VDD pm1p2_svt_lp W=500.00n L=60.00n
.ENDS

.SUBCKT DFFTRQX2H9R CK D Q RN VDD VSS
MM3 m c net43 VSS nm1p2_svt_lp W=360.00n L=60.00n
MM30 c cn VSS VSS nm1p2_svt_lp W=340.00n L=60.00n
MM27 cn CK VSS VSS nm1p2_svt_lp W=340.00n L=60.00n
MM38 net_0162 RN VSS VSS nm1p2_svt_lp W=270.00n L=60.00n
MM24 net48 cn net43 VSS nm1p2_svt_lp W=200.00n L=60.00n
MM23 VSS s net48 VSS nm1p2_svt_lp W=200.00n L=60.00n
MM19 Q s VSS VSS nm1p2_svt_lp W=430.00n L=60.00n
MM17 s net43 VSS VSS nm1p2_svt_lp W=300.00n L=60.00n
MM12 net52 c pm VSS nm1p2_svt_lp W=300.00n L=60.00n
MM11 VSS m net52 VSS nm1p2_svt_lp W=300.00n L=60.00n
MM9 pm cn net69 VSS nm1p2_svt_lp W=270.00n L=60.00n
MM7 net69 D net_0162 VSS nm1p2_svt_lp W=270.00n L=60.00n
MM0 m pm VSS VSS nm1p2_svt_lp W=350.00n L=60.00n
MM4 m cn net43 VDD pm1p2_svt_lp W=540.00n L=60.00n
MM29 c cn VDD VDD pm1p2_svt_lp W=500.00n L=60.00n
MM28 cn CK VDD VDD pm1p2_svt_lp W=500.00n L=60.00n
MM37 net128 RN VDD VDD pm1p2_svt_lp W=300.00n L=60.00n
MM26 VDD s net109 VDD pm1p2_svt_lp W=300.00n L=60.00n
MM25 net109 c net43 VDD pm1p2_svt_lp W=300.00n L=60.00n
MM20 Q s VDD VDD pm1p2_svt_lp W=650.00n L=60.00n
MM18 s net43 VDD VDD pm1p2_svt_lp W=450.00n L=60.00n
MM14 net117 cn pm VDD pm1p2_svt_lp W=450.00n L=60.00n
MM13 VDD m net117 VDD pm1p2_svt_lp W=450.00n L=60.00n
MM10 pm c net128 VDD pm1p2_svt_lp W=350.00n L=60.00n
MM8 net128 D VDD VDD pm1p2_svt_lp W=350.00n L=60.00n
MM1 m pm VDD VDD pm1p2_svt_lp W=540.00n L=60.00n
.ENDS

.SUBCKT DFFTRQX4H9R CK D Q RN VDD VSS
MM3 m c net43 VSS nm1p2_svt_lp W=360.00n L=60.00n
MM30 c cn VSS VSS nm1p2_svt_lp W=340.00n L=60.00n
MM27 cn CK VSS VSS nm1p2_svt_lp W=340.00n L=60.00n
MM38 net_0162 RN VSS VSS nm1p2_svt_lp W=270.00n L=60.00n
MM24 net48 cn net43 VSS nm1p2_svt_lp W=200.00n L=60.00n
MM23 VSS s net48 VSS nm1p2_svt_lp W=200.00n L=60.00n
MM19 Q s VSS VSS nm1p2_svt_lp W=860.00n L=60.00n
MM17 s net43 VSS VSS nm1p2_svt_lp W=340.00n L=60.00n
MM12 net52 c pm VSS nm1p2_svt_lp W=300.00n L=60.00n
MM11 VSS m net52 VSS nm1p2_svt_lp W=300.00n L=60.00n
MM9 pm cn net69 VSS nm1p2_svt_lp W=270.00n L=60.00n
MM7 net69 D net_0162 VSS nm1p2_svt_lp W=270.00n L=60.00n
MM0 m pm VSS VSS nm1p2_svt_lp W=360.00n L=60.00n
MM4 m cn net43 VDD pm1p2_svt_lp W=540.00n L=60.00n
MM29 c cn VDD VDD pm1p2_svt_lp W=500.0n L=60.00n
MM28 cn CK VDD VDD pm1p2_svt_lp W=500.0n L=60.00n
MM37 net128 RN VDD VDD pm1p2_svt_lp W=300.00n L=60.00n
MM26 VDD s net109 VDD pm1p2_svt_lp W=300.00n L=60.00n
MM25 net109 c net43 VDD pm1p2_svt_lp W=300.00n L=60.00n
MM20 Q s VDD VDD pm1p2_svt_lp W=1.3u L=60.00n
MM18 s net43 VDD VDD pm1p2_svt_lp W=500.00n L=60.00n
MM14 net117 cn pm VDD pm1p2_svt_lp W=450.00n L=60.00n
MM13 VDD m net117 VDD pm1p2_svt_lp W=450.00n L=60.00n
MM10 pm c net128 VDD pm1p2_svt_lp W=350.00n L=60.00n
MM8 net128 D VDD VDD pm1p2_svt_lp W=350.00n L=60.00n
MM1 m pm VDD VDD pm1p2_svt_lp W=540.00n L=60.00n
.ENDS

.SUBCKT DFFSX1H9R CK D Q QN SDN VDD VSS
MM3 net_0154 c net43 VSS nm1p2_svt_lp W=290.00n L=60.00n
MM48 net_0132 SDN VSS VSS nm1p2_svt_lp W=430.00n L=60.00n
MM49 QN net43 VSS VSS nm1p2_svt_lp W=290.00n L=60.00n
MM39 s net43 VSS VSS nm1p2_svt_lp W=200.00n L=60.00n
MM30 c cn VSS VSS nm1p2_svt_lp W=200.00n L=60.00n
MM27 cn CK VSS VSS nm1p2_svt_lp W=200.00n L=60.00n
MM24 net48 cn net43 VSS nm1p2_svt_lp W=200.00n L=60.00n
MM23 net_0132 s net48 VSS nm1p2_svt_lp W=200.00n L=60.00n
MM19 Q s VSS VSS nm1p2_svt_lp W=290.00n L=60.00n
MM12 net52 c pm VSS nm1p2_svt_lp W=200.00n L=60.00n
MM11 VSS net_0154 net52 VSS nm1p2_svt_lp W=200.00n L=60.00n
MM9 pm cn net69 VSS nm1p2_svt_lp W=200.00n L=60.00n
MM7 net69 D VSS VSS nm1p2_svt_lp W=200.00n L=60.00n
MM0 net_0154 pm net_0132 VSS nm1p2_svt_lp W=430.00n L=60.00n
MM43 net_0154 SDN VDD VDD pm1p2_svt_lp W=300.00n L=60.00n
MM50 QN net43 VDD VDD pm1p2_svt_lp W=440.00n L=60.00n
MM38 s net43 VDD VDD pm1p2_svt_lp W=360.00n L=60.00n
MM41 net43 SDN VDD VDD pm1p2_svt_lp W=300.00n L=60.00n
MM29 c cn VDD VDD pm1p2_svt_lp W=300.00n L=60.00n
MM28 cn CK VDD VDD pm1p2_svt_lp W=300.00n L=60.00n
MM26 VDD s net109 VDD pm1p2_svt_lp W=300.00n L=60.00n
MM25 net109 c net43 VDD pm1p2_svt_lp W=300.00n L=60.00n
MM20 Q s VDD VDD pm1p2_svt_lp W=440.00n L=60.00n
MM4 net_0154 cn net43 VDD pm1p2_svt_lp W=440.00n L=60.00n
MM14 net117 cn pm VDD pm1p2_svt_lp W=300.00n L=60.00n
MM13 VDD net_0154 net117 VDD pm1p2_svt_lp W=300.00n L=60.00n
MM10 pm c net128 VDD pm1p2_svt_lp W=300.00n L=60.00n
MM8 net128 D VDD VDD pm1p2_svt_lp W=300.00n L=60.00n
MM1 net_0154 pm VDD VDD pm1p2_svt_lp W=400.00n L=60.00n
.ENDS

.SUBCKT DFFSX2H9R CK D Q QN SDN VDD VSS
MM3 net_0154 c net43 VSS nm1p2_svt_lp W=430.00n L=60.00n
MM48 net_0132 SDN VSS VSS nm1p2_svt_lp W=430.00n L=60.00n
MM49 QN net43 VSS VSS nm1p2_svt_lp W=430.00n L=60.00n
MM39 s net43 VSS VSS nm1p2_svt_lp W=290.00n L=60.00n
MM30 c cn VSS VSS nm1p2_svt_lp W=290.00n L=60.00n
MM27 cn CK VSS VSS nm1p2_svt_lp W=200.00n L=60.00n
MM24 net48 cn net43 VSS nm1p2_svt_lp W=200.00n L=60.00n
MM23 net_0132 s net48 VSS nm1p2_svt_lp W=200.00n L=60.00n
MM19 Q s VSS VSS nm1p2_svt_lp W=430.00n L=60.00n
MM12 net52 c pm VSS nm1p2_svt_lp W=200.00n L=60.00n
MM11 VSS net_0154 net52 VSS nm1p2_svt_lp W=200.00n L=60.00n
MM9 pm cn net69 VSS nm1p2_svt_lp W=300.00n L=60.00n
MM7 net69 D VSS VSS nm1p2_svt_lp W=300.00n L=60.00n
MM0 net_0154 pm net_0132 VSS nm1p2_svt_lp W=430.00n L=60.00n
MM43 net_0154 SDN VDD VDD pm1p2_svt_lp W=300.00n L=60.00n
MM50 QN net43 VDD VDD pm1p2_svt_lp W=650.00n L=60.00n
MM38 s net43 VDD VDD pm1p2_svt_lp W=650.00n L=60.00n
MM41 net43 SDN VDD VDD pm1p2_svt_lp W=300.00n L=60.00n
MM29 c cn VDD VDD pm1p2_svt_lp W=440.00n L=60.00n
MM28 cn CK VDD VDD pm1p2_svt_lp W=300.00n L=60.00n
MM26 VDD s net109 VDD pm1p2_svt_lp W=300.00n L=60.00n
MM25 net109 c net43 VDD pm1p2_svt_lp W=300.00n L=60.00n
MM20 Q s VDD VDD pm1p2_svt_lp W=650.00n L=60.00n
MM4 net_0154 cn net43 VDD pm1p2_svt_lp W=650.00n L=60.00n
MM14 net117 cn pm VDD pm1p2_svt_lp W=300.00n L=60.00n
MM13 VDD net_0154 net117 VDD pm1p2_svt_lp W=300.00n L=60.00n
MM10 pm c net128 VDD pm1p2_svt_lp W=390.00n L=60.00n
MM8 net128 D VDD VDD pm1p2_svt_lp W=390.00n L=60.00n
MM1 net_0154 pm VDD VDD pm1p2_svt_lp W=650.00n L=60.00n
.ENDS

.SUBCKT DFFSX4H9R CK D Q QN SDN VDD VSS
MM3 net_0154 c net43 VSS nm1p2_svt_lp W=430.00n L=60.00n
MM48 net_0132 SDN VSS VSS nm1p2_svt_lp W=780.00n L=60.00n
MM49 QN net43 VSS VSS nm1p2_svt_lp W=860.00n L=60.00n
MM39 s net43 VSS VSS nm1p2_svt_lp W=430.00n L=60.00n
MM30 c cn VSS VSS nm1p2_svt_lp W=430.00n L=60.00n
MM27 cn CK VSS VSS nm1p2_svt_lp W=290.00n L=60.00n
MM24 net48 cn net43 VSS nm1p2_svt_lp W=200.00n L=60.00n
MM23 net_0132 s net48 VSS nm1p2_svt_lp W=200.00n L=60.00n
MM19 Q s VSS VSS nm1p2_svt_lp W=860.00n L=60.00n
MM12 net52 c pm VSS nm1p2_svt_lp W=200.00n L=60.00n
MM11 VSS net_0154 net52 VSS nm1p2_svt_lp W=200.00n L=60.00n
MM9 pm cn net69 VSS nm1p2_svt_lp W=380.00n L=60.00n
MM7 net69 D VSS VSS nm1p2_svt_lp W=380.00n L=60.00n
MM0 net_0154 pm net_0132 VSS nm1p2_svt_lp W=780.00n L=60.00n
MM43 net_0154 SDN VDD VDD pm1p2_svt_lp W=300.00n L=60.00n
MM50 QN net43 VDD VDD pm1p2_svt_lp W=1.3u L=60.00n
MM38 s net43 VDD VDD pm1p2_svt_lp W=650.00n L=60.00n
MM41 net43 SDN VDD VDD pm1p2_svt_lp W=300.00n L=60.00n
MM29 c cn VDD VDD pm1p2_svt_lp W=650.00n L=60.00n
MM28 cn CK VDD VDD pm1p2_svt_lp W=440.00n L=60.00n
MM26 VDD s net109 VDD pm1p2_svt_lp W=300.00n L=60.00n
MM25 net109 c net43 VDD pm1p2_svt_lp W=300.00n L=60.00n
MM20 Q s VDD VDD pm1p2_svt_lp W=1.3u L=60.00n
MM4 net_0154 cn net43 VDD pm1p2_svt_lp W=650.00n L=60.00n
MM14 net117 cn pm VDD pm1p2_svt_lp W=300.00n L=60.00n
MM13 VDD net_0154 net117 VDD pm1p2_svt_lp W=300.00n L=60.00n
MM10 pm c net128 VDD pm1p2_svt_lp W=570.00n L=60.00n
MM8 net128 D VDD VDD pm1p2_svt_lp W=570.00n L=60.00n
MM1 net_0154 pm VDD VDD pm1p2_svt_lp W=910.00n L=60.00n
.ENDS

.SUBCKT DFFNSX1H9R CKN D Q QN SDN VDD VSS
MM3 net_0154 c net43 VSS nm1p2_svt_lp W=200.00n L=60.00n
MM48 net_0132 SDN VSS VSS nm1p2_svt_lp W=290.00n L=60.00n
MM49 QN net43 VSS VSS nm1p2_svt_lp W=290.00n L=60.00n
MM39 s net43 VSS VSS nm1p2_svt_lp W=270.00n L=60.00n
MM30 cn c VSS VSS nm1p2_svt_lp W=200.00n L=60.00n
MM27 c CKN VSS VSS nm1p2_svt_lp W=200.00n L=60.00n
MM24 net48 cn net43 VSS nm1p2_svt_lp W=200.00n L=60.00n
MM23 net_0132 s net48 VSS nm1p2_svt_lp W=200.00n L=60.00n
MM19 Q s VSS VSS nm1p2_svt_lp W=290.00n L=60.00n
MM12 net52 c pm VSS nm1p2_svt_lp W=200.00n L=60.00n
MM11 VSS net_0154 net52 VSS nm1p2_svt_lp W=200.00n L=60.00n
MM9 pm cn net69 VSS nm1p2_svt_lp W=200.00n L=60.00n
MM7 net69 D VSS VSS nm1p2_svt_lp W=200.00n L=60.00n
MM0 net_0154 pm net_0132 VSS nm1p2_svt_lp W=290.00n L=60.00n
MM43 net_0154 SDN VDD VDD pm1p2_svt_lp W=300.00n L=60.00n
MM50 QN net43 VDD VDD pm1p2_svt_lp W=440.00n L=60.00n
MM38 s net43 VDD VDD pm1p2_svt_lp W=300.00n L=60.00n
MM41 net43 SDN VDD VDD pm1p2_svt_lp W=300.00n L=60.00n
MM29 cn c VDD VDD pm1p2_svt_lp W=300.00n L=60.00n
MM28 c CKN VDD VDD pm1p2_svt_lp W=300.00n L=60.00n
MM26 VDD s net109 VDD pm1p2_svt_lp W=300.00n L=60.00n
MM25 net109 c net43 VDD pm1p2_svt_lp W=300.00n L=60.00n
MM20 Q s VDD VDD pm1p2_svt_lp W=440.00n L=60.00n
MM4 net_0154 cn net43 VDD pm1p2_svt_lp W=300.00n L=60.00n
MM14 net117 cn pm VDD pm1p2_svt_lp W=300.00n L=60.00n
MM13 VDD net_0154 net117 VDD pm1p2_svt_lp W=300.00n L=60.00n
MM10 pm c net128 VDD pm1p2_svt_lp W=440.00n L=60.00n
MM8 net128 D VDD VDD pm1p2_svt_lp W=440.00n L=60.00n
MM1 net_0154 pm VDD VDD pm1p2_svt_lp W=300.00n L=60.00n
.ENDS

.SUBCKT DFFNSX2H9R CKN D Q QN SDN VDD VSS
MM3 net_0154 c net43 VSS nm1p2_svt_lp W=260.00n L=60.00n
MM48 net_0132 SDN VSS VSS nm1p2_svt_lp W=390.00n L=60.00n
MM49 QN net43 VSS VSS nm1p2_svt_lp W=430.00n L=60.00n
MM39 s net43 VSS VSS nm1p2_svt_lp W=350.00n L=60.00n
MM30 cn c VSS VSS nm1p2_svt_lp W=200.00n L=60.00n
MM27 c CKN VSS VSS nm1p2_svt_lp W=200.00n L=60.00n
MM24 net48 cn net43 VSS nm1p2_svt_lp W=200.00n L=60.00n
MM23 net_0132 s net48 VSS nm1p2_svt_lp W=200.00n L=60.00n
MM19 Q s VSS VSS nm1p2_svt_lp W=430.00n L=60.00n
MM12 net52 c pm VSS nm1p2_svt_lp W=200.00n L=60.00n
MM11 VSS net_0154 net52 VSS nm1p2_svt_lp W=200.00n L=60.00n
MM9 pm cn net69 VSS nm1p2_svt_lp W=200.00n L=60.00n
MM7 net69 D VSS VSS nm1p2_svt_lp W=200.00n L=60.00n
MM0 net_0154 pm net_0132 VSS nm1p2_svt_lp W=390.00n L=60.00n
MM43 net_0154 SDN VDD VDD pm1p2_svt_lp W=300.00n L=60.00n
MM50 QN net43 VDD VDD pm1p2_svt_lp W=650.00n L=60.00n
MM38 s net43 VDD VDD pm1p2_svt_lp W=400.00n L=60.00n
MM41 net43 SDN VDD VDD pm1p2_svt_lp W=300.00n L=60.00n
MM29 cn c VDD VDD pm1p2_svt_lp W=300.00n L=60.00n
MM28 c CKN VDD VDD pm1p2_svt_lp W=300.00n L=60.00n
MM26 VDD s net109 VDD pm1p2_svt_lp W=300.00n L=60.00n
MM25 net109 c net43 VDD pm1p2_svt_lp W=300.00n L=60.00n
MM20 Q s VDD VDD pm1p2_svt_lp W=650.00n L=60.00n
MM4 net_0154 cn net43 VDD pm1p2_svt_lp W=395.00n L=60.00n
MM14 net117 cn pm VDD pm1p2_svt_lp W=300.00n L=60.00n
MM13 VDD net_0154 net117 VDD pm1p2_svt_lp W=300.00n L=60.00n
MM10 pm c net128 VDD pm1p2_svt_lp W=440.00n L=60.00n
MM8 net128 D VDD VDD pm1p2_svt_lp W=440.00n L=60.00n
MM1 net_0154 pm VDD VDD pm1p2_svt_lp W=395.00n L=60.00n
.ENDS

.SUBCKT DFFNSX4H9R CKN D Q QN SDN VDD VSS
MM3 net_0154 c net43 VSS nm1p2_svt_lp W=430.00n L=60.00n
MM48 net_0132 SDN VSS VSS nm1p2_svt_lp W=430.00n L=60.00n
MM49 QN net43 VSS VSS nm1p2_svt_lp W=430.00n L=60.00n m=2
MM39 s net43 VSS VSS nm1p2_svt_lp W=390.00n L=60.00n
MM30 cn c VSS VSS nm1p2_svt_lp W=400.00n L=60.00n
MM27 c CKN VSS VSS nm1p2_svt_lp W=400.00n L=60.00n
MM24 net48 cn net43 VSS nm1p2_svt_lp W=200.00n L=60.00n
MM23 net_0132 s net48 VSS nm1p2_svt_lp W=200.00n L=60.00n
MM19 Q s VSS VSS nm1p2_svt_lp W=430.00n L=60.00n m=2
MM12 net52 c pm VSS nm1p2_svt_lp W=200.00n L=60.00n
MM11 VSS net_0154 net52 VSS nm1p2_svt_lp W=200.00n L=60.00n
MM9 pm cn net69 VSS nm1p2_svt_lp W=200.00n L=60.00n
MM7 net69 D VSS VSS nm1p2_svt_lp W=200.00n L=60.00n
MM0 net_0154 pm net_0132 VSS nm1p2_svt_lp W=430.00n L=60.00n
MM43 net_0154 SDN VDD VDD pm1p2_svt_lp W=300.00n L=60.00n
MM50 QN net43 VDD VDD pm1p2_svt_lp W=650.00n L=60.00n m=2
MM38 s net43 VDD VDD pm1p2_svt_lp W=580.00n L=60.00n
MM41 net43 SDN VDD VDD pm1p2_svt_lp W=300.00n L=60.00n
MM29 cn c VDD VDD pm1p2_svt_lp W=600.00n L=60.00n
MM28 c CKN VDD VDD pm1p2_svt_lp W=600.00n L=60.00n
MM26 VDD s net109 VDD pm1p2_svt_lp W=300.00n L=60.00n
MM25 net109 c net43 VDD pm1p2_svt_lp W=300.00n L=60.00n
MM20 Q s VDD VDD pm1p2_svt_lp W=650.00n L=60.00n m=2
MM4 net_0154 cn net43 VDD pm1p2_svt_lp W=650.00n L=60.00n
MM14 net117 cn pm VDD pm1p2_svt_lp W=300.00n L=60.00n
MM13 VDD net_0154 net117 VDD pm1p2_svt_lp W=300.00n L=60.00n
MM10 pm c net128 VDD pm1p2_svt_lp W=440.00n L=60.00n
MM8 net128 D VDD VDD pm1p2_svt_lp W=440.00n L=60.00n
MM1 net_0154 pm VDD VDD pm1p2_svt_lp W=620.00n L=60.00n
.ENDS

.SUBCKT DFFTSX1H9R CK D Q QN SN VDD VSS
MM39 QN net073 VSS VSS nm1p2_svt_lp W=290.00n L=60.00n
MM43 snn SN VSS VSS nm1p2_svt_lp W=200.00n L=60.00n
MM3 net049 c net073 VSS nm1p2_svt_lp W=270.00n L=60.00n
MM42 net69 snn VSS VSS nm1p2_svt_lp W=200.00n L=60.00n
MM30 c cn VSS VSS nm1p2_svt_lp W=290.00n L=60.00n
MM27 cn CK VSS VSS nm1p2_svt_lp W=200.00n L=60.00n
MM24 net48 cn net073 VSS nm1p2_svt_lp W=200.00n L=60.00n
MM23 VSS net063 net48 VSS nm1p2_svt_lp W=200.00n L=60.00n
MM19 Q net063 VSS VSS nm1p2_svt_lp W=290.00n L=60.00n
MM17 net063 net073 VSS VSS nm1p2_svt_lp W=240.00n L=60.00n
MM12 net52 c net051 VSS nm1p2_svt_lp W=200.00n L=60.00n
MM11 VSS net049 net52 VSS nm1p2_svt_lp W=200.00n L=60.00n
MM9 net051 cn net69 VSS nm1p2_svt_lp W=250.00n L=60.00n
MM7 net69 D VSS VSS nm1p2_svt_lp W=250.00n L=60.00n
MM0 net049 net051 VSS VSS nm1p2_svt_lp W=270.00n L=60.00n
MM41 net_0231 snn VDD VDD pm1p2_svt_lp W=440.00n L=60.00n
MM40 QN net073 VDD VDD pm1p2_svt_lp W=440.00n L=60.00n
MM44 snn SN VDD VDD pm1p2_svt_lp W=300.00n L=60.00n
MM4 net049 cn net073 VDD pm1p2_svt_lp W=400.00n L=60.00n
MM29 c cn VDD VDD pm1p2_svt_lp W=440.00n L=60.00n
MM28 cn CK VDD VDD pm1p2_svt_lp W=300.00n L=60.00n
MM26 VDD net063 net109 VDD pm1p2_svt_lp W=300.00n L=60.00n
MM25 net109 c net073 VDD pm1p2_svt_lp W=300.00n L=60.00n
MM20 Q net063 VDD VDD pm1p2_svt_lp W=440.00n L=60.00n
MM18 net063 net073 VDD VDD pm1p2_svt_lp W=360.00n L=60.00n
MM14 net117 cn net051 VDD pm1p2_svt_lp W=300.00n L=60.00n
MM13 VDD net049 net117 VDD pm1p2_svt_lp W=300.00n L=60.00n
MM10 net051 c net128 VDD pm1p2_svt_lp W=440.00n L=60.00n
MM8 net128 D net_0231 VDD pm1p2_svt_lp W=440.00n L=60.00n
MM1 net049 net051 VDD VDD pm1p2_svt_lp W=400.00n L=60.00n
.ENDS

.SUBCKT DFFTSX2H9R CK D Q QN SN VDD VSS
MM39 QN net073 VSS VSS nm1p2_svt_lp W=430.00n L=60.00n
MM43 snn SN VSS VSS nm1p2_svt_lp W=200.00n L=60.00n
MM3 net049 c net073 VSS nm1p2_svt_lp W=350.00n L=60.00n
MM42 net69 snn VSS VSS nm1p2_svt_lp W=200.00n L=60.00n
MM30 c cn VSS VSS nm1p2_svt_lp W=380.00n L=60.00n
MM27 cn CK VSS VSS nm1p2_svt_lp W=290.00n L=60.00n
MM24 net48 cn net073 VSS nm1p2_svt_lp W=200.00n L=60.00n
MM23 VSS net063 net48 VSS nm1p2_svt_lp W=200.00n L=60.00n
MM19 Q net063 VSS VSS nm1p2_svt_lp W=430.00n L=60.00n
MM17 net063 net073 VSS VSS nm1p2_svt_lp W=290.00n L=60.00n
MM12 net52 c net051 VSS nm1p2_svt_lp W=200.00n L=60.00n
MM11 VSS net049 net52 VSS nm1p2_svt_lp W=200.00n L=60.00n
MM9 net051 cn net69 VSS nm1p2_svt_lp W=260.00n L=60.00n
MM7 net69 D VSS VSS nm1p2_svt_lp W=260.00n L=60.00n
MM0 net049 net051 VSS VSS nm1p2_svt_lp W=350.00n L=60.00n
MM41 net_0231 snn VDD VDD pm1p2_svt_lp W=510.00n L=60.00n
MM40 QN net073 VDD VDD pm1p2_svt_lp W=650.00n L=60.00n
MM44 snn SN VDD VDD pm1p2_svt_lp W=300.00n L=60.00n
MM4 net049 cn net073 VDD pm1p2_svt_lp W=510.00n L=60.00n
MM29 c cn VDD VDD pm1p2_svt_lp W=570.00n L=60.00n
MM28 cn CK VDD VDD pm1p2_svt_lp W=440.00n L=60.00n
MM26 VDD net063 net109 VDD pm1p2_svt_lp W=300.00n L=60.00n
MM25 net109 c net073 VDD pm1p2_svt_lp W=300.00n L=60.00n
MM20 Q net063 VDD VDD pm1p2_svt_lp W=650.00n L=60.00n
MM18 net063 net073 VDD VDD pm1p2_svt_lp W=440.00n L=60.00n
MM14 net117 cn net051 VDD pm1p2_svt_lp W=300.00n L=60.00n
MM13 VDD net049 net117 VDD pm1p2_svt_lp W=300.00n L=60.00n
MM10 net051 c net128 VDD pm1p2_svt_lp W=510.00n L=60.00n
MM8 net128 D net_0231 VDD pm1p2_svt_lp W=510.00n L=60.00n
MM1 net049 net051 VDD VDD pm1p2_svt_lp W=510.00n L=60.00n
.ENDS

.SUBCKT DFFTSX4H9R CK D Q QN SN VDD VSS
MM39 QN net073 VSS VSS nm1p2_svt_lp W=860.00n L=60.00n
MM43 snn SN VSS VSS nm1p2_svt_lp W=200.00n L=60.00n
MM3 net049 c net073 VSS nm1p2_svt_lp W=340.00n L=60.00n
MM42 net69 snn VSS VSS nm1p2_svt_lp W=250.00n L=60.00n
MM30 c cn VSS VSS nm1p2_svt_lp W=430.00n L=60.00n
MM27 cn CK VSS VSS nm1p2_svt_lp W=430.00n L=60.00n
MM24 net48 cn net073 VSS nm1p2_svt_lp W=200.00n L=60.00n
MM23 VSS net063 net48 VSS nm1p2_svt_lp W=200.00n L=60.00n
MM19 Q net063 VSS VSS nm1p2_svt_lp W=860.00n L=60.00n
MM17 net063 net073 VSS VSS nm1p2_svt_lp W=430.00n L=60.00n
MM12 net52 c net051 VSS nm1p2_svt_lp W=200.00n L=60.00n
MM11 VSS net049 net52 VSS nm1p2_svt_lp W=200.00n L=60.00n
MM9 net051 cn net69 VSS nm1p2_svt_lp W=270.00n L=60.00n
MM7 net69 D VSS VSS nm1p2_svt_lp W=270.00n L=60.00n
MM0 net049 net051 VSS VSS nm1p2_svt_lp W=340.00n L=60.00n
MM41 net_0231 snn VDD VDD pm1p2_svt_lp W=510.00n L=60.00n
MM40 QN net073 VDD VDD pm1p2_svt_lp W=1.3u L=60.00n
MM44 snn SN VDD VDD pm1p2_svt_lp W=300.00n L=60.00n
MM4 net049 cn net073 VDD pm1p2_svt_lp W=510.00n L=60.00n
MM29 c cn VDD VDD pm1p2_svt_lp W=650.00n L=60.00n
MM28 cn CK VDD VDD pm1p2_svt_lp W=650.00n L=60.00n
MM26 VDD net063 net109 VDD pm1p2_svt_lp W=300.00n L=60.00n
MM25 net109 c net073 VDD pm1p2_svt_lp W=300.00n L=60.00n
MM20 Q net063 VDD VDD pm1p2_svt_lp W=1.3u L=60.00n
MM18 net063 net073 VDD VDD pm1p2_svt_lp W=490.00n L=60.00n
MM14 net117 cn net051 VDD pm1p2_svt_lp W=300.00n L=60.00n
MM13 VDD net049 net117 VDD pm1p2_svt_lp W=300.00n L=60.00n
MM10 net051 c net128 VDD pm1p2_svt_lp W=510.00n L=60.00n
MM8 net128 D net_0231 VDD pm1p2_svt_lp W=510.00n L=60.00n
MM1 net049 net051 VDD VDD pm1p2_svt_lp W=510.00n L=60.00n
.ENDS

.SUBCKT DFFRSX1H9R CK D Q QN RDN SDN VDD VSS
MM45 R RDN VSS VSS nm1p2_svt_lp W=200.00n L=60.00n
MM47 net_0154 R net_0132 VSS nm1p2_svt_lp W=200.00n L=60.00n
MM3 net_0154 c net43 VSS nm1p2_svt_lp W=290.00n L=60.00n
MM48 net_0132 SDN VSS VSS nm1p2_svt_lp W=290.00n L=60.00n
MM49 QN net43 VSS VSS nm1p2_svt_lp W=290.00n L=60.00n
MM39 s net43 VSS VSS nm1p2_svt_lp W=290.00n L=60.00n
MM40 net43 R net_0132 VSS nm1p2_svt_lp W=200.00n L=60.00n
MM30 c cn VSS VSS nm1p2_svt_lp W=200.00n L=60.00n
MM27 cn CK VSS VSS nm1p2_svt_lp W=200.00n L=60.00n
MM24 net48 cn net43 VSS nm1p2_svt_lp W=200.00n L=60.00n
MM23 net_0132 s net48 VSS nm1p2_svt_lp W=200.00n L=60.00n
MM19 Q s VSS VSS nm1p2_svt_lp W=290.00n L=60.00n
MM12 net52 c pm VSS nm1p2_svt_lp W=200.00n L=60.00n
MM11 VSS net_0154 net52 VSS nm1p2_svt_lp W=200.00n L=60.00n
MM9 pm cn net69 VSS nm1p2_svt_lp W=220.00n L=60.00n
MM7 net69 D VSS VSS nm1p2_svt_lp W=220.00n L=60.00n
MM0 net_0154 pm net_0132 VSS nm1p2_svt_lp W=360.00n L=60.00n
MM46 R RDN VDD VDD pm1p2_svt_lp W=300.00n L=60.00n
MM43 net_0154 SDN VDD VDD pm1p2_svt_lp W=300.00n L=60.00n
MM50 QN net43 VDD VDD pm1p2_svt_lp W=440.00n L=60.00n
MM38 s net43 VDD VDD pm1p2_svt_lp W=400.00n L=60.00n
MM41 net43 SDN VDD VDD pm1p2_svt_lp W=300.00n L=60.00n
MM44 net_0243 R VDD VDD pm1p2_svt_lp W=440.00n L=60.00n
MM29 c cn VDD VDD pm1p2_svt_lp W=300.00n L=60.00n
MM28 cn CK VDD VDD pm1p2_svt_lp W=300.00n L=60.00n
MM26 net_0243 s net109 VDD pm1p2_svt_lp W=300.00n L=60.00n
MM25 net109 c net43 VDD pm1p2_svt_lp W=300.00n L=60.00n
MM20 Q s VDD VDD pm1p2_svt_lp W=440.00n L=60.00n
MM4 net_0154 cn net43 VDD pm1p2_svt_lp W=440.00n L=60.00n
MM14 net117 cn pm VDD pm1p2_svt_lp W=300.00n L=60.00n
MM13 VDD net_0154 net117 VDD pm1p2_svt_lp W=300.00n L=60.00n
MM10 pm c net128 VDD pm1p2_svt_lp W=300.00n L=60.00n
MM8 net128 D VDD VDD pm1p2_svt_lp W=300.00n L=60.00n
MM1 net_0154 pm net_0243 VDD pm1p2_svt_lp W=440.00n L=60.00n
.ENDS

.SUBCKT DFFRSX2H9R CK D Q QN RDN SDN VDD VSS
MM45 R RDN VSS VSS nm1p2_svt_lp W=200.00n L=60.00n
MM47 net_0154 R net_0132 VSS nm1p2_svt_lp W=360.00n L=60.00n
MM3 net_0154 c net43 VSS nm1p2_svt_lp W=380.00n L=60.00n
MM48 net_0132 SDN VSS VSS nm1p2_svt_lp W=400.00n L=60.00n
MM49 QN net43 VSS VSS nm1p2_svt_lp W=430.00n L=60.00n
MM39 s net43 VSS VSS nm1p2_svt_lp W=390.00n L=60.00n
MM40 net43 R net_0132 VSS nm1p2_svt_lp W=350.00n L=60.00n
MM30 c cn VSS VSS nm1p2_svt_lp W=200.00n L=60.00n
MM27 cn CK VSS VSS nm1p2_svt_lp W=200.00n L=60.00n
MM24 net48 cn net43 VSS nm1p2_svt_lp W=200.00n L=60.00n
MM23 net_0132 s net48 VSS nm1p2_svt_lp W=200.00n L=60.00n
MM19 Q s VSS VSS nm1p2_svt_lp W=430.00n L=60.00n
MM12 net52 c pm VSS nm1p2_svt_lp W=200.00n L=60.00n
MM11 VSS net_0154 net52 VSS nm1p2_svt_lp W=200.00n L=60.00n
MM9 pm cn net69 VSS nm1p2_svt_lp W=220.00n L=60.00n
MM7 net69 D VSS VSS nm1p2_svt_lp W=220.00n L=60.00n
MM0 net_0154 pm net_0132 VSS nm1p2_svt_lp W=400.00n L=60.00n
MM46 R RDN VDD VDD pm1p2_svt_lp W=300.00n L=60.00n
MM43 net_0154 SDN VDD VDD pm1p2_svt_lp W=300.00n L=60.00n
MM50 QN net43 VDD VDD pm1p2_svt_lp W=650.00n L=60.00n
MM38 s net43 VDD VDD pm1p2_svt_lp W=500.00n L=60.00n
MM41 net43 SDN VDD VDD pm1p2_svt_lp W=300.00n L=60.00n
MM44 net_0243 R VDD VDD pm1p2_svt_lp W=600.00n L=60.00n
MM29 c cn VDD VDD pm1p2_svt_lp W=300.00n L=60.00n
MM28 cn CK VDD VDD pm1p2_svt_lp W=300.00n L=60.00n
MM26 net_0243 s net109 VDD pm1p2_svt_lp W=300.00n L=60.00n
MM25 net109 c net43 VDD pm1p2_svt_lp W=300.00n L=60.00n
MM20 Q s VDD VDD pm1p2_svt_lp W=650.00n L=60.00n
MM4 net_0154 cn net43 VDD pm1p2_svt_lp W=600.00n L=60.00n
MM14 net117 cn pm VDD pm1p2_svt_lp W=300.00n L=60.00n
MM13 VDD net_0154 net117 VDD pm1p2_svt_lp W=300.00n L=60.00n
MM10 pm c net128 VDD pm1p2_svt_lp W=300.00n L=60.00n
MM8 net128 D VDD VDD pm1p2_svt_lp W=300.00n L=60.00n
MM1 net_0154 pm net_0243 VDD pm1p2_svt_lp W=600.00n L=60.00n
.ENDS

.SUBCKT DFFRSX4H9R CK D Q QN RDN SDN VDD VSS
MM45 R RDN VSS VSS nm1p2_svt_lp W=200.00n L=60.00n
MM47 net_0154 R net_0132 VSS nm1p2_svt_lp W=360.00n L=60.00n
MM3 net_0154 c net43 VSS nm1p2_svt_lp W=410.00n L=60.00n
MM48 net_0132 SDN VSS VSS nm1p2_svt_lp W=430.00n L=60.00n m=2
MM49 QN net43 VSS VSS nm1p2_svt_lp W=430.00n L=60.00n m=2
MM39 s net43 VSS VSS nm1p2_svt_lp W=320.00n L=60.00n m=2
MM40 net43 R net_0132 VSS nm1p2_svt_lp W=350.00n L=60.00n
MM30 c cn VSS VSS nm1p2_svt_lp W=430.00n L=60.00n
MM27 cn CK VSS VSS nm1p2_svt_lp W=430.00n L=60.00n
MM24 net48 cn net43 VSS nm1p2_svt_lp W=200.00n L=60.00n
MM23 net_0132 s net48 VSS nm1p2_svt_lp W=200.00n L=60.00n
MM19 Q s VSS VSS nm1p2_svt_lp W=430.00n L=60.00n m=2
MM12 net52 c pm VSS nm1p2_svt_lp W=200.00n L=60.00n
MM11 VSS net_0154 net52 VSS nm1p2_svt_lp W=200.00n L=60.00n
MM9 pm cn net69 VSS nm1p2_svt_lp W=220.00n L=60.00n
MM7 net69 D VSS VSS nm1p2_svt_lp W=220.00n L=60.00n
MM0 net_0154 pm net_0132 VSS nm1p2_svt_lp W=430.00n L=60.00n
MM46 R RDN VDD VDD pm1p2_svt_lp W=300.00n L=60.00n
MM43 net_0154 SDN VDD VDD pm1p2_svt_lp W=300.00n L=60.00n
MM50 QN net43 VDD VDD pm1p2_svt_lp W=650.00n L=60.00n m=2
MM38 s net43 VDD VDD pm1p2_svt_lp W=600.00n L=60.00n
MM41 net43 SDN VDD VDD pm1p2_svt_lp W=300.00n L=60.00n
MM44 net_0243 R VDD VDD pm1p2_svt_lp W=650.00n L=60.00n m=2
MM29 c cn VDD VDD pm1p2_svt_lp W=650.00n L=60.00n
MM28 cn CK VDD VDD pm1p2_svt_lp W=650.00n L=60.00n
MM26 net_0243 s net109 VDD pm1p2_svt_lp W=290.00n L=60.00n
MM25 net109 c net43 VDD pm1p2_svt_lp W=290.00n L=60.00n
MM20 Q s VDD VDD pm1p2_svt_lp W=650.00n L=60.00n m=2
MM4 net_0154 cn net43 VDD pm1p2_svt_lp W=630.00n L=60.00n
MM14 net117 cn pm VDD pm1p2_svt_lp W=300.00n L=60.00n
MM13 VDD net_0154 net117 VDD pm1p2_svt_lp W=300.00n L=60.00n
MM10 pm c net128 VDD pm1p2_svt_lp W=300.00n L=60.00n
MM8 net128 D VDD VDD pm1p2_svt_lp W=300.00n L=60.00n
MM1 net_0154 pm net_0243 VDD pm1p2_svt_lp W=650.00n L=60.00n
.ENDS

.SUBCKT DFFNRSX1H9R CKN D Q QN RDN SDN VDD VSS
MM45 R RDN VSS VSS nm1p2_svt_lp W=200.00n L=60.00n
MM47 net_0154 R net_0132 VSS nm1p2_svt_lp W=200.00n L=60.00n
MM3 net_0154 c net43 VSS nm1p2_svt_lp W=200.00n L=60.00n
MM48 net_0132 SDN VSS VSS nm1p2_svt_lp W=200.00n L=60.00n
MM49 QN net43 VSS VSS nm1p2_svt_lp W=290.00n L=60.00n
MM39 s net43 VSS VSS nm1p2_svt_lp W=290.00n L=60.00n
MM40 net43 R net_0132 VSS nm1p2_svt_lp W=200.00n L=60.00n
MM30 cn c VSS VSS nm1p2_svt_lp W=290.00n L=60.00n
MM27 c CKN VSS VSS nm1p2_svt_lp W=200.00n L=60.00n
MM24 net48 cn net43 VSS nm1p2_svt_lp W=200.00n L=60.00n
MM23 net_0132 s net48 VSS nm1p2_svt_lp W=200.00n L=60.00n
MM19 Q s VSS VSS nm1p2_svt_lp W=290.00n L=60.00n
MM12 net52 c pm VSS nm1p2_svt_lp W=200.00n L=60.00n
MM11 VSS net_0154 net52 VSS nm1p2_svt_lp W=200.00n L=60.00n
MM9 pm cn net69 VSS nm1p2_svt_lp W=200.00n L=60.00n
MM7 net69 D VSS VSS nm1p2_svt_lp W=200.00n L=60.00n
MM0 net_0154 pm net_0132 VSS nm1p2_svt_lp W=200.00n L=60.00n
MM46 R RDN VDD VDD pm1p2_svt_lp W=300.00n L=60.00n
MM43 net_0154 SDN VDD VDD pm1p2_svt_lp W=300.00n L=60.00n
MM50 QN net43 VDD VDD pm1p2_svt_lp W=440.00n L=60.00n
MM38 s net43 VDD VDD pm1p2_svt_lp W=380.00n L=60.00n
MM41 net43 SDN VDD VDD pm1p2_svt_lp W=300.00n L=60.00n
MM44 net_0243 R VDD VDD pm1p2_svt_lp W=440.00n L=60.00n
MM29 cn c VDD VDD pm1p2_svt_lp W=440.00n L=60.00n
MM28 c CKN VDD VDD pm1p2_svt_lp W=300.00n L=60.00n
MM26 net_0243 s net109 VDD pm1p2_svt_lp W=300.00n L=60.00n
MM25 net109 c net43 VDD pm1p2_svt_lp W=300.00n L=60.00n
MM20 Q s VDD VDD pm1p2_svt_lp W=440.00n L=60.00n
MM4 net_0154 cn net43 VDD pm1p2_svt_lp W=440.00n L=60.00n
MM14 net117 cn pm VDD pm1p2_svt_lp W=300.00n L=60.00n
MM13 VDD net_0154 net117 VDD pm1p2_svt_lp W=300.00n L=60.00n
MM10 pm c net128 VDD pm1p2_svt_lp W=350.00n L=60.00n
MM8 net128 D VDD VDD pm1p2_svt_lp W=350.00n L=60.00n
MM1 net_0154 pm net_0243 VDD pm1p2_svt_lp W=440.00n L=60.00n
.ENDS

.SUBCKT DFFNRSX2H9R CKN D Q QN RDN SDN VDD VSS
MM45 R RDN VSS VSS nm1p2_svt_lp W=200.00n L=60.00n
MM47 net_0154 R net_0132 VSS nm1p2_svt_lp W=250.00n L=60.00n
MM3 net_0154 c net43 VSS nm1p2_svt_lp W=260.00n L=60.00n
MM48 net_0132 SDN VSS VSS nm1p2_svt_lp W=240.00n L=60.00n
MM49 QN net43 VSS VSS nm1p2_svt_lp W=430.00n L=60.00n
MM39 s net43 VSS VSS nm1p2_svt_lp W=250.00n L=60.00n
MM40 net43 R net_0132 VSS nm1p2_svt_lp W=250.00n L=60.00n
MM30 cn c VSS VSS nm1p2_svt_lp W=290.00n L=60.00n
MM27 c CKN VSS VSS nm1p2_svt_lp W=430.00n L=60.00n
MM24 net48 cn net43 VSS nm1p2_svt_lp W=200.00n L=60.00n
MM23 net_0132 s net48 VSS nm1p2_svt_lp W=200.00n L=60.00n
MM19 Q s VSS VSS nm1p2_svt_lp W=430.00n L=60.00n
MM12 net52 c pm VSS nm1p2_svt_lp W=200.00n L=60.00n
MM11 VSS net_0154 net52 VSS nm1p2_svt_lp W=200.00n L=60.00n
MM9 pm cn net69 VSS nm1p2_svt_lp W=200.00n L=60.00n
MM7 net69 D VSS VSS nm1p2_svt_lp W=200.00n L=60.00n
MM0 net_0154 pm net_0132 VSS nm1p2_svt_lp W=240.00n L=60.00n
MM46 R RDN VDD VDD pm1p2_svt_lp W=300.00n L=60.00n
MM43 net_0154 SDN VDD VDD pm1p2_svt_lp W=300.00n L=60.00n
MM50 QN net43 VDD VDD pm1p2_svt_lp W=650.00n L=60.00n
MM38 s net43 VDD VDD pm1p2_svt_lp W=320.00n L=60.00n
MM41 net43 SDN VDD VDD pm1p2_svt_lp W=300.00n L=60.00n
MM44 net_0243 R VDD VDD pm1p2_svt_lp W=460.00n L=60.00n m=1
MM29 cn c VDD VDD pm1p2_svt_lp W=440.00n L=60.00n
MM28 c CKN VDD VDD pm1p2_svt_lp W=650.00n L=60.00n
MM26 net_0243 s net109 VDD pm1p2_svt_lp W=300.00n L=60.00n
MM25 net109 c net43 VDD pm1p2_svt_lp W=300.00n L=60.00n
MM20 Q s VDD VDD pm1p2_svt_lp W=650.00n L=60.00n
MM4 net_0154 cn net43 VDD pm1p2_svt_lp W=440.00n L=60.00n
MM14 net117 cn pm VDD pm1p2_svt_lp W=300.00n L=60.00n
MM13 VDD net_0154 net117 VDD pm1p2_svt_lp W=300.00n L=60.00n
MM10 pm c net128 VDD pm1p2_svt_lp W=400.00n L=60.00n
MM8 net128 D VDD VDD pm1p2_svt_lp W=400.00n L=60.00n
MM1 net_0154 pm net_0243 VDD pm1p2_svt_lp W=580.00n L=60.00n
.ENDS

.SUBCKT DFFNRSX4H9R CKN D Q QN RDN SDN VDD VSS
MM45 R RDN VSS VSS nm1p2_svt_lp W=200.00n L=60.00n
MM47 net_0154 R net_0132 VSS nm1p2_svt_lp W=200.00n L=60.00n
MM3 net_0154 c net43 VSS nm1p2_svt_lp W=260.00n L=60.00n
MM48 net_0132 SDN VSS VSS nm1p2_svt_lp W=240.00n L=60.00n
MM49 QN net43 VSS VSS nm1p2_svt_lp W=430.00n L=60.00n m=2
MM39 s net43 VSS VSS nm1p2_svt_lp W=430.00n L=60.00n
MM40 net43 R net_0132 VSS nm1p2_svt_lp W=200.00n L=60.00n
MM30 cn c VSS VSS nm1p2_svt_lp W=420.00n L=60.00n
MM27 c CKN VSS VSS nm1p2_svt_lp W=430.00n L=60.00n
MM24 net48 cn net43 VSS nm1p2_svt_lp W=200.00n L=60.00n
MM23 net_0132 s net48 VSS nm1p2_svt_lp W=200.00n L=60.00n
MM19 Q s VSS VSS nm1p2_svt_lp W=430.00n L=60.00n m=2
MM12 net52 c pm VSS nm1p2_svt_lp W=200.00n L=60.00n
MM11 VSS net_0154 net52 VSS nm1p2_svt_lp W=200.00n L=60.00n
MM9 pm cn net69 VSS nm1p2_svt_lp W=200.00n L=60.00n
MM7 net69 D VSS VSS nm1p2_svt_lp W=200.00n L=60.00n
MM0 net_0154 pm net_0132 VSS nm1p2_svt_lp W=240.00n L=60.00n
MM46 R RDN VDD VDD pm1p2_svt_lp W=300.00n L=60.00n
MM43 net_0154 SDN VDD VDD pm1p2_svt_lp W=300.00n L=60.00n
MM50 QN net43 VDD VDD pm1p2_svt_lp W=650.00n L=60.00n m=2
MM38 s net43 VDD VDD pm1p2_svt_lp W=470.00n L=60.00n
MM41 net43 SDN VDD VDD pm1p2_svt_lp W=300.00n L=60.00n
MM44 net_0243 R VDD VDD pm1p2_svt_lp W=460n L=60.00n
MM29 cn c VDD VDD pm1p2_svt_lp W=640.00n L=60.00n
MM28 c CKN VDD VDD pm1p2_svt_lp W=650.00n L=60.00n
MM26 net_0243 s net109 VDD pm1p2_svt_lp W=300.00n L=60.00n
MM25 net109 c net43 VDD pm1p2_svt_lp W=300.00n L=60.00n
MM20 Q s VDD VDD pm1p2_svt_lp W=650.00n L=60.00n m=2
MM4 net_0154 cn net43 VDD pm1p2_svt_lp W=430.00n L=60.00n
MM14 net117 cn pm VDD pm1p2_svt_lp W=300.00n L=60.00n
MM13 VDD net_0154 net117 VDD pm1p2_svt_lp W=300.00n L=60.00n
MM10 pm c net128 VDD pm1p2_svt_lp W=400.00n L=60.00n
MM8 net128 D VDD VDD pm1p2_svt_lp W=400.00n L=60.00n
MM1 net_0154 pm net_0243 VDD pm1p2_svt_lp W=620.00n L=60.00n
.ENDS

.SUBCKT DFFTRSX1H9R CK D Q QN RN SN VDD VSS
MM43 snn SN VSS VSS nm1p2_svt_lp W=300.00n L=60.00n
MM39 QN net073 VSS VSS nm1p2_svt_lp W=290.00n L=60.00n
MM3 net049 c net073 VSS nm1p2_svt_lp W=340.00n L=60.00n
MM42 net69 snn net_0162 VSS nm1p2_svt_lp W=250.00n L=60.00n
MM30 c cn VSS VSS nm1p2_svt_lp W=300.00n L=60.00n
MM27 cn CK VSS VSS nm1p2_svt_lp W=300.00n L=60.00n
MM38 net_0162 RN VSS VSS nm1p2_svt_lp W=250.00n L=60.00n
MM24 net48 cn net073 VSS nm1p2_svt_lp W=200.00n L=60.00n
MM23 VSS net063 net48 VSS nm1p2_svt_lp W=200.00n L=60.00n
MM19 Q net063 VSS VSS nm1p2_svt_lp W=290.00n L=60.00n
MM17 net063 net073 VSS VSS nm1p2_svt_lp W=260.00n L=60.00n
MM12 net52 c net051 VSS nm1p2_svt_lp W=200.00n L=60.00n
MM11 VSS net049 net52 VSS nm1p2_svt_lp W=200.00n L=60.00n
MM9 net051 cn net69 VSS nm1p2_svt_lp W=250.00n L=60.00n
MM7 net69 D net_0162 VSS nm1p2_svt_lp W=250.00n L=60.00n
MM0 net049 net051 VSS VSS nm1p2_svt_lp W=340.00n L=60.00n
MM44 snn SN VDD VDD pm1p2_svt_lp W=450.00n L=60.00n
MM41 net_0231 snn VDD VDD pm1p2_svt_lp W=380.00n L=60.00n
MM40 QN net073 VDD VDD pm1p2_svt_lp W=440.00n L=60.00n
MM4 net049 cn net073 VDD pm1p2_svt_lp W=500.00n L=60.00n
MM29 c cn VDD VDD pm1p2_svt_lp W=450.00n L=60.00n
MM28 cn CK VDD VDD pm1p2_svt_lp W=450.00n L=60.00n
MM37 net128 RN VDD VDD pm1p2_svt_lp W=300.00n L=60.00n
MM26 VDD net063 net109 VDD pm1p2_svt_lp W=300.00n L=60.00n
MM25 net109 c net073 VDD pm1p2_svt_lp W=300.00n L=60.00n
MM20 Q net063 VDD VDD pm1p2_svt_lp W=440.00n L=60.00n
MM18 net063 net073 VDD VDD pm1p2_svt_lp W=390.00n L=60.00n
MM14 net117 cn net051 VDD pm1p2_svt_lp W=300.00n L=60.00n
MM13 VDD net049 net117 VDD pm1p2_svt_lp W=300.00n L=60.00n
MM10 net051 c net128 VDD pm1p2_svt_lp W=380.00n L=60.00n
MM8 net128 D net_0231 VDD pm1p2_svt_lp W=380.00n L=60.00n
MM1 net049 net051 VDD VDD pm1p2_svt_lp W=500.00n L=60.00n
.ENDS

.SUBCKT DFFTRSX2H9R CK D Q QN RN SN VDD VSS
MM43 snn SN VSS VSS nm1p2_svt_lp W=300.00n L=60.00n
MM39 QN net073 VSS VSS nm1p2_svt_lp W=430.00n L=60.00n
MM3 net049 c net073 VSS nm1p2_svt_lp W=360.00n L=60.00n
MM42 net69 snn net_0162 VSS nm1p2_svt_lp W=340.00n L=60.00n
MM30 c cn VSS VSS nm1p2_svt_lp W=340.00n L=60.00n
MM27 cn CK VSS VSS nm1p2_svt_lp W=430.00n L=60.00n
MM38 net_0162 RN VSS VSS nm1p2_svt_lp W=340.00n L=60.00n
MM24 net48 cn net073 VSS nm1p2_svt_lp W=200.00n L=60.00n
MM23 VSS net063 net48 VSS nm1p2_svt_lp W=200.00n L=60.00n
MM19 Q net063 VSS VSS nm1p2_svt_lp W=430.00n L=60.00n
MM17 net063 net073 VSS VSS nm1p2_svt_lp W=300.00n L=60.00n
MM12 net52 c net051 VSS nm1p2_svt_lp W=200.00n L=60.00n
MM11 VSS net049 net52 VSS nm1p2_svt_lp W=200.00n L=60.00n
MM9 net051 cn net69 VSS nm1p2_svt_lp W=340.00n L=60.00n
MM7 net69 D net_0162 VSS nm1p2_svt_lp W=340.00n L=60.00n
MM0 net049 net051 VSS VSS nm1p2_svt_lp W=360.00n L=60.00n
MM44 snn SN VDD VDD pm1p2_svt_lp W=450.00n L=60.00n
MM41 net_0231 snn VDD VDD pm1p2_svt_lp W=510.00n L=60.00n
MM40 QN net073 VDD VDD pm1p2_svt_lp W=650.00n L=60.00n
MM4 net049 cn net073 VDD pm1p2_svt_lp W=510.00n L=60.00n
MM29 c cn VDD VDD pm1p2_svt_lp W=500.00n L=60.00n
MM28 cn CK VDD VDD pm1p2_svt_lp W=650.00n L=60.00n
MM37 net128 RN VDD VDD pm1p2_svt_lp W=300.00n L=60.00n
MM26 VDD net063 net109 VDD pm1p2_svt_lp W=300.00n L=60.00n
MM25 net109 c net073 VDD pm1p2_svt_lp W=300.00n L=60.00n
MM20 Q net063 VDD VDD pm1p2_svt_lp W=650.00n L=60.00n
MM18 net063 net073 VDD VDD pm1p2_svt_lp W=450.00n L=60.00n
MM14 net117 cn net051 VDD pm1p2_svt_lp W=300.00n L=60.00n
MM13 VDD net049 net117 VDD pm1p2_svt_lp W=300.00n L=60.00n
MM10 net051 c net128 VDD pm1p2_svt_lp W=510.00n L=60.00n
MM8 net128 D net_0231 VDD pm1p2_svt_lp W=510.00n L=60.00n
MM1 net049 net051 VDD VDD pm1p2_svt_lp W=510.00n L=60.00n
.ENDS

.SUBCKT DFFTRS4H9R CK D Q QN RN SN VDD VSS
MM43 snn SN VSS VSS nm1p2_svt_lp W=300.00n L=60.00n
MM39 QN net073 VSS VSS nm1p2_svt_lp W=860.00n L=60.00n
MM3 net049 c net073 VSS nm1p2_svt_lp W=360.00n L=60.00n
MM42 net69 snn net_0162 VSS nm1p2_svt_lp W=340.00n L=60.00n
MM30 c cn VSS VSS nm1p2_svt_lp W=340.00n L=60.00n
MM27 cn CK VSS VSS nm1p2_svt_lp W=430.00n L=60.00n
MM38 net_0162 RN VSS VSS nm1p2_svt_lp W=340.00n L=60.00n
MM24 net48 cn net073 VSS nm1p2_svt_lp W=200.00n L=60.00n
MM23 VSS net063 net48 VSS nm1p2_svt_lp W=200.00n L=60.00n
MM19 Q net063 VSS VSS nm1p2_svt_lp W=860.00n L=60.00n
MM17 net063 net073 VSS VSS nm1p2_svt_lp W=360.00n L=60.00n
MM12 net52 c net051 VSS nm1p2_svt_lp W=200.00n L=60.00n
MM11 VSS net049 net52 VSS nm1p2_svt_lp W=200.00n L=60.00n
MM9 net051 cn net69 VSS nm1p2_svt_lp W=340.00n L=60.00n
MM7 net69 D net_0162 VSS nm1p2_svt_lp W=340.00n L=60.00n
MM0 net049 net051 VSS VSS nm1p2_svt_lp W=360.00n L=60.00n
MM44 snn SN VDD VDD pm1p2_svt_lp W=450.00n L=60.00n
MM41 net_0231 snn VDD VDD pm1p2_svt_lp W=510.00n L=60.00n
MM40 QN net073 VDD VDD pm1p2_svt_lp W=1.3u L=60.00n
MM4 net049 cn net073 VDD pm1p2_svt_lp W=510.00n L=60.00n
MM29 c cn VDD VDD pm1p2_svt_lp W=500.00n L=60.00n
MM28 cn CK VDD VDD pm1p2_svt_lp W=650.00n L=60.00n
MM37 net128 RN VDD VDD pm1p2_svt_lp W=300.00n L=60.00n
MM26 VDD net063 net109 VDD pm1p2_svt_lp W=300.00n L=60.00n
MM25 net109 c net073 VDD pm1p2_svt_lp W=300.00n L=60.00n
MM20 Q net063 VDD VDD pm1p2_svt_lp W=1.3u L=60.00n
MM18 net063 net073 VDD VDD pm1p2_svt_lp W=540.00n L=60.00n
MM14 net117 cn net051 VDD pm1p2_svt_lp W=300.00n L=60.00n
MM13 VDD net049 net117 VDD pm1p2_svt_lp W=300.00n L=60.00n
MM10 net051 c net128 VDD pm1p2_svt_lp W=510.00n L=60.00n
MM8 net128 D net_0231 VDD pm1p2_svt_lp W=510.00n L=60.00n
MM1 net049 net051 VDD VDD pm1p2_svt_lp W=510.00n L=60.00n
.ENDS

.SUBCKT EDFFX1H9R CK D E Q QN VDD VSS
MM43 QN s VSS VSS nm1p2_svt_lp W=290.00n L=60.00n
MM40 net_0157 s net_0149 VSS nm1p2_svt_lp W=290.00n L=60.00n
MM41 net_0149 en VSS VSS nm1p2_svt_lp W=290.00n L=60.00n
MM31 en E VSS VSS nm1p2_svt_lp W=200.00n L=60.00n
MM33 net43 c net_0136 VSS nm1p2_svt_lp W=300.00n L=60.00n
MM34 net_0136 m VSS VSS nm1p2_svt_lp W=300.00n L=60.00n
MM30 c cn VSS VSS nm1p2_svt_lp W=300.00n L=60.00n
MM27 cn CK VSS VSS nm1p2_svt_lp W=200.00n L=60.00n
MM24 net48 cn net43 VSS nm1p2_svt_lp W=200.00n L=60.00n
MM23 VSS s net48 VSS nm1p2_svt_lp W=200.00n L=60.00n
MM22 Q net43 VSS VSS nm1p2_svt_lp W=290.00n L=60.00n
MM17 s net43 VSS VSS nm1p2_svt_lp W=260.00n L=60.00n
MM12 net52 c net_0144 VSS nm1p2_svt_lp W=200.00n L=60.00n
MM11 VSS m net52 VSS nm1p2_svt_lp W=200.00n L=60.00n
MM9 net_0157 D net69 VSS nm1p2_svt_lp W=290.00n L=60.00n
MM3 net_0157 cn net_0144 VSS nm1p2_svt_lp W=390.00n L=60.00n
MM7 net69 E VSS VSS nm1p2_svt_lp W=290.00n L=60.00n
MM0 m net_0144 VSS VSS nm1p2_svt_lp W=395.00n L=60.00n
MM42 QN s VDD VDD pm1p2_svt_lp W=440.00n L=60.00n
MM37 net_0157 s net_0228 VDD pm1p2_svt_lp W=440.00n L=60.00n
MM38 net_0228 E VDD VDD pm1p2_svt_lp W=440.00n L=60.00n
MM32 en E VDD VDD pm1p2_svt_lp W=300.00n L=60.00n
MM29 c cn VDD VDD pm1p2_svt_lp W=450.00n L=60.00n
MM28 cn CK VDD VDD pm1p2_svt_lp W=300.00n L=60.00n
MM26 VDD s net109 VDD pm1p2_svt_lp W=300.00n L=60.00n
MM25 net109 c net43 VDD pm1p2_svt_lp W=300.00n L=60.00n
MM21 Q net43 VDD VDD pm1p2_svt_lp W=440.00n L=60.00n
MM18 s net43 VDD VDD pm1p2_svt_lp W=400.00n L=60.00n
MM35 net43 cn net_0211 VDD pm1p2_svt_lp W=300.00n L=60.00n
MM36 net_0211 m VDD VDD pm1p2_svt_lp W=300.00n L=60.00n
MM14 net117 cn net_0144 VDD pm1p2_svt_lp W=300.00n L=60.00n
MM13 VDD m net117 VDD pm1p2_svt_lp W=300.00n L=60.00n
MM10 net_0157 D net128 VDD pm1p2_svt_lp W=440.00n L=60.00n
MM8 net128 en VDD VDD pm1p2_svt_lp W=440.00n L=60.00n
MM4 net_0157 c net_0144 VDD pm1p2_svt_lp W=600.00n L=60.00n
MM1 m net_0144 VDD VDD pm1p2_svt_lp W=495.00n L=60.00n
.ENDS

.SUBCKT EDFFX2H9R CK D E Q QN VDD VSS
MM43 QN s VSS VSS nm1p2_svt_lp W=430.00n L=60.00n
MM40 net_0157 s net_0149 VSS nm1p2_svt_lp W=290.00n L=60.00n
MM41 net_0149 en VSS VSS nm1p2_svt_lp W=290.00n L=60.00n
MM31 en E VSS VSS nm1p2_svt_lp W=200.00n L=60.00n
MM33 net43 c net_0136 VSS nm1p2_svt_lp W=400.00n L=60.00n
MM34 net_0136 m VSS VSS nm1p2_svt_lp W=400.00n L=60.00n
MM30 c cn VSS VSS nm1p2_svt_lp W=300.00n L=60.00n
MM27 cn CK VSS VSS nm1p2_svt_lp W=200.00n L=60.00n
MM24 net48 cn net43 VSS nm1p2_svt_lp W=200.00n L=60.00n
MM23 VSS s net48 VSS nm1p2_svt_lp W=200.00n L=60.00n
MM22 Q net43 VSS VSS nm1p2_svt_lp W=430.00n L=60.00n
MM17 s net43 VSS VSS nm1p2_svt_lp W=260.00n L=60.00n
MM12 net52 c net_0144 VSS nm1p2_svt_lp W=200.00n L=60.00n
MM11 VSS m net52 VSS nm1p2_svt_lp W=200.00n L=60.00n
MM9 net_0157 D net69 VSS nm1p2_svt_lp W=290.00n L=60.00n
MM3 net_0157 cn net_0144 VSS nm1p2_svt_lp W=390.00n L=60.00n
MM7 net69 E VSS VSS nm1p2_svt_lp W=290.00n L=60.00n
MM0 m net_0144 VSS VSS nm1p2_svt_lp W=340.00n L=60.00n
MM42 QN s VDD VDD pm1p2_svt_lp W=650.00n L=60.00n
MM37 net_0157 s net_0228 VDD pm1p2_svt_lp W=440.00n L=60.00n
MM38 net_0228 E VDD VDD pm1p2_svt_lp W=440.00n L=60.00n
MM32 en E VDD VDD pm1p2_svt_lp W=300.00n L=60.00n
MM29 c cn VDD VDD pm1p2_svt_lp W=450.00n L=60.00n
MM28 cn CK VDD VDD pm1p2_svt_lp W=300.00n L=60.00n
MM26 VDD s net109 VDD pm1p2_svt_lp W=300.00n L=60.00n
MM25 net109 c net43 VDD pm1p2_svt_lp W=300.00n L=60.00n
MM21 Q net43 VDD VDD pm1p2_svt_lp W=650.00n L=60.00n
MM18 s net43 VDD VDD pm1p2_svt_lp W=400.00n L=60.00n
MM35 net43 cn net_0211 VDD pm1p2_svt_lp W=400.00n L=60.00n
MM36 net_0211 m VDD VDD pm1p2_svt_lp W=400.00n L=60.00n
MM14 net117 cn net_0144 VDD pm1p2_svt_lp W=300.00n L=60.00n
MM13 VDD m net117 VDD pm1p2_svt_lp W=300.00n L=60.00n
MM10 net_0157 D net128 VDD pm1p2_svt_lp W=440.00n L=60.00n
MM8 net128 en VDD VDD pm1p2_svt_lp W=440.00n L=60.00n
MM4 net_0157 c net_0144 VDD pm1p2_svt_lp W=600.00n L=60.00n
MM1 m net_0144 VDD VDD pm1p2_svt_lp W=550.00n L=60.00n
.ENDS

.SUBCKT EDFFX4H9R CK D E Q QN VDD VSS
MM43 QN s VSS VSS nm1p2_svt_lp W=860.00n L=60.00n
MM40 net_0157 s net_0149 VSS nm1p2_svt_lp W=290.00n L=60.00n
MM41 net_0149 en VSS VSS nm1p2_svt_lp W=290.00n L=60.00n
MM31 en E VSS VSS nm1p2_svt_lp W=200.00n L=60.00n
MM33 net43 c net_0136 VSS nm1p2_svt_lp W=430.00n L=60.00n
MM34 net_0136 m VSS VSS nm1p2_svt_lp W=430.00n L=60.00n
MM30 c cn VSS VSS nm1p2_svt_lp W=300.00n L=60.00n
MM27 cn CK VSS VSS nm1p2_svt_lp W=200.00n L=60.00n
MM24 net48 cn net43 VSS nm1p2_svt_lp W=200.00n L=60.00n
MM23 VSS s net48 VSS nm1p2_svt_lp W=200.00n L=60.00n
MM22 Q net43 VSS VSS nm1p2_svt_lp W=860.00n L=60.00n
MM17 s net43 VSS VSS nm1p2_svt_lp W=260.00n L=60.00n
MM12 net52 c net_0144 VSS nm1p2_svt_lp W=200.00n L=60.00n
MM11 VSS m net52 VSS nm1p2_svt_lp W=200.00n L=60.00n
MM9 net_0157 D net69 VSS nm1p2_svt_lp W=290.00n L=60.00n
MM3 net_0157 cn net_0144 VSS nm1p2_svt_lp W=390.00n L=60.00n
MM7 net69 E VSS VSS nm1p2_svt_lp W=290.00n L=60.00n
MM0 m net_0144 VSS VSS nm1p2_svt_lp W=400.00n L=60.00n
MM42 QN s VDD VDD pm1p2_svt_lp W=1.3u L=60.00n
MM37 net_0157 s net_0228 VDD pm1p2_svt_lp W=440.00n L=60.00n
MM38 net_0228 E VDD VDD pm1p2_svt_lp W=440.00n L=60.00n
MM32 en E VDD VDD pm1p2_svt_lp W=300.00n L=60.00n
MM29 c cn VDD VDD pm1p2_svt_lp W=450.00n L=60.00n
MM28 cn CK VDD VDD pm1p2_svt_lp W=300.00n L=60.00n
MM26 VDD s net109 VDD pm1p2_svt_lp W=300.00n L=60.00n
MM25 net109 c net43 VDD pm1p2_svt_lp W=300.00n L=60.00n
MM21 Q net43 VDD VDD pm1p2_svt_lp W=1.3u L=60.00n
MM18 s net43 VDD VDD pm1p2_svt_lp W=400.00n L=60.00n
MM35 net43 cn net_0211 VDD pm1p2_svt_lp W=460.00n L=60.00n
MM36 net_0211 m VDD VDD pm1p2_svt_lp W=460.00n L=60.00n
MM14 net117 cn net_0144 VDD pm1p2_svt_lp W=300.00n L=60.00n
MM13 VDD m net117 VDD pm1p2_svt_lp W=300.00n L=60.00n
MM10 net_0157 D net128 VDD pm1p2_svt_lp W=440.00n L=60.00n
MM8 net128 en VDD VDD pm1p2_svt_lp W=440.00n L=60.00n
MM4 net_0157 c net_0144 VDD pm1p2_svt_lp W=600.00n L=60.00n
MM1 m net_0144 VDD VDD pm1p2_svt_lp W=600.00n L=60.00n
.ENDS

.SUBCKT EDFFRX1H9R CK D E Q QN RDN VDD VSS
MM45 VSS RDN net_0134 VSS nm1p2_svt_lp W=300.00n L=60.00n
MM40 net_0157 s net_0149 VSS nm1p2_svt_lp W=420.00n L=60.00n
MM41 net_0149 en net_0213 VSS nm1p2_svt_lp W=420.00n L=60.00n
MM47 QN s VSS VSS nm1p2_svt_lp W=290.00n L=60.00n
MM31 en E VSS VSS nm1p2_svt_lp W=240.00n L=60.00n
MM33 net43 c net_0136 VSS nm1p2_svt_lp W=300.00n L=60.00n
MM34 net_0136 m VSS VSS nm1p2_svt_lp W=300.00n L=60.00n
MM30 c cn VSS VSS nm1p2_svt_lp W=300.00n L=60.00n
MM27 cn CK VSS VSS nm1p2_svt_lp W=200.00n L=60.00n
MM44 VSS RDN net_0138 VSS nm1p2_svt_lp W=300.00n L=60.00n
MM24 net48 cn net43 VSS nm1p2_svt_lp W=300.00n L=60.00n
MM23 net_0138 s net48 VSS nm1p2_svt_lp W=300.00n L=60.00n
MM22 Q net43 VSS VSS nm1p2_svt_lp W=290.00n L=60.00n
MM17 s net43 VSS VSS nm1p2_svt_lp W=280.00n L=60.00n
MM12 net52 c net_0144 VSS nm1p2_svt_lp W=300.00n L=60.00n
MM11 net_0134 m net52 VSS nm1p2_svt_lp W=300.00n L=60.00n
MM9 net_0157 D net69 VSS nm1p2_svt_lp W=420.00n L=60.00n
MM3 net_0157 cn net_0144 VSS nm1p2_svt_lp W=400.00n L=60.00n
MM7 net69 E net_0213 VSS nm1p2_svt_lp W=420.00n L=60.00n
MM46 net_0213 RDN VSS VSS nm1p2_svt_lp W=420.00n L=60.00n
MM0 m net_0144 VSS VSS nm1p2_svt_lp W=400.00n L=60.00n
MM42 VDD RDN net_0144 VDD pm1p2_svt_lp W=300.00n L=60.00n
MM43 VDD RDN net43 VDD pm1p2_svt_lp W=300.00n L=60.00n
MM37 net_0157 s net_0228 VDD pm1p2_svt_lp W=440.00n L=60.00n
MM38 net_0228 E VDD VDD pm1p2_svt_lp W=440.00n L=60.00n
MM48 QN s VDD VDD pm1p2_svt_lp W=440.00n L=60.00n
MM32 en E VDD VDD pm1p2_svt_lp W=360.00n L=60.00n
MM29 c cn VDD VDD pm1p2_svt_lp W=450.00n L=60.00n
MM28 cn CK VDD VDD pm1p2_svt_lp W=300.00n L=60.00n
MM26 VDD s net109 VDD pm1p2_svt_lp W=300.00n L=60.00n
MM25 net109 c net43 VDD pm1p2_svt_lp W=300.00n L=60.00n
MM21 Q net43 VDD VDD pm1p2_svt_lp W=440.00n L=60.00n
MM18 s net43 VDD VDD pm1p2_svt_lp W=420.00n L=60.00n
MM35 net43 cn net_0211 VDD pm1p2_svt_lp W=320.00n L=60.00n
MM36 net_0211 m VDD VDD pm1p2_svt_lp W=320.00n L=60.00n
MM14 net117 cn net_0144 VDD pm1p2_svt_lp W=300.00n L=60.00n
MM13 VDD m net117 VDD pm1p2_svt_lp W=300.00n L=60.00n
MM10 net_0157 D net128 VDD pm1p2_svt_lp W=440.00n L=60.00n
MM8 net128 en VDD VDD pm1p2_svt_lp W=440.00n L=60.00n
MM4 net_0157 c net_0144 VDD pm1p2_svt_lp W=600.00n L=60.00n
MM1 m net_0144 VDD VDD pm1p2_svt_lp W=600.00n L=60.00n
.ENDS

.SUBCKT EDFFRX2H9R CK D E Q QN RDN VDD VSS
MM45 VSS RDN net_0134 VSS nm1p2_svt_lp W=300.00n L=60.00n
MM40 net_0157 s net_0149 VSS nm1p2_svt_lp W=420.00n L=60.00n
MM41 net_0149 en net_0213 VSS nm1p2_svt_lp W=420.00n L=60.00n
MM47 QN s VSS VSS nm1p2_svt_lp W=430.00n L=60.00n
MM31 en E VSS VSS nm1p2_svt_lp W=240.00n L=60.00n
MM33 net43 c net_0136 VSS nm1p2_svt_lp W=400.00n L=60.00n
MM34 net_0136 m VSS VSS nm1p2_svt_lp W=400.00n L=60.00n
MM30 c cn VSS VSS nm1p2_svt_lp W=300.00n L=60.00n
MM27 cn CK VSS VSS nm1p2_svt_lp W=200.00n L=60.00n
MM44 VSS RDN net_0138 VSS nm1p2_svt_lp W=300.00n L=60.00n
MM24 net48 cn net43 VSS nm1p2_svt_lp W=300.00n L=60.00n
MM23 net_0138 s net48 VSS nm1p2_svt_lp W=300.00n L=60.00n
MM22 Q net43 VSS VSS nm1p2_svt_lp W=430.00n L=60.00n
MM17 s net43 VSS VSS nm1p2_svt_lp W=280.00n L=60.00n
MM12 net52 c net_0144 VSS nm1p2_svt_lp W=300.00n L=60.00n
MM11 net_0134 m net52 VSS nm1p2_svt_lp W=300.00n L=60.00n
MM9 net_0157 D net69 VSS nm1p2_svt_lp W=420.00n L=60.00n
MM3 net_0157 cn net_0144 VSS nm1p2_svt_lp W=400.00n L=60.00n
MM7 net69 E net_0213 VSS nm1p2_svt_lp W=420.00n L=60.00n
MM46 net_0213 RDN VSS VSS nm1p2_svt_lp W=420.00n L=60.00n
MM0 m net_0144 VSS VSS nm1p2_svt_lp W=400.00n L=60.00n
MM42 VDD RDN net_0144 VDD pm1p2_svt_lp W=300.00n L=60.00n
MM43 VDD RDN net43 VDD pm1p2_svt_lp W=300.00n L=60.00n
MM37 net_0157 s net_0228 VDD pm1p2_svt_lp W=440.00n L=60.00n
MM38 net_0228 E VDD VDD pm1p2_svt_lp W=440.00n L=60.00n
MM48 QN s VDD VDD pm1p2_svt_lp W=650.00n L=60.00n
MM32 en E VDD VDD pm1p2_svt_lp W=360.00n L=60.00n
MM29 c cn VDD VDD pm1p2_svt_lp W=450.00n L=60.00n
MM28 cn CK VDD VDD pm1p2_svt_lp W=300.00n L=60.00n
MM26 VDD s net109 VDD pm1p2_svt_lp W=300.00n L=60.00n
MM25 net109 c net43 VDD pm1p2_svt_lp W=300.00n L=60.00n
MM21 Q net43 VDD VDD pm1p2_svt_lp W=650.00n L=60.00n
MM18 s net43 VDD VDD pm1p2_svt_lp W=420.00n L=60.00n
MM35 net43 cn net_0211 VDD pm1p2_svt_lp W=430.00n L=60.00n
MM36 net_0211 m VDD VDD pm1p2_svt_lp W=430.00n L=60.00n
MM14 net117 cn net_0144 VDD pm1p2_svt_lp W=300.00n L=60.00n
MM13 VDD m net117 VDD pm1p2_svt_lp W=300.00n L=60.00n
MM10 net_0157 D net128 VDD pm1p2_svt_lp W=440.00n L=60.00n
MM8 net128 en VDD VDD pm1p2_svt_lp W=440.00n L=60.00n
MM4 net_0157 c net_0144 VDD pm1p2_svt_lp W=600.00n L=60.00n
MM1 m net_0144 VDD VDD pm1p2_svt_lp W=600.00n L=60.00n
.ENDS

.SUBCKT EDFFRX4H9R CK D E Q QN RDN VDD VSS
MM45 VSS RDN net_0134 VSS nm1p2_svt_lp W=300.00n L=60.00n
MM40 net_0157 s net_0149 VSS nm1p2_svt_lp W=420.00n L=60.00n
MM41 net_0149 en net_0213 VSS nm1p2_svt_lp W=420.00n L=60.00n
MM47 QN s VSS VSS nm1p2_svt_lp W=860.00n L=60.00n
MM31 en E VSS VSS nm1p2_svt_lp W=240.00n L=60.00n
MM33 net43 c net_0136 VSS nm1p2_svt_lp W=400.00n L=60.00n
MM34 net_0136 m VSS VSS nm1p2_svt_lp W=400.00n L=60.00n
MM30 c cn VSS VSS nm1p2_svt_lp W=300.00n L=60.00n
MM27 cn CK VSS VSS nm1p2_svt_lp W=200.00n L=60.00n
MM44 VSS RDN net_0138 VSS nm1p2_svt_lp W=300.00n L=60.00n
MM24 net48 cn net43 VSS nm1p2_svt_lp W=300.00n L=60.00n
MM23 net_0138 s net48 VSS nm1p2_svt_lp W=300.00n L=60.00n
MM22 Q net43 VSS VSS nm1p2_svt_lp W=860.00n L=60.00n
MM17 s net43 VSS VSS nm1p2_svt_lp W=300.00n L=60.00n
MM12 net52 c net_0144 VSS nm1p2_svt_lp W=300.00n L=60.00n
MM11 net_0134 m net52 VSS nm1p2_svt_lp W=300.00n L=60.00n
MM9 net_0157 D net69 VSS nm1p2_svt_lp W=420.00n L=60.00n
MM3 net_0157 cn net_0144 VSS nm1p2_svt_lp W=400.00n L=60.00n
MM7 net69 E net_0213 VSS nm1p2_svt_lp W=420.00n L=60.00n
MM46 net_0213 RDN VSS VSS nm1p2_svt_lp W=420.00n L=60.00n
MM0 m net_0144 VSS VSS nm1p2_svt_lp W=400.00n L=60.00n
MM42 VDD RDN net_0144 VDD pm1p2_svt_lp W=300.00n L=60.00n
MM43 VDD RDN net43 VDD pm1p2_svt_lp W=300.00n L=60.00n
MM37 net_0157 s net_0228 VDD pm1p2_svt_lp W=440.00n L=60.00n
MM38 net_0228 E VDD VDD pm1p2_svt_lp W=440.00n L=60.00n
MM48 QN s VDD VDD pm1p2_svt_lp W=1.3u L=60.00n
MM32 en E VDD VDD pm1p2_svt_lp W=360.00n L=60.00n
MM29 c cn VDD VDD pm1p2_svt_lp W=450.00n L=60.00n
MM28 cn CK VDD VDD pm1p2_svt_lp W=300.00n L=60.00n
MM26 VDD s net109 VDD pm1p2_svt_lp W=300.00n L=60.00n
MM25 net109 c net43 VDD pm1p2_svt_lp W=300.00n L=60.00n
MM21 Q net43 VDD VDD pm1p2_svt_lp W=1.3u L=60.00n
MM18 s net43 VDD VDD pm1p2_svt_lp W=420.00n L=60.00n
MM35 net43 cn net_0211 VDD pm1p2_svt_lp W=460.00n L=60.00n
MM36 net_0211 m VDD VDD pm1p2_svt_lp W=460.00n L=60.00n
MM14 net117 cn net_0144 VDD pm1p2_svt_lp W=300.00n L=60.00n
MM13 VDD m net117 VDD pm1p2_svt_lp W=300.00n L=60.00n
MM10 net_0157 D net128 VDD pm1p2_svt_lp W=440.00n L=60.00n
MM8 net128 en VDD VDD pm1p2_svt_lp W=440.00n L=60.00n
MM4 net_0157 c net_0144 VDD pm1p2_svt_lp W=600.00n L=60.00n
MM1 m net_0144 VDD VDD pm1p2_svt_lp W=600.00n L=60.00n
.ENDS

.SUBCKT EDFFRQX1H9R CK D E Q RDN VDD VSS
MM45 VSS RDN net_0134 VSS nm1p2_svt_lp W=300.00n L=60.00n
MM40 net_0157 s net_0149 VSS nm1p2_svt_lp W=420.00n L=60.00n
MM41 net_0149 en net_0213 VSS nm1p2_svt_lp W=420.00n L=60.00n
MM31 en E VSS VSS nm1p2_svt_lp W=240.00n L=60.00n
MM33 net43 c net_0136 VSS nm1p2_svt_lp W=300.00n L=60.00n
MM34 net_0136 m VSS VSS nm1p2_svt_lp W=300.00n L=60.00n
MM30 c cn VSS VSS nm1p2_svt_lp W=300.00n L=60.00n
MM27 cn CK VSS VSS nm1p2_svt_lp W=200.00n L=60.00n
MM44 VSS RDN net_0138 VSS nm1p2_svt_lp W=300.00n L=60.00n
MM24 net48 cn net43 VSS nm1p2_svt_lp W=300.00n L=60.00n
MM23 net_0138 s net48 VSS nm1p2_svt_lp W=300.00n L=60.00n
MM22 Q net43 VSS VSS nm1p2_svt_lp W=290.00n L=60.00n
MM17 s net43 VSS VSS nm1p2_svt_lp W=200.00n L=60.00n
MM12 net52 c net_0144 VSS nm1p2_svt_lp W=300.00n L=60.00n
MM11 net_0134 m net52 VSS nm1p2_svt_lp W=300.00n L=60.00n
MM9 net_0157 D net69 VSS nm1p2_svt_lp W=420.00n L=60.00n
MM3 net_0157 cn net_0144 VSS nm1p2_svt_lp W=400.00n L=60.00n
MM7 net69 E net_0213 VSS nm1p2_svt_lp W=420.00n L=60.00n
MM46 net_0213 RDN VSS VSS nm1p2_svt_lp W=420.00n L=60.00n
MM0 m net_0144 VSS VSS nm1p2_svt_lp W=400.00n L=60.00n
MM42 VDD RDN net_0144 VDD pm1p2_svt_lp W=300.00n L=60.00n
MM43 VDD RDN net43 VDD pm1p2_svt_lp W=300.00n L=60.00n
MM37 net_0157 s net_0228 VDD pm1p2_svt_lp W=440.00n L=60.00n
MM38 net_0228 E VDD VDD pm1p2_svt_lp W=440.00n L=60.00n
MM32 en E VDD VDD pm1p2_svt_lp W=360.00n L=60.00n
MM29 c cn VDD VDD pm1p2_svt_lp W=450.00n L=60.00n
MM28 cn CK VDD VDD pm1p2_svt_lp W=300.00n L=60.00n
MM26 VDD s net109 VDD pm1p2_svt_lp W=300.00n L=60.00n
MM25 net109 c net43 VDD pm1p2_svt_lp W=300.00n L=60.00n
MM21 Q net43 VDD VDD pm1p2_svt_lp W=440.00n L=60.00n
MM18 s net43 VDD VDD pm1p2_svt_lp W=300.00n L=60.00n
MM35 net43 cn net_0211 VDD pm1p2_svt_lp W=320.00n L=60.00n
MM36 net_0211 m VDD VDD pm1p2_svt_lp W=320.00n L=60.00n
MM14 net117 cn net_0144 VDD pm1p2_svt_lp W=300.00n L=60.00n
MM13 VDD m net117 VDD pm1p2_svt_lp W=300.00n L=60.00n
MM10 net_0157 D net128 VDD pm1p2_svt_lp W=440.00n L=60.00n
MM8 net128 en VDD VDD pm1p2_svt_lp W=440.00n L=60.00n
MM4 net_0157 c net_0144 VDD pm1p2_svt_lp W=600.00n L=60.00n
MM1 m net_0144 VDD VDD pm1p2_svt_lp W=600.00n L=60.00n
.ENDS

.SUBCKT EDFFRQX2H9R CK D E Q RDN VDD VSS
MM45 VSS RDN net_0134 VSS nm1p2_svt_lp W=300.00n L=60.00n
MM40 net_0157 s net_0149 VSS nm1p2_svt_lp W=420.00n L=60.00n
MM41 net_0149 en net_0213 VSS nm1p2_svt_lp W=420.00n L=60.00n
MM31 en E VSS VSS nm1p2_svt_lp W=240.00n L=60.00n
MM33 net43 c net_0136 VSS nm1p2_svt_lp W=400.00n L=60.00n
MM34 net_0136 m VSS VSS nm1p2_svt_lp W=400.00n L=60.00n
MM30 c cn VSS VSS nm1p2_svt_lp W=300.00n L=60.00n
MM27 cn CK VSS VSS nm1p2_svt_lp W=200.00n L=60.00n
MM44 VSS RDN net_0138 VSS nm1p2_svt_lp W=300.00n L=60.00n
MM24 net48 cn net43 VSS nm1p2_svt_lp W=300.00n L=60.00n
MM23 net_0138 s net48 VSS nm1p2_svt_lp W=300.00n L=60.00n
MM22 Q net43 VSS VSS nm1p2_svt_lp W=430.00n L=60.00n
MM17 s net43 VSS VSS nm1p2_svt_lp W=240.00n L=60.00n
MM12 net52 c net_0144 VSS nm1p2_svt_lp W=300.00n L=60.00n
MM11 net_0134 m net52 VSS nm1p2_svt_lp W=300.00n L=60.00n
MM9 net_0157 D net69 VSS nm1p2_svt_lp W=420.00n L=60.00n
MM3 net_0157 cn net_0144 VSS nm1p2_svt_lp W=400.00n L=60.00n
MM7 net69 E net_0213 VSS nm1p2_svt_lp W=420.00n L=60.00n
MM46 net_0213 RDN VSS VSS nm1p2_svt_lp W=420.00n L=60.00n
MM0 m net_0144 VSS VSS nm1p2_svt_lp W=400.00n L=60.00n
MM42 VDD RDN net_0144 VDD pm1p2_svt_lp W=300.00n L=60.00n
MM43 VDD RDN net43 VDD pm1p2_svt_lp W=300.00n L=60.00n
MM37 net_0157 s net_0228 VDD pm1p2_svt_lp W=440.00n L=60.00n
MM38 net_0228 E VDD VDD pm1p2_svt_lp W=440.00n L=60.00n
MM32 en E VDD VDD pm1p2_svt_lp W=360.00n L=60.00n
MM29 c cn VDD VDD pm1p2_svt_lp W=450.00n L=60.00n
MM28 cn CK VDD VDD pm1p2_svt_lp W=300.00n L=60.00n
MM26 VDD s net109 VDD pm1p2_svt_lp W=300.00n L=60.00n
MM25 net109 c net43 VDD pm1p2_svt_lp W=300.00n L=60.00n
MM21 Q net43 VDD VDD pm1p2_svt_lp W=650.00n L=60.00n
MM18 s net43 VDD VDD pm1p2_svt_lp W=360.00n L=60.00n
MM35 net43 cn net_0211 VDD pm1p2_svt_lp W=430.00n L=60.00n
MM36 net_0211 m VDD VDD pm1p2_svt_lp W=430.00n L=60.00n
MM14 net117 cn net_0144 VDD pm1p2_svt_lp W=300.00n L=60.00n
MM13 VDD m net117 VDD pm1p2_svt_lp W=300.00n L=60.00n
MM10 net_0157 D net128 VDD pm1p2_svt_lp W=440.00n L=60.00n
MM8 net128 en VDD VDD pm1p2_svt_lp W=440.00n L=60.00n
MM4 net_0157 c net_0144 VDD pm1p2_svt_lp W=600.00n L=60.00n
MM1 m net_0144 VDD VDD pm1p2_svt_lp W=600.00n L=60.00n
.ENDS

.SUBCKT EDFFRQX4H9R CK D E Q RDN VDD VSS
MM45 VSS RDN net_0134 VSS nm1p2_svt_lp W=300.00n L=60.00n
MM40 net_0157 s net_0149 VSS nm1p2_svt_lp W=420.00n L=60.00n
MM41 net_0149 en net_0213 VSS nm1p2_svt_lp W=420.00n L=60.00n
MM31 en E VSS VSS nm1p2_svt_lp W=240.00n L=60.00n
MM33 net43 c net_0136 VSS nm1p2_svt_lp W=400.00n L=60.00n
MM34 net_0136 m VSS VSS nm1p2_svt_lp W=400.00n L=60.00n
MM30 c cn VSS VSS nm1p2_svt_lp W=300.00n L=60.00n
MM27 cn CK VSS VSS nm1p2_svt_lp W=200.00n L=60.00n
MM44 VSS RDN net_0138 VSS nm1p2_svt_lp W=300.00n L=60.00n
MM24 net48 cn net43 VSS nm1p2_svt_lp W=300.00n L=60.00n
MM23 net_0138 s net48 VSS nm1p2_svt_lp W=300.00n L=60.00n
MM22 Q net43 VSS VSS nm1p2_svt_lp W=860.00n L=60.00n
MM17 s net43 VSS VSS nm1p2_svt_lp W=240.00n L=60.00n
MM12 net52 c net_0144 VSS nm1p2_svt_lp W=300.00n L=60.00n
MM11 net_0134 m net52 VSS nm1p2_svt_lp W=300.00n L=60.00n
MM9 net_0157 D net69 VSS nm1p2_svt_lp W=420.00n L=60.00n
MM3 net_0157 cn net_0144 VSS nm1p2_svt_lp W=400.00n L=60.00n
MM7 net69 E net_0213 VSS nm1p2_svt_lp W=420.00n L=60.00n
MM46 net_0213 RDN VSS VSS nm1p2_svt_lp W=420.00n L=60.00n
MM0 m net_0144 VSS VSS nm1p2_svt_lp W=400.00n L=60.00n
MM42 VDD RDN net_0144 VDD pm1p2_svt_lp W=300.00n L=60.00n
MM43 VDD RDN net43 VDD pm1p2_svt_lp W=300.00n L=60.00n
MM37 net_0157 s net_0228 VDD pm1p2_svt_lp W=440.00n L=60.00n
MM38 net_0228 E VDD VDD pm1p2_svt_lp W=440.00n L=60.00n
MM32 en E VDD VDD pm1p2_svt_lp W=360.00n L=60.00n
MM29 c cn VDD VDD pm1p2_svt_lp W=450.00n L=60.00n
MM28 cn CK VDD VDD pm1p2_svt_lp W=300.00n L=60.00n
MM26 VDD s net109 VDD pm1p2_svt_lp W=300.00n L=60.00n
MM25 net109 c net43 VDD pm1p2_svt_lp W=300.00n L=60.00n
MM21 Q net43 VDD VDD pm1p2_svt_lp W=1.3u L=60.00n
MM18 s net43 VDD VDD pm1p2_svt_lp W=360.00n L=60.00n
MM35 net43 cn net_0211 VDD pm1p2_svt_lp W=460.00n L=60.00n
MM36 net_0211 m VDD VDD pm1p2_svt_lp W=460.00n L=60.00n
MM14 net117 cn net_0144 VDD pm1p2_svt_lp W=300.00n L=60.00n
MM13 VDD m net117 VDD pm1p2_svt_lp W=300.00n L=60.00n
MM10 net_0157 D net128 VDD pm1p2_svt_lp W=440.00n L=60.00n
MM8 net128 en VDD VDD pm1p2_svt_lp W=440.00n L=60.00n
MM4 net_0157 c net_0144 VDD pm1p2_svt_lp W=600.00n L=60.00n
MM1 m net_0144 VDD VDD pm1p2_svt_lp W=600.00n L=60.00n
.ENDS

.SUBCKT EDFFTRX1H9R CK D E Q QN RN VDD VSS
MM43 QN s VSS VSS nm1p2_svt_lp W=290.00n L=60.00n
MM40 net_0157 s net_0149 VSS nm1p2_svt_lp W=340.00n L=60.00n
MM41 net_0149 en net_0164 VSS nm1p2_svt_lp W=340.00n L=60.00n
MM42 net_0164 RN VSS VSS nm1p2_svt_lp W=385.00n L=60.00n
MM31 en E VSS VSS nm1p2_svt_lp W=200.00n L=60.00n
MM33 net43 c net_0136 VSS nm1p2_svt_lp W=280.00n L=60.00n
MM34 net_0136 m VSS VSS nm1p2_svt_lp W=280.00n L=60.00n
MM30 c cn VSS VSS nm1p2_svt_lp W=300.00n L=60.00n
MM27 cn CK VSS VSS nm1p2_svt_lp W=200.00n L=60.00n
MM24 net48 cn net43 VSS nm1p2_svt_lp W=200.00n L=60.00n
MM23 VSS s net48 VSS nm1p2_svt_lp W=200.00n L=60.00n
MM22 Q net43 VSS VSS nm1p2_svt_lp W=290.00n L=60.00n
MM17 s net43 VSS VSS nm1p2_svt_lp W=280.00n L=60.00n
MM12 net52 c net_0144 VSS nm1p2_svt_lp W=185.00n L=60.00n
MM11 VSS m net52 VSS nm1p2_svt_lp W=185.00n L=60.00n
MM9 net_0157 D net69 VSS nm1p2_svt_lp W=340.00n L=60.00n
MM3 net_0157 cn net_0144 VSS nm1p2_svt_lp W=355.00n L=60.00n
MM7 net69 E net_0164 VSS nm1p2_svt_lp W=340.00n L=60.00n
MM0 m net_0144 VSS VSS nm1p2_svt_lp W=400.00n L=60.00n
MM44 QN s VDD VDD pm1p2_svt_lp W=440.00n L=60.00n
MM37 net_0157 s net_0228 VDD pm1p2_svt_lp W=360.00n L=60.00n
MM38 net_0228 E VDD VDD pm1p2_svt_lp W=360.00n L=60.00n
MM39 net_0157 RN VDD VDD pm1p2_svt_lp W=200.00n L=60.00n
MM32 en E VDD VDD pm1p2_svt_lp W=300.00n L=60.00n
MM29 c cn VDD VDD pm1p2_svt_lp W=450.0n L=60.00n
MM28 cn CK VDD VDD pm1p2_svt_lp W=300.00n L=60.00n
MM26 VDD s net109 VDD pm1p2_svt_lp W=300.00n L=60.00n
MM25 net109 c net43 VDD pm1p2_svt_lp W=300.00n L=60.00n
MM21 Q net43 VDD VDD pm1p2_svt_lp W=440.00n L=60.00n
MM18 s net43 VDD VDD pm1p2_svt_lp W=420.00n L=60.00n
MM35 net43 cn net_0211 VDD pm1p2_svt_lp W=300.00n L=60.00n
MM36 net_0211 m VDD VDD pm1p2_svt_lp W=300.00n L=60.00n
MM14 net117 cn net_0144 VDD pm1p2_svt_lp W=300.00n L=60.00n
MM13 VDD m net117 VDD pm1p2_svt_lp W=300.00n L=60.00n
MM10 net_0157 D net128 VDD pm1p2_svt_lp W=360.00n L=60.00n
MM8 net128 en VDD VDD pm1p2_svt_lp W=360.00n L=60.00n
MM4 net_0157 c net_0144 VDD pm1p2_svt_lp W=555.00n L=60.00n
MM1 m net_0144 VDD VDD pm1p2_svt_lp W=600.00n L=60.00n
.ENDS

.SUBCKT EDFFTRX2H9R CK D E Q QN RN VDD VSS
MM43 QN s VSS VSS nm1p2_svt_lp W=390.00n L=60.00n
MM40 net_0157 s net_0149 VSS nm1p2_svt_lp W=340.00n L=60.00n
MM41 net_0149 en net_0164 VSS nm1p2_svt_lp W=340.00n L=60.00n
MM42 net_0164 RN VSS VSS nm1p2_svt_lp W=385.00n L=60.00n
MM31 en E VSS VSS nm1p2_svt_lp W=200.00n L=60.00n
MM33 net43 c net_0136 VSS nm1p2_svt_lp W=400.00n L=60.00n
MM34 net_0136 m VSS VSS nm1p2_svt_lp W=400.00n L=60.00n
MM30 c cn VSS VSS nm1p2_svt_lp W=300.00n L=60.00n
MM27 cn CK VSS VSS nm1p2_svt_lp W=200.00n L=60.00n
MM24 net48 cn net43 VSS nm1p2_svt_lp W=200.00n L=60.00n
MM23 VSS s net48 VSS nm1p2_svt_lp W=200.00n L=60.00n
MM22 Q net43 VSS VSS nm1p2_svt_lp W=390.00n L=60.00n
MM17 s net43 VSS VSS nm1p2_svt_lp W=260.00n L=60.00n
MM12 net52 c net_0144 VSS nm1p2_svt_lp W=185.00n L=60.00n
MM11 VSS m net52 VSS nm1p2_svt_lp W=185.00n L=60.00n
MM9 net_0157 D net69 VSS nm1p2_svt_lp W=340.00n L=60.00n
MM3 net_0157 cn net_0144 VSS nm1p2_svt_lp W=355.00n L=60.00n
MM7 net69 E net_0164 VSS nm1p2_svt_lp W=340.00n L=60.00n
MM0 m net_0144 VSS VSS nm1p2_svt_lp W=400.00n L=60.00n
MM44 QN s VDD VDD pm1p2_svt_lp W=610.00n L=60.00n
MM37 net_0157 s net_0228 VDD pm1p2_svt_lp W=360.00n L=60.00n
MM38 net_0228 E VDD VDD pm1p2_svt_lp W=360.00n L=60.00n
MM39 net_0157 RN VDD VDD pm1p2_svt_lp W=200.00n L=60.00n
MM32 en E VDD VDD pm1p2_svt_lp W=300.00n L=60.00n
MM29 c cn VDD VDD pm1p2_svt_lp W=450.0n L=60.00n
MM28 cn CK VDD VDD pm1p2_svt_lp W=300.00n L=60.00n
MM26 VDD s net109 VDD pm1p2_svt_lp W=300.00n L=60.00n
MM25 net109 c net43 VDD pm1p2_svt_lp W=300.00n L=60.00n
MM21 Q net43 VDD VDD pm1p2_svt_lp W=610.00n L=60.00n
MM18 s net43 VDD VDD pm1p2_svt_lp W=400.00n L=60.00n
MM35 net43 cn net_0211 VDD pm1p2_svt_lp W=440.00n L=60.00n
MM36 net_0211 m VDD VDD pm1p2_svt_lp W=440.00n L=60.00n
MM14 net117 cn net_0144 VDD pm1p2_svt_lp W=300.00n L=60.00n
MM13 VDD m net117 VDD pm1p2_svt_lp W=300.00n L=60.00n
MM10 net_0157 D net128 VDD pm1p2_svt_lp W=360.00n L=60.00n
MM8 net128 en VDD VDD pm1p2_svt_lp W=360.00n L=60.00n
MM4 net_0157 c net_0144 VDD pm1p2_svt_lp W=555.00n L=60.00n
MM1 m net_0144 VDD VDD pm1p2_svt_lp W=600.00n L=60.00n
.ENDS

.SUBCKT EDFFTRX4H9R CK D E Q QN RN VDD VSS
MM43 QN s VSS VSS nm1p2_svt_lp W=860.00n L=60.00n
MM40 net_0157 s net_0149 VSS nm1p2_svt_lp W=340.00n L=60.00n
MM41 net_0149 en net_0164 VSS nm1p2_svt_lp W=340.00n L=60.00n
MM42 net_0164 RN VSS VSS nm1p2_svt_lp W=385.00n L=60.00n
MM31 en E VSS VSS nm1p2_svt_lp W=200.00n L=60.00n
MM33 net43 c net_0136 VSS nm1p2_svt_lp W=430.00n L=60.00n
MM34 net_0136 m VSS VSS nm1p2_svt_lp W=430.00n L=60.00n
MM30 c cn VSS VSS nm1p2_svt_lp W=300.00n L=60.00n
MM27 cn CK VSS VSS nm1p2_svt_lp W=200.00n L=60.00n
MM24 net48 cn net43 VSS nm1p2_svt_lp W=200.00n L=60.00n
MM23 VSS s net48 VSS nm1p2_svt_lp W=200.00n L=60.00n
MM22 Q net43 VSS VSS nm1p2_svt_lp W=860.00n L=60.00n
MM17 s net43 VSS VSS nm1p2_svt_lp W=260.00n L=60.00n
MM12 net52 c net_0144 VSS nm1p2_svt_lp W=185.00n L=60.00n
MM11 VSS m net52 VSS nm1p2_svt_lp W=185.00n L=60.00n
MM9 net_0157 D net69 VSS nm1p2_svt_lp W=340.00n L=60.00n
MM3 net_0157 cn net_0144 VSS nm1p2_svt_lp W=260.00n L=60.00n
MM7 net69 E net_0164 VSS nm1p2_svt_lp W=340.00n L=60.00n
MM0 m net_0144 VSS VSS nm1p2_svt_lp W=260.00n L=60.00n
MM44 QN s VDD VDD pm1p2_svt_lp W=1.3u L=60.00n
MM37 net_0157 s net_0228 VDD pm1p2_svt_lp W=360.00n L=60.00n
MM38 net_0228 E VDD VDD pm1p2_svt_lp W=360.00n L=60.00n
MM39 net_0157 RN VDD VDD pm1p2_svt_lp W=200.00n L=60.00n
MM32 en E VDD VDD pm1p2_svt_lp W=300.00n L=60.00n
MM29 c cn VDD VDD pm1p2_svt_lp W=450.0n L=60.00n
MM28 cn CK VDD VDD pm1p2_svt_lp W=300.00n L=60.00n
MM26 VDD s net109 VDD pm1p2_svt_lp W=300.00n L=60.00n
MM25 net109 c net43 VDD pm1p2_svt_lp W=300.00n L=60.00n
MM21 Q net43 VDD VDD pm1p2_svt_lp W=1.3u L=60.00n
MM18 s net43 VDD VDD pm1p2_svt_lp W=400.00n L=60.00n
MM35 net43 cn net_0211 VDD pm1p2_svt_lp W=500.00n L=60.00n
MM36 net_0211 m VDD VDD pm1p2_svt_lp W=500.00n L=60.00n
MM14 net117 cn net_0144 VDD pm1p2_svt_lp W=300.00n L=60.00n
MM13 VDD m net117 VDD pm1p2_svt_lp W=300.00n L=60.00n
MM10 net_0157 D net128 VDD pm1p2_svt_lp W=360.00n L=60.00n
MM8 net128 en VDD VDD pm1p2_svt_lp W=360.00n L=60.00n
MM4 net_0157 c net_0144 VDD pm1p2_svt_lp W=400.00n L=60.00n
MM1 m net_0144 VDD VDD pm1p2_svt_lp W=400.00n L=60.00n
.ENDS

.SUBCKT EDFFTRQX1H9R CK D E Q RN VDD VSS
MM40 net_0157 s net_0149 VSS nm1p2_svt_lp W=340.00n L=60.00n
MM41 net_0149 en net_0164 VSS nm1p2_svt_lp W=340.00n L=60.00n
MM42 net_0164 RN VSS VSS nm1p2_svt_lp W=385.00n L=60.00n
MM31 en E VSS VSS nm1p2_svt_lp W=300.00n L=60.00n
MM33 net43 c net_0136 VSS nm1p2_svt_lp W=280.00n L=60.00n
MM34 net_0136 m VSS VSS nm1p2_svt_lp W=280.00n L=60.00n
MM30 c cn VSS VSS nm1p2_svt_lp W=300.00n L=60.00n
MM27 cn CK VSS VSS nm1p2_svt_lp W=200.00n L=60.00n
MM24 net48 cn net43 VSS nm1p2_svt_lp W=200.00n L=60.00n
MM23 VSS s net48 VSS nm1p2_svt_lp W=200.00n L=60.00n
MM22 Q net43 VSS VSS nm1p2_svt_lp W=290.00n L=60.00n
MM17 s net43 VSS VSS nm1p2_svt_lp W=200.00n L=60.00n
MM12 net52 c net_0144 VSS nm1p2_svt_lp W=185.00n L=60.00n
MM11 VSS m net52 VSS nm1p2_svt_lp W=185.00n L=60.00n
MM9 net_0157 D net69 VSS nm1p2_svt_lp W=340.00n L=60.00n
MM3 net_0157 cn net_0144 VSS nm1p2_svt_lp W=355.00n L=60.00n
MM7 net69 E net_0164 VSS nm1p2_svt_lp W=340.00n L=60.00n
MM0 m net_0144 VSS VSS nm1p2_svt_lp W=400.00n L=60.00n
MM37 net_0157 s net_0228 VDD pm1p2_svt_lp W=360.00n L=60.00n
MM38 net_0228 E VDD VDD pm1p2_svt_lp W=360.00n L=60.00n
MM39 net_0157 RN VDD VDD pm1p2_svt_lp W=200.00n L=60.00n
MM32 en E VDD VDD pm1p2_svt_lp W=415.00n L=60.00n
MM29 c cn VDD VDD pm1p2_svt_lp W=450.0n L=60.00n
MM28 cn CK VDD VDD pm1p2_svt_lp W=300.00n L=60.00n
MM26 VDD s net109 VDD pm1p2_svt_lp W=300.00n L=60.00n
MM25 net109 c net43 VDD pm1p2_svt_lp W=300.00n L=60.00n
MM21 Q net43 VDD VDD pm1p2_svt_lp W=440.00n L=60.00n
MM18 s net43 VDD VDD pm1p2_svt_lp W=300.00n L=60.00n
MM35 net43 cn net_0211 VDD pm1p2_svt_lp W=300.00n L=60.00n
MM36 net_0211 m VDD VDD pm1p2_svt_lp W=300.00n L=60.00n
MM14 net117 cn net_0144 VDD pm1p2_svt_lp W=300.00n L=60.00n
MM13 VDD m net117 VDD pm1p2_svt_lp W=300.00n L=60.00n
MM10 net_0157 D net128 VDD pm1p2_svt_lp W=360.00n L=60.00n
MM8 net128 en VDD VDD pm1p2_svt_lp W=360.00n L=60.00n
MM4 net_0157 c net_0144 VDD pm1p2_svt_lp W=555.00n L=60.00n
MM1 m net_0144 VDD VDD pm1p2_svt_lp W=600.00n L=60.00n
.ENDS

.SUBCKT EDFFTRQX2H9R CK D E Q RN VDD VSS
MM40 net_0157 s net_0149 VSS nm1p2_svt_lp W=340.00n L=60.00n
MM41 net_0149 en net_0164 VSS nm1p2_svt_lp W=340.00n L=60.00n
MM42 net_0164 RN VSS VSS nm1p2_svt_lp W=385.00n L=60.00n
MM31 en E VSS VSS nm1p2_svt_lp W=200.00n L=60.00n
MM33 net43 c net_0136 VSS nm1p2_svt_lp W=420.00n L=60.00n
MM34 net_0136 m VSS VSS nm1p2_svt_lp W=420.00n L=60.00n
MM30 c cn VSS VSS nm1p2_svt_lp W=300.00n L=60.00n
MM27 cn CK VSS VSS nm1p2_svt_lp W=200.00n L=60.00n
MM24 net48 cn net43 VSS nm1p2_svt_lp W=200.00n L=60.00n
MM23 VSS s net48 VSS nm1p2_svt_lp W=200.00n L=60.00n
MM22 Q net43 VSS VSS nm1p2_svt_lp W=430.00n L=60.00n
MM17 s net43 VSS VSS nm1p2_svt_lp W=200.00n L=60.00n
MM12 net52 c net_0144 VSS nm1p2_svt_lp W=185.00n L=60.00n
MM11 VSS m net52 VSS nm1p2_svt_lp W=185.00n L=60.00n
MM9 net_0157 D net69 VSS nm1p2_svt_lp W=340.00n L=60.00n
MM3 net_0157 cn net_0144 VSS nm1p2_svt_lp W=355.00n L=60.00n
MM7 net69 E net_0164 VSS nm1p2_svt_lp W=340.00n L=60.00n
MM0 m net_0144 VSS VSS nm1p2_svt_lp W=400.00n L=60.00n
MM37 net_0157 s net_0228 VDD pm1p2_svt_lp W=360.00n L=60.00n
MM38 net_0228 E VDD VDD pm1p2_svt_lp W=360.00n L=60.00n
MM39 net_0157 RN VDD VDD pm1p2_svt_lp W=200.00n L=60.00n
MM32 en E VDD VDD pm1p2_svt_lp W=300.00n L=60.00n
MM29 c cn VDD VDD pm1p2_svt_lp W=450.0n L=60.00n
MM28 cn CK VDD VDD pm1p2_svt_lp W=300.00n L=60.00n
MM26 VDD s net109 VDD pm1p2_svt_lp W=300.00n L=60.00n
MM25 net109 c net43 VDD pm1p2_svt_lp W=300.00n L=60.00n
MM21 Q net43 VDD VDD pm1p2_svt_lp W=650.00n L=60.00n
MM18 s net43 VDD VDD pm1p2_svt_lp W=300.00n L=60.00n
MM35 net43 cn net_0211 VDD pm1p2_svt_lp W=440.00n L=60.00n
MM36 net_0211 m VDD VDD pm1p2_svt_lp W=440.00n L=60.00n
MM14 net117 cn net_0144 VDD pm1p2_svt_lp W=300.00n L=60.00n
MM13 VDD m net117 VDD pm1p2_svt_lp W=300.00n L=60.00n
MM10 net_0157 D net128 VDD pm1p2_svt_lp W=360.00n L=60.00n
MM8 net128 en VDD VDD pm1p2_svt_lp W=360.00n L=60.00n
MM4 net_0157 c net_0144 VDD pm1p2_svt_lp W=555.00n L=60.00n
MM1 m net_0144 VDD VDD pm1p2_svt_lp W=600.00n L=60.00n
.ENDS

.SUBCKT EDFFTRQX4H9R CK D E Q RN VDD VSS
MM40 net_0157 s net_0149 VSS nm1p2_svt_lp W=340.00n L=60.00n
MM41 net_0149 en net_0164 VSS nm1p2_svt_lp W=340.00n L=60.00n
MM42 net_0164 RN VSS VSS nm1p2_svt_lp W=385.00n L=60.00n
MM31 en E VSS VSS nm1p2_svt_lp W=300.00n L=60.00n
MM33 net43 c net_0136 VSS nm1p2_svt_lp W=430.00n L=60.00n
MM34 net_0136 m VSS VSS nm1p2_svt_lp W=430.00n L=60.00n
MM30 c cn VSS VSS nm1p2_svt_lp W=300.00n L=60.00n
MM27 cn CK VSS VSS nm1p2_svt_lp W=200.0n L=60.00n
MM24 net48 cn net43 VSS nm1p2_svt_lp W=200.00n L=60.00n
MM23 VSS s net48 VSS nm1p2_svt_lp W=200.00n L=60.00n
MM22 Q net43 VSS VSS nm1p2_svt_lp W=860.00n L=60.00n
MM17 s net43 VSS VSS nm1p2_svt_lp W=200.00n L=60.00n
MM12 net52 c net_0144 VSS nm1p2_svt_lp W=185.00n L=60.00n
MM11 VSS m net52 VSS nm1p2_svt_lp W=185.00n L=60.00n
MM9 net_0157 D net69 VSS nm1p2_svt_lp W=340.00n L=60.00n
MM3 net_0157 cn net_0144 VSS nm1p2_svt_lp W=355.00n L=60.00n
MM7 net69 E net_0164 VSS nm1p2_svt_lp W=340.00n L=60.00n
MM0 m net_0144 VSS VSS nm1p2_svt_lp W=400.00n L=60.00n
MM37 net_0157 s net_0228 VDD pm1p2_svt_lp W=360.00n L=60.00n
MM38 net_0228 E VDD VDD pm1p2_svt_lp W=360.00n L=60.00n
MM39 net_0157 RN VDD VDD pm1p2_svt_lp W=200.00n L=60.00n
MM32 en E VDD VDD pm1p2_svt_lp W=450.00n L=60.00n
MM29 c cn VDD VDD pm1p2_svt_lp W=450.0n L=60.00n
MM28 cn CK VDD VDD pm1p2_svt_lp W=300.00n L=60.00n
MM26 VDD s net109 VDD pm1p2_svt_lp W=300.00n L=60.00n
MM25 net109 c net43 VDD pm1p2_svt_lp W=300.00n L=60.00n
MM21 Q net43 VDD VDD pm1p2_svt_lp W=1.3u L=60.00n
MM18 s net43 VDD VDD pm1p2_svt_lp W=300.00n L=60.00n
MM35 net43 cn net_0211 VDD pm1p2_svt_lp W=440.00n L=60.00n
MM36 net_0211 m VDD VDD pm1p2_svt_lp W=440.00n L=60.00n
MM14 net117 cn net_0144 VDD pm1p2_svt_lp W=300.00n L=60.00n
MM13 VDD m net117 VDD pm1p2_svt_lp W=300.00n L=60.00n
MM10 net_0157 D net128 VDD pm1p2_svt_lp W=360.00n L=60.00n
MM8 net128 en VDD VDD pm1p2_svt_lp W=360.00n L=60.00n
MM4 net_0157 c net_0144 VDD pm1p2_svt_lp W=555.00n L=60.00n
MM1 m net_0144 VDD VDD pm1p2_svt_lp W=600.00n L=60.00n
.ENDS

.SUBCKT SDFFX1H9R CK D Q QN SE SI VDD VSS
MM52 QN s VSS VSS nm1p2_svt_lp W=290.00n L=60.00n
MM46 net_0107 SI VSS VSS nm1p2_svt_lp W=200.00n L=60.00n
MM45 net_0163 SE net_0107 VSS nm1p2_svt_lp W=200.00n L=60.00n
MM39 ps c net_099 VSS nm1p2_svt_lp W=280.00n L=60.00n
MM48 SEN SE VSS VSS nm1p2_svt_lp W=200.00n L=60.00n
MM40 net_099 m VSS VSS nm1p2_svt_lp W=280.00n L=60.00n
MM43 net_0123 SEN VSS VSS nm1p2_svt_lp W=300.00n L=60.00n
MM30 c cn VSS VSS nm1p2_svt_lp W=290.00n L=60.00n
MM27 cn CK VSS VSS nm1p2_svt_lp W=200.00n L=60.00n
MM24 net48 cn ps VSS nm1p2_svt_lp W=200.00n L=60.00n
MM23 VSS s net48 VSS nm1p2_svt_lp W=200.00n L=60.00n
MM19 Q ps VSS VSS nm1p2_svt_lp W=290.00n L=60.00n
MM17 s ps VSS VSS nm1p2_svt_lp W=200.00n L=60.00n
MM12 net52 c net_0159 VSS nm1p2_svt_lp W=200.00n L=60.00n
MM11 VSS m net52 VSS nm1p2_svt_lp W=200.00n L=60.00n
MM9 net_0159 cn net_0163 VSS nm1p2_svt_lp W=300.00n L=60.00n
MM42 net_0163 D net_0123 VSS nm1p2_svt_lp W=300.00n L=60.00n
MM0 m net_0159 VSS VSS nm1p2_svt_lp W=290.00n L=60.00n
MM53 QN s VDD VDD pm1p2_svt_lp W=440.00n L=60.00n
MM51 net128 SEN net_0174 VDD pm1p2_svt_lp W=300.00n L=60.00n
MM50 net_0174 SI VDD VDD pm1p2_svt_lp W=300.00n L=60.00n
MM38 ps cn net_0158 VDD pm1p2_svt_lp W=300.00n L=60.00n
MM41 net_0158 m VDD VDD pm1p2_svt_lp W=300.00n L=60.00n
MM49 SEN SE VDD VDD pm1p2_svt_lp W=300.00n L=60.00n
MM29 c cn VDD VDD pm1p2_svt_lp W=440.00n L=60.00n
MM28 cn CK VDD VDD pm1p2_svt_lp W=300.00n L=60.00n
MM26 VDD s net109 VDD pm1p2_svt_lp W=300.00n L=60.00n
MM25 net109 c ps VDD pm1p2_svt_lp W=300.00n L=60.00n
MM20 Q ps VDD VDD pm1p2_svt_lp W=440.00n L=60.00n
MM18 s ps VDD VDD pm1p2_svt_lp W=300.00n L=60.00n
MM14 net117 cn net_0159 VDD pm1p2_svt_lp W=300.00n L=60.00n
MM13 VDD m net117 VDD pm1p2_svt_lp W=300.00n L=60.00n
MM10 net_0159 c net128 VDD pm1p2_svt_lp W=450.00n L=60.00n
MM44 net_0230 SE VDD VDD pm1p2_svt_lp W=450.00n L=60.00n
MM47 net128 D net_0230 VDD pm1p2_svt_lp W=450.00n L=60.00n
MM1 m net_0159 VDD VDD pm1p2_svt_lp W=440.00n L=60.00n
.ENDS

.SUBCKT SDFFX2H9R CK D Q QN SE SI VDD VSS
MM52 QN s VSS VSS nm1p2_svt_lp W=430.00n L=60.00n
MM46 net_0107 SI VSS VSS nm1p2_svt_lp W=200.00n L=60.00n
MM45 net_0163 SE net_0107 VSS nm1p2_svt_lp W=200.00n L=60.00n
MM39 ps c net_099 VSS nm1p2_svt_lp W=400.00n L=60.00n
MM48 SEN SE VSS VSS nm1p2_svt_lp W=200.00n L=60.00n
MM40 net_099 m VSS VSS nm1p2_svt_lp W=400.00n L=60.00n
MM43 net_0123 SEN VSS VSS nm1p2_svt_lp W=300.00n L=60.00n
MM30 c cn VSS VSS nm1p2_svt_lp W=290.00n L=60.00n
MM27 cn CK VSS VSS nm1p2_svt_lp W=200.00n L=60.00n
MM24 net48 cn ps VSS nm1p2_svt_lp W=200.00n L=60.00n
MM23 VSS s net48 VSS nm1p2_svt_lp W=200.00n L=60.00n
MM19 Q ps VSS VSS nm1p2_svt_lp W=430.00n L=60.00n
MM17 s ps VSS VSS nm1p2_svt_lp W=200.00n L=60.00n
MM12 net52 c net_0159 VSS nm1p2_svt_lp W=200.00n L=60.00n
MM11 VSS m net52 VSS nm1p2_svt_lp W=200.00n L=60.00n
MM9 net_0159 cn net_0163 VSS nm1p2_svt_lp W=300.00n L=60.00n
MM42 net_0163 D net_0123 VSS nm1p2_svt_lp W=300.00n L=60.00n
MM0 m net_0159 VSS VSS nm1p2_svt_lp W=430.00n L=60.00n
MM53 QN s VDD VDD pm1p2_svt_lp W=650.00n L=60.00n
MM51 net128 SEN net_0174 VDD pm1p2_svt_lp W=300.00n L=60.00n
MM50 net_0174 SI VDD VDD pm1p2_svt_lp W=300.00n L=60.00n
MM38 ps cn net_0158 VDD pm1p2_svt_lp W=440.00n L=60.00n
MM41 net_0158 m VDD VDD pm1p2_svt_lp W=440.00n L=60.00n
MM49 SEN SE VDD VDD pm1p2_svt_lp W=300.00n L=60.00n
MM29 c cn VDD VDD pm1p2_svt_lp W=440.00n L=60.00n
MM28 cn CK VDD VDD pm1p2_svt_lp W=300.00n L=60.00n
MM26 VDD s net109 VDD pm1p2_svt_lp W=300.00n L=60.00n
MM25 net109 c ps VDD pm1p2_svt_lp W=300.00n L=60.00n
MM20 Q ps VDD VDD pm1p2_svt_lp W=650.00n L=60.00n
MM18 s ps VDD VDD pm1p2_svt_lp W=300.00n L=60.00n
MM14 net117 cn net_0159 VDD pm1p2_svt_lp W=300.00n L=60.00n
MM13 VDD m net117 VDD pm1p2_svt_lp W=300.00n L=60.00n
MM10 net_0159 c net128 VDD pm1p2_svt_lp W=450.00n L=60.00n
MM44 net_0230 SE VDD VDD pm1p2_svt_lp W=450.00n L=60.00n
MM47 net128 D net_0230 VDD pm1p2_svt_lp W=450.00n L=60.00n
MM1 m net_0159 VDD VDD pm1p2_svt_lp W=650.00n L=60.00n
.ENDS

.SUBCKT SDFFX4H9R CK D Q QN SE SI VDD VSS
MM52 QN s VSS VSS nm1p2_svt_lp W=860.00n L=60.00n
MM46 net_0107 SI VSS VSS nm1p2_svt_lp W=200.00n L=60.00n
MM45 net_0163 SE net_0107 VSS nm1p2_svt_lp W=200.00n L=60.00n
MM39 ps c net_099 VSS nm1p2_svt_lp W=420.00n L=60.00n
MM48 SEN SE VSS VSS nm1p2_svt_lp W=200.00n L=60.00n
MM40 net_099 m VSS VSS nm1p2_svt_lp W=430.00n L=60.00n
MM43 net_0123 SEN VSS VSS nm1p2_svt_lp W=300.00n L=60.00n
MM30 c cn VSS VSS nm1p2_svt_lp W=290.00n L=60.00n
MM27 cn CK VSS VSS nm1p2_svt_lp W=200.00n L=60.00n
MM24 net48 cn ps VSS nm1p2_svt_lp W=300.00n L=60.00n
MM23 VSS s net48 VSS nm1p2_svt_lp W=300.00n L=60.00n
MM19 Q ps VSS VSS nm1p2_svt_lp W=860.00n L=60.00n
MM17 s ps VSS VSS nm1p2_svt_lp W=290.00n L=60.00n
MM12 net52 c net_0159 VSS nm1p2_svt_lp W=200.00n L=60.00n
MM11 VSS m net52 VSS nm1p2_svt_lp W=200.00n L=60.00n
MM9 net_0159 cn net_0163 VSS nm1p2_svt_lp W=300.00n L=60.00n
MM42 net_0163 D net_0123 VSS nm1p2_svt_lp W=300.00n L=60.00n
MM0 m net_0159 VSS VSS nm1p2_svt_lp W=430.00n L=60.00n
MM53 QN s VDD VDD pm1p2_svt_lp W=1.3u L=60.00n
MM51 net128 SEN net_0174 VDD pm1p2_svt_lp W=300.00n L=60.00n
MM50 net_0174 SI VDD VDD pm1p2_svt_lp W=300.00n L=60.00n
MM38 ps cn net_0158 VDD pm1p2_svt_lp W=520.0n L=60.00n
MM41 net_0158 m VDD VDD pm1p2_svt_lp W=520.0n L=60.00n
MM49 SEN SE VDD VDD pm1p2_svt_lp W=300.00n L=60.00n
MM29 c cn VDD VDD pm1p2_svt_lp W=440.00n L=60.00n
MM28 cn CK VDD VDD pm1p2_svt_lp W=300.0n L=60.00n
MM26 VDD s net109 VDD pm1p2_svt_lp W=300.00n L=60.00n
MM25 net109 c ps VDD pm1p2_svt_lp W=300.00n L=60.00n
MM20 Q ps VDD VDD pm1p2_svt_lp W=1.3u L=60.00n
MM18 s ps VDD VDD pm1p2_svt_lp W=440.00n L=60.00n
MM14 net117 cn net_0159 VDD pm1p2_svt_lp W=300.00n L=60.00n
MM13 VDD m net117 VDD pm1p2_svt_lp W=300.00n L=60.00n
MM10 net_0159 c net128 VDD pm1p2_svt_lp W=450.00n L=60.00n
MM44 net_0230 SE VDD VDD pm1p2_svt_lp W=450.00n L=60.00n
MM47 net128 D net_0230 VDD pm1p2_svt_lp W=450.00n L=60.00n
MM1 m net_0159 VDD VDD pm1p2_svt_lp W=650.00n L=60.00n
.ENDS

.SUBCKT SDFFNX1H9R CKN D Q QN SE SI VDD VSS
MM52 QN s VSS VSS nm1p2_svt_lp W=290.00n L=60.00n
MM46 net_0107 SE VSS VSS nm1p2_svt_lp W=250.00n L=60.00n
MM45 net_0163 SI net_0107 VSS nm1p2_svt_lp W=250.00n L=60.00n
MM39 ps c net_099 VSS nm1p2_svt_lp W=230.00n L=60.00n
MM48 SEN SE VSS VSS nm1p2_svt_lp W=200.00n L=60.00n
MM40 net_099 m VSS VSS nm1p2_svt_lp W=230.00n L=60.00n
MM43 net_0123 SEN VSS VSS nm1p2_svt_lp W=250.00n L=60.00n
MM30 cn c VSS VSS nm1p2_svt_lp W=250.00n L=60.00n
MM27 c CKN VSS VSS nm1p2_svt_lp W=200.00n L=60.00n
MM24 net48 cn ps VSS nm1p2_svt_lp W=200.00n L=60.00n
MM23 VSS s net48 VSS nm1p2_svt_lp W=200.00n L=60.00n
MM19 Q ps VSS VSS nm1p2_svt_lp W=290.00n L=60.00n
MM17 s ps VSS VSS nm1p2_svt_lp W=240.00n L=60.00n
MM12 net52 c net_0159 VSS nm1p2_svt_lp W=200.00n L=60.00n
MM11 VSS m net52 VSS nm1p2_svt_lp W=200.00n L=60.00n
MM9 net_0159 cn net_0163 VSS nm1p2_svt_lp W=250.00n L=60.00n
MM42 net_0163 D net_0123 VSS nm1p2_svt_lp W=250.00n L=60.00n
MM0 m net_0159 VSS VSS nm1p2_svt_lp W=270.00n L=60.00n
MM53 QN s VDD VDD pm1p2_svt_lp W=440.00n L=60.00n
MM51 net128 SI net_0174 VDD pm1p2_svt_lp W=650.00n L=60.00n
MM50 net_0174 SEN VDD VDD pm1p2_svt_lp W=650.00n L=60.00n
MM38 ps cn net_0158 VDD pm1p2_svt_lp W=650.00n L=60.00n
MM41 net_0158 m VDD VDD pm1p2_svt_lp W=650.00n L=60.00n
MM49 SEN SE VDD VDD pm1p2_svt_lp W=300.00n L=60.00n
MM29 cn c VDD VDD pm1p2_svt_lp W=380.00n L=60.00n
MM28 c CKN VDD VDD pm1p2_svt_lp W=300.00n L=60.00n
MM26 VDD s net109 VDD pm1p2_svt_lp W=300.00n L=60.00n
MM25 net109 c ps VDD pm1p2_svt_lp W=300.00n L=60.00n
MM20 Q ps VDD VDD pm1p2_svt_lp W=440.00n L=60.00n
MM18 s ps VDD VDD pm1p2_svt_lp W=360.00n L=60.00n
MM14 net117 cn net_0159 VDD pm1p2_svt_lp W=300.00n L=60.00n
MM13 VDD m net117 VDD pm1p2_svt_lp W=300.00n L=60.00n
MM10 net_0159 c net128 VDD pm1p2_svt_lp W=650.00n L=60.00n
MM44 net_0230 SE VDD VDD pm1p2_svt_lp W=650.00n L=60.00n
MM47 net128 D net_0230 VDD pm1p2_svt_lp W=650.00n L=60.00n
MM1 m net_0159 VDD VDD pm1p2_svt_lp W=400.00n L=60.00n
.ENDS

.SUBCKT SDFFNX2H9R CKN D Q QN SE SI VDD VSS
MM52 QN s VSS VSS nm1p2_svt_lp W=430.00n L=60.00n
MM46 net_0107 SE VSS VSS nm1p2_svt_lp W=250.00n L=60.00n
MM45 net_0163 SI net_0107 VSS nm1p2_svt_lp W=250.00n L=60.00n
MM39 ps c net_099 VSS nm1p2_svt_lp W=230.00n L=60.00n
MM48 SEN SE VSS VSS nm1p2_svt_lp W=200.00n L=60.00n
MM40 net_099 m VSS VSS nm1p2_svt_lp W=230.00n L=60.00n
MM43 net_0123 SEN VSS VSS nm1p2_svt_lp W=250.00n L=60.00n
MM30 cn c VSS VSS nm1p2_svt_lp W=290.00n L=60.00n
MM27 c CKN VSS VSS nm1p2_svt_lp W=200.00n L=60.00n
MM24 net48 cn ps VSS nm1p2_svt_lp W=200.00n L=60.00n
MM23 VSS s net48 VSS nm1p2_svt_lp W=200.00n L=60.00n
MM19 Q ps VSS VSS nm1p2_svt_lp W=430.00n L=60.00n
MM17 s ps VSS VSS nm1p2_svt_lp W=290.00n L=60.00n
MM12 net52 c net_0159 VSS nm1p2_svt_lp W=200.00n L=60.00n
MM11 VSS m net52 VSS nm1p2_svt_lp W=200.00n L=60.00n
MM9 net_0159 cn net_0163 VSS nm1p2_svt_lp W=250.00n L=60.00n
MM42 net_0163 D net_0123 VSS nm1p2_svt_lp W=250.00n L=60.00n
MM0 m net_0159 VSS VSS nm1p2_svt_lp W=390.00n L=60.00n
MM53 QN s VDD VDD pm1p2_svt_lp W=650.00n L=60.00n
MM51 net128 SI net_0174 VDD pm1p2_svt_lp W=650.00n L=60.00n
MM50 net_0174 SEN VDD VDD pm1p2_svt_lp W=650.00n L=60.00n
MM38 ps cn net_0158 VDD pm1p2_svt_lp W=650.00n L=60.00n
MM41 net_0158 m VDD VDD pm1p2_svt_lp W=650.00n L=60.00n
MM49 SEN SE VDD VDD pm1p2_svt_lp W=300.00n L=60.00n
MM29 cn c VDD VDD pm1p2_svt_lp W=440.00n L=60.00n
MM28 c CKN VDD VDD pm1p2_svt_lp W=300.00n L=60.00n
MM26 VDD s net109 VDD pm1p2_svt_lp W=300.00n L=60.00n
MM25 net109 c ps VDD pm1p2_svt_lp W=300.00n L=60.00n
MM20 Q ps VDD VDD pm1p2_svt_lp W=650.00n L=60.00n
MM18 s ps VDD VDD pm1p2_svt_lp W=440.00n L=60.00n
MM14 net117 cn net_0159 VDD pm1p2_svt_lp W=300.00n L=60.00n
MM13 VDD m net117 VDD pm1p2_svt_lp W=300.00n L=60.00n
MM10 net_0159 c net128 VDD pm1p2_svt_lp W=650.00n L=60.00n
MM44 net_0230 SE VDD VDD pm1p2_svt_lp W=650.00n L=60.00n
MM47 net128 D net_0230 VDD pm1p2_svt_lp W=650.00n L=60.00n
MM1 m net_0159 VDD VDD pm1p2_svt_lp W=580.00n L=60.00n
.ENDS

.SUBCKT SDFFNX4H9R CKN D Q QN SE SI VDD VSS
MM52 QN s VSS VSS nm1p2_svt_lp W=860.00n L=60.00n
MM46 net_0107 SE VSS VSS nm1p2_svt_lp W=260.00n L=60.00n
MM45 net_0163 SI net_0107 VSS nm1p2_svt_lp W=260.00n L=60.00n
MM39 ps c net_099 VSS nm1p2_svt_lp W=250.00n L=60.00n
MM48 SEN SE VSS VSS nm1p2_svt_lp W=200.00n L=60.00n
MM40 net_099 m VSS VSS nm1p2_svt_lp W=250.00n L=60.00n
MM43 net_0123 SEN VSS VSS nm1p2_svt_lp W=260.00n L=60.00n
MM30 cn c VSS VSS nm1p2_svt_lp W=290.00n L=60.00n
MM27 c CKN VSS VSS nm1p2_svt_lp W=290.00n L=60.00n
MM24 net48 cn ps VSS nm1p2_svt_lp W=200.00n L=60.00n
MM23 VSS s net48 VSS nm1p2_svt_lp W=200.00n L=60.00n
MM19 Q ps VSS VSS nm1p2_svt_lp W=860.00n L=60.00n
MM17 s ps VSS VSS nm1p2_svt_lp W=360.00n L=60.00n
MM12 net52 c net_0159 VSS nm1p2_svt_lp W=200.00n L=60.00n
MM11 VSS m net52 VSS nm1p2_svt_lp W=200.00n L=60.00n
MM9 net_0159 cn net_0163 VSS nm1p2_svt_lp W=260.00n L=60.00n
MM42 net_0163 D net_0123 VSS nm1p2_svt_lp W=260.00n L=60.00n
MM0 m net_0159 VSS VSS nm1p2_svt_lp W=430.00n L=60.00n
MM53 QN s VDD VDD pm1p2_svt_lp W=1.3u L=60.00n
MM51 net128 SI net_0174 VDD pm1p2_svt_lp W=650.00n L=60.00n
MM50 net_0174 SEN VDD VDD pm1p2_svt_lp W=650.00n L=60.00n
MM38 ps cn net_0158 VDD pm1p2_svt_lp W=650.00n L=60.00n
MM41 net_0158 m VDD VDD pm1p2_svt_lp W=650.00n L=60.00n
MM49 SEN SE VDD VDD pm1p2_svt_lp W=300.00n L=60.00n
MM29 cn c VDD VDD pm1p2_svt_lp W=440.00n L=60.00n
MM28 c CKN VDD VDD pm1p2_svt_lp W=430.00n L=60.00n
MM26 VDD s net109 VDD pm1p2_svt_lp W=300.00n L=60.00n
MM25 net109 c ps VDD pm1p2_svt_lp W=300.00n L=60.00n
MM20 Q ps VDD VDD pm1p2_svt_lp W=1.3u L=60.00n
MM18 s ps VDD VDD pm1p2_svt_lp W=540.00n L=60.00n
MM14 net117 cn net_0159 VDD pm1p2_svt_lp W=300.00n L=60.00n
MM13 VDD m net117 VDD pm1p2_svt_lp W=300.00n L=60.00n
MM10 net_0159 c net128 VDD pm1p2_svt_lp W=650.00n L=60.00n
MM44 net_0230 SE VDD VDD pm1p2_svt_lp W=650.00n L=60.00n
MM47 net128 D net_0230 VDD pm1p2_svt_lp W=650.00n L=60.00n
MM1 m net_0159 VDD VDD pm1p2_svt_lp W=650.00n L=60.00n
.ENDS

.SUBCKT SDFFRX1H9R CK D Q QN RDN SE SI VDD VSS
MM53 QN ps VSS VSS nm1p2_svt_lp W=290.00n L=60.00n
MM45 net_0137 sen net_0133 VSS nm1p2_svt_lp W=290.00n L=60.00n
MM46 net_0133 D net_0104 VSS nm1p2_svt_lp W=290.00n L=60.00n
MM3 net_0154 c ps VSS nm1p2_svt_lp W=290.00n L=60.00n
MM49 net_0137 cn net_0132 VSS nm1p2_svt_lp W=200.00n L=60.00n
MM44 net_0104 RDN VSS VSS nm1p2_svt_lp W=290.00n L=60.00n
MM42 VSS RDN net_0119 VSS nm1p2_svt_lp W=200.00n L=60.00n
MM51 sen SE VSS VSS nm1p2_svt_lp W=200n L=60.00n
MM39 s ps net_099 VSS nm1p2_svt_lp W=290.00n L=60.00n
MM40 net_099 RDN VSS VSS nm1p2_svt_lp W=290.00n L=60.00n
MM30 c cn VSS VSS nm1p2_svt_lp W=200n L=60.00n
MM27 cn CK VSS VSS nm1p2_svt_lp W=200n L=60.00n
MM24 net48 cn ps VSS nm1p2_svt_lp W=200.00n L=60.00n
MM23 VSS s net48 VSS nm1p2_svt_lp W=200.00n L=60.00n
MM19 Q s VSS VSS nm1p2_svt_lp W=290.00n L=60.00n
MM12 net52 c net_0132 VSS nm1p2_svt_lp W=200.00n L=60.00n
MM11 net_0119 net_0154 net52 VSS nm1p2_svt_lp W=200.00n L=60.00n
MM9 net_0137 SE net69 VSS nm1p2_svt_lp W=290.00n L=60.00n
MM7 net69 SI net_0104 VSS nm1p2_svt_lp W=290.00n L=60.00n
MM0 net_0154 net_0132 VSS VSS nm1p2_svt_lp W=290.00n L=60.00n
MM54 QN ps VDD VDD pm1p2_svt_lp W=440.00n L=60.00n
MM47 net_0137 SE net_0212 VDD pm1p2_svt_lp W=330.00n L=60.00n
MM48 net_0212 D VDD VDD pm1p2_svt_lp W=330.00n L=60.00n
MM43 net_0132 RDN VDD VDD pm1p2_svt_lp W=300.00n L=60.00n
MM52 sen SE VDD VDD pm1p2_svt_lp W=300.00n L=60.00n
MM38 s ps VDD VDD pm1p2_svt_lp W=300.00n L=60.00n
MM41 s RDN VDD VDD pm1p2_svt_lp W=300.00n L=60.00n
MM50 net_0137 c net_0132 VDD pm1p2_svt_lp W=300.00n L=60.00n
MM29 c cn VDD VDD pm1p2_svt_lp W=300.00n L=60.00n
MM28 cn CK VDD VDD pm1p2_svt_lp W=300.00n L=60.00n
MM26 VDD s net109 VDD pm1p2_svt_lp W=300.00n L=60.00n
MM25 net109 c ps VDD pm1p2_svt_lp W=300.00n L=60.00n
MM20 Q s VDD VDD pm1p2_svt_lp W=440.00n L=60.00n
MM4 net_0154 cn ps VDD pm1p2_svt_lp W=440.00n L=60.00n
MM14 net117 cn net_0132 VDD pm1p2_svt_lp W=300.00n L=60.00n
MM13 VDD net_0154 net117 VDD pm1p2_svt_lp W=300.00n L=60.00n
MM10 net_0137 sen net128 VDD pm1p2_svt_lp W=330.00n L=60.00n
MM8 net128 SI VDD VDD pm1p2_svt_lp W=330.00n L=60.00n
MM1 net_0154 net_0132 VDD VDD pm1p2_svt_lp W=440.00n L=60.00n
.ENDS

.SUBCKT SDFFRX2H9R CK D Q QN RDN SE SI VDD VSS
MM53 QN ps VSS VSS nm1p2_svt_lp W=430.00n L=60.00n
MM45 net_0137 sen net_0133 VSS nm1p2_svt_lp W=320.00n L=60.00n
MM46 net_0133 D net_0104 VSS nm1p2_svt_lp W=320.00n L=60.00n
MM3 net_0154 c ps VSS nm1p2_svt_lp W=360.00n L=60.00n
MM49 net_0137 cn net_0132 VSS nm1p2_svt_lp W=200.00n L=60.00n
MM44 net_0104 RDN VSS VSS nm1p2_svt_lp W=320.00n L=60.00n
MM42 VSS RDN net_0119 VSS nm1p2_svt_lp W=200.00n L=60.00n
MM51 sen SE VSS VSS nm1p2_svt_lp W=200n L=60.00n
MM39 s ps net_099 VSS nm1p2_svt_lp W=390.00n L=60.00n
MM40 net_099 RDN VSS VSS nm1p2_svt_lp W=390.00n L=60.00n
MM30 c cn VSS VSS nm1p2_svt_lp W=200n L=60.00n
MM27 cn CK VSS VSS nm1p2_svt_lp W=200n L=60.00n
MM24 net48 cn ps VSS nm1p2_svt_lp W=200.00n L=60.00n
MM23 VSS s net48 VSS nm1p2_svt_lp W=200.00n L=60.00n
MM19 Q s VSS VSS nm1p2_svt_lp W=430.00n L=60.00n
MM12 net52 c net_0132 VSS nm1p2_svt_lp W=200.00n L=60.00n
MM11 net_0119 net_0154 net52 VSS nm1p2_svt_lp W=200.00n L=60.00n
MM9 net_0137 SE net69 VSS nm1p2_svt_lp W=320.00n L=60.00n
MM7 net69 SI net_0104 VSS nm1p2_svt_lp W=320.00n L=60.00n
MM0 net_0154 net_0132 VSS VSS nm1p2_svt_lp W=350.00n L=60.00n
MM54 QN ps VDD VDD pm1p2_svt_lp W=650.00n L=60.00n
MM47 net_0137 SE net_0212 VDD pm1p2_svt_lp W=350.00n L=60.00n
MM48 net_0212 D VDD VDD pm1p2_svt_lp W=350.00n L=60.00n
MM43 net_0132 RDN VDD VDD pm1p2_svt_lp W=300.00n L=60.00n
MM52 sen SE VDD VDD pm1p2_svt_lp W=300.00n L=60.00n
MM38 s ps VDD VDD pm1p2_svt_lp W=400.00n L=60.00n
MM41 s RDN VDD VDD pm1p2_svt_lp W=300.00n L=60.00n
MM50 net_0137 c net_0132 VDD pm1p2_svt_lp W=300.00n L=60.00n
MM29 c cn VDD VDD pm1p2_svt_lp W=300.00n L=60.00n
MM28 cn CK VDD VDD pm1p2_svt_lp W=300.00n L=60.00n
MM26 VDD s net109 VDD pm1p2_svt_lp W=300.00n L=60.00n
MM25 net109 c ps VDD pm1p2_svt_lp W=300.00n L=60.00n
MM20 Q s VDD VDD pm1p2_svt_lp W=650.00n L=60.00n
MM4 net_0154 cn ps VDD pm1p2_svt_lp W=540.00n L=60.00n
MM14 net117 cn net_0132 VDD pm1p2_svt_lp W=300.00n L=60.00n
MM13 VDD net_0154 net117 VDD pm1p2_svt_lp W=300.00n L=60.00n
MM10 net_0137 sen net128 VDD pm1p2_svt_lp W=350.00n L=60.00n
MM8 net128 SI VDD VDD pm1p2_svt_lp W=350.00n L=60.00n
MM1 net_0154 net_0132 VDD VDD pm1p2_svt_lp W=540.00n L=60.00n
.ENDS

.SUBCKT SDFFRX4H9R CK D Q QN RDN SE SI VDD VSS
MM53 QN ps VSS VSS nm1p2_svt_lp W=430.00n L=60.00n m=2
MM45 net_0137 sen net_0133 VSS nm1p2_svt_lp W=430.00n L=60.00n
MM46 net_0133 D net_0104 VSS nm1p2_svt_lp W=430.00n L=60.00n
MM3 net_0154 c ps VSS nm1p2_svt_lp W=360.00n L=60.00n
MM49 net_0137 cn net_0132 VSS nm1p2_svt_lp W=340.00n L=60.00n
MM44 net_0104 RDN VSS VSS nm1p2_svt_lp W=400.00n L=60.00n
MM42 VSS RDN net_0119 VSS nm1p2_svt_lp W=200.00n L=60.00n
MM51 sen SE VSS VSS nm1p2_svt_lp W=200n L=60.00n
MM39 s ps net_099 VSS nm1p2_svt_lp W=300.00n L=60.00n m=2
MM40 net_099 RDN VSS VSS nm1p2_svt_lp W=300.00n L=60.00n m=2
MM30 c cn VSS VSS nm1p2_svt_lp W=430n L=60.00n
MM27 cn CK VSS VSS nm1p2_svt_lp W=300n L=60.00n
MM24 net48 cn ps VSS nm1p2_svt_lp W=200.00n L=60.00n
MM23 VSS s net48 VSS nm1p2_svt_lp W=200.00n L=60.00n
MM19 Q s VSS VSS nm1p2_svt_lp W=430.00n L=60.00n m=2
MM12 net52 c net_0132 VSS nm1p2_svt_lp W=200.00n L=60.00n
MM11 net_0119 net_0154 net52 VSS nm1p2_svt_lp W=200.00n L=60.00n
MM9 net_0137 SE net69 VSS nm1p2_svt_lp W=430.00n L=60.00n
MM7 net69 SI net_0104 VSS nm1p2_svt_lp W=430.00n L=60.00n
MM0 net_0154 net_0132 VSS VSS nm1p2_svt_lp W=350.00n L=60.00n
MM54 QN ps VDD VDD pm1p2_svt_lp W=650.00n L=60.00n m=2
MM47 net_0137 SE net_0212 VDD pm1p2_svt_lp W=500n L=60.00n
MM48 net_0212 D VDD VDD pm1p2_svt_lp W=500n L=60.00n
MM43 net_0132 RDN VDD VDD pm1p2_svt_lp W=300.00n L=60.00n
MM52 sen SE VDD VDD pm1p2_svt_lp W=300.00n L=60.00n
MM38 s ps VDD VDD pm1p2_svt_lp W=450.00n L=60.00n
MM41 s RDN VDD VDD pm1p2_svt_lp W=300.00n L=60.00n
MM50 net_0137 c net_0132 VDD pm1p2_svt_lp W=530.00n L=60.00n
MM29 c cn VDD VDD pm1p2_svt_lp W=650.00n L=60.00n
MM28 cn CK VDD VDD pm1p2_svt_lp W=450.00n L=60.00n
MM26 VDD s net109 VDD pm1p2_svt_lp W=300.00n L=60.00n
MM25 net109 c ps VDD pm1p2_svt_lp W=300.00n L=60.00n
MM20 Q s VDD VDD pm1p2_svt_lp W=650.00n L=60.00n m=2
MM4 net_0154 cn ps VDD pm1p2_svt_lp W=540.00n L=60.00n
MM14 net117 cn net_0132 VDD pm1p2_svt_lp W=300.00n L=60.00n
MM13 VDD net_0154 net117 VDD pm1p2_svt_lp W=300.00n L=60.00n
MM10 net_0137 sen net128 VDD pm1p2_svt_lp W=500n L=60.00n
MM8 net128 SI VDD VDD pm1p2_svt_lp W=500n L=60.00n
MM1 net_0154 net_0132 VDD VDD pm1p2_svt_lp W=540.00n L=60.00n
.ENDS

.SUBCKT SDFFRQX1H9R CK D Q RDN SE SI VDD VSS
MM45 net_0137 sen net_0133 VSS nm1p2_svt_lp W=290.00n L=60.00n
MM46 net_0133 D net_0104 VSS nm1p2_svt_lp W=290.00n L=60.00n
MM3 net_0154 c ps VSS nm1p2_svt_lp W=290.00n L=60.00n
MM49 net_0137 cn net_0132 VSS nm1p2_svt_lp W=200.00n L=60.00n
MM44 net_0104 RDN VSS VSS nm1p2_svt_lp W=290.00n L=60.00n
MM42 VSS RDN net_0119 VSS nm1p2_svt_lp W=200.00n L=60.00n
MM51 sen SE VSS VSS nm1p2_svt_lp W=200n L=60.00n
MM39 s ps net_099 VSS nm1p2_svt_lp W=290.00n L=60.00n
MM40 net_099 RDN VSS VSS nm1p2_svt_lp W=290.00n L=60.00n
MM30 c cn VSS VSS nm1p2_svt_lp W=200n L=60.00n
MM27 cn CK VSS VSS nm1p2_svt_lp W=200n L=60.00n
MM24 net48 cn ps VSS nm1p2_svt_lp W=200.00n L=60.00n
MM23 VSS s net48 VSS nm1p2_svt_lp W=200.00n L=60.00n
MM19 Q s VSS VSS nm1p2_svt_lp W=290.00n L=60.00n
MM12 net52 c net_0132 VSS nm1p2_svt_lp W=200.00n L=60.00n
MM11 net_0119 net_0154 net52 VSS nm1p2_svt_lp W=200.00n L=60.00n
MM9 net_0137 SE net69 VSS nm1p2_svt_lp W=290.00n L=60.00n
MM7 net69 SI net_0104 VSS nm1p2_svt_lp W=290.00n L=60.00n
MM0 net_0154 net_0132 VSS VSS nm1p2_svt_lp W=290.00n L=60.00n
MM47 net_0137 SE net_0212 VDD pm1p2_svt_lp W=330.00n L=60.00n
MM48 net_0212 D VDD VDD pm1p2_svt_lp W=330.00n L=60.00n
MM43 net_0132 RDN VDD VDD pm1p2_svt_lp W=300.00n L=60.00n
MM52 sen SE VDD VDD pm1p2_svt_lp W=300.00n L=60.00n
MM38 s ps VDD VDD pm1p2_svt_lp W=300.00n L=60.00n
MM41 s RDN VDD VDD pm1p2_svt_lp W=300.00n L=60.00n
MM50 net_0137 c net_0132 VDD pm1p2_svt_lp W=300.00n L=60.00n
MM29 c cn VDD VDD pm1p2_svt_lp W=300.00n L=60.00n
MM28 cn CK VDD VDD pm1p2_svt_lp W=300.00n L=60.00n
MM26 VDD s net109 VDD pm1p2_svt_lp W=300.00n L=60.00n
MM25 net109 c ps VDD pm1p2_svt_lp W=300.00n L=60.00n
MM20 Q s VDD VDD pm1p2_svt_lp W=440.00n L=60.00n
MM4 net_0154 cn ps VDD pm1p2_svt_lp W=440.00n L=60.00n
MM14 net117 cn net_0132 VDD pm1p2_svt_lp W=300.00n L=60.00n
MM13 VDD net_0154 net117 VDD pm1p2_svt_lp W=300.00n L=60.00n
MM10 net_0137 sen net128 VDD pm1p2_svt_lp W=330.00n L=60.00n
MM8 net128 SI VDD VDD pm1p2_svt_lp W=330.00n L=60.00n
MM1 net_0154 net_0132 VDD VDD pm1p2_svt_lp W=440.00n L=60.00n
.ENDS

.SUBCKT SDFFRQX2H9R CK D Q RDN SE SI VDD VSS
MM45 net_0137 sen net_0133 VSS nm1p2_svt_lp W=320.00n L=60.00n
MM46 net_0133 D net_0104 VSS nm1p2_svt_lp W=320.00n L=60.00n
MM3 net_0154 c ps VSS nm1p2_svt_lp W=360.00n L=60.00n
MM49 net_0137 cn net_0132 VSS nm1p2_svt_lp W=200.00n L=60.00n
MM44 net_0104 RDN VSS VSS nm1p2_svt_lp W=320.00n L=60.00n
MM42 VSS RDN net_0119 VSS nm1p2_svt_lp W=200.00n L=60.00n
MM51 sen SE VSS VSS nm1p2_svt_lp W=200n L=60.00n
MM39 s ps net_099 VSS nm1p2_svt_lp W=390.00n L=60.00n
MM40 net_099 RDN VSS VSS nm1p2_svt_lp W=390.00n L=60.00n
MM30 c cn VSS VSS nm1p2_svt_lp W=200n L=60.00n
MM27 cn CK VSS VSS nm1p2_svt_lp W=200n L=60.00n
MM24 net48 cn ps VSS nm1p2_svt_lp W=200.00n L=60.00n
MM23 VSS s net48 VSS nm1p2_svt_lp W=200.00n L=60.00n
MM19 Q s VSS VSS nm1p2_svt_lp W=430.00n L=60.00n
MM12 net52 c net_0132 VSS nm1p2_svt_lp W=200.00n L=60.00n
MM11 net_0119 net_0154 net52 VSS nm1p2_svt_lp W=200.00n L=60.00n
MM9 net_0137 SE net69 VSS nm1p2_svt_lp W=320.00n L=60.00n
MM7 net69 SI net_0104 VSS nm1p2_svt_lp W=320.00n L=60.00n
MM0 net_0154 net_0132 VSS VSS nm1p2_svt_lp W=350.00n L=60.00n
MM47 net_0137 SE net_0212 VDD pm1p2_svt_lp W=350.00n L=60.00n
MM48 net_0212 D VDD VDD pm1p2_svt_lp W=350.00n L=60.00n
MM43 net_0132 RDN VDD VDD pm1p2_svt_lp W=300.00n L=60.00n
MM52 sen SE VDD VDD pm1p2_svt_lp W=300.00n L=60.00n
MM38 s ps VDD VDD pm1p2_svt_lp W=400.00n L=60.00n
MM41 s RDN VDD VDD pm1p2_svt_lp W=300.00n L=60.00n
MM50 net_0137 c net_0132 VDD pm1p2_svt_lp W=300.00n L=60.00n
MM29 c cn VDD VDD pm1p2_svt_lp W=300.00n L=60.00n
MM28 cn CK VDD VDD pm1p2_svt_lp W=300.00n L=60.00n
MM26 VDD s net109 VDD pm1p2_svt_lp W=300.00n L=60.00n
MM25 net109 c ps VDD pm1p2_svt_lp W=300.00n L=60.00n
MM20 Q s VDD VDD pm1p2_svt_lp W=650.00n L=60.00n
MM4 net_0154 cn ps VDD pm1p2_svt_lp W=540.00n L=60.00n
MM14 net117 cn net_0132 VDD pm1p2_svt_lp W=300.00n L=60.00n
MM13 VDD net_0154 net117 VDD pm1p2_svt_lp W=300.00n L=60.00n
MM10 net_0137 sen net128 VDD pm1p2_svt_lp W=350.00n L=60.00n
MM8 net128 SI VDD VDD pm1p2_svt_lp W=350.00n L=60.00n
MM1 net_0154 net_0132 VDD VDD pm1p2_svt_lp W=540.00n L=60.00n
.ENDS

.SUBCKT SDFFRQX4H9R CK D Q RDN SE SI VDD VSS
MM45 net_0137 sen net_0133 VSS nm1p2_svt_lp W=430.00n L=60.00n
MM46 net_0133 D net_0104 VSS nm1p2_svt_lp W=430.00n L=60.00n
MM3 net_0154 c ps VSS nm1p2_svt_lp W=360.00n L=60.00n
MM49 net_0137 cn net_0132 VSS nm1p2_svt_lp W=340.00n L=60.00n
MM44 net_0104 RDN VSS VSS nm1p2_svt_lp W=400.00n L=60.00n
MM42 VSS RDN net_0119 VSS nm1p2_svt_lp W=200.00n L=60.00n
MM51 sen SE VSS VSS nm1p2_svt_lp W=200n L=60.00n
MM39 s ps net_099 VSS nm1p2_svt_lp W=300.00n L=60.00n m=2
MM40 net_099 RDN VSS VSS nm1p2_svt_lp W=300.00n L=60.00n m=2
MM30 c cn VSS VSS nm1p2_svt_lp W=430n L=60.00n
MM27 cn CK VSS VSS nm1p2_svt_lp W=300n L=60.00n
MM24 net48 cn ps VSS nm1p2_svt_lp W=200.00n L=60.00n
MM23 VSS s net48 VSS nm1p2_svt_lp W=200.00n L=60.00n
MM19 Q s VSS VSS nm1p2_svt_lp W=430.00n L=60.00n m=2
MM12 net52 c net_0132 VSS nm1p2_svt_lp W=200.00n L=60.00n
MM11 net_0119 net_0154 net52 VSS nm1p2_svt_lp W=200.00n L=60.00n
MM9 net_0137 SE net69 VSS nm1p2_svt_lp W=430.00n L=60.00n
MM7 net69 SI net_0104 VSS nm1p2_svt_lp W=430.00n L=60.00n
MM0 net_0154 net_0132 VSS VSS nm1p2_svt_lp W=350.00n L=60.00n
MM47 net_0137 SE net_0212 VDD pm1p2_svt_lp W=500n L=60.00n
MM48 net_0212 D VDD VDD pm1p2_svt_lp W=500n L=60.00n
MM43 net_0132 RDN VDD VDD pm1p2_svt_lp W=300.00n L=60.00n
MM52 sen SE VDD VDD pm1p2_svt_lp W=300.00n L=60.00n
MM38 s ps VDD VDD pm1p2_svt_lp W=450.00n L=60.00n
MM41 s RDN VDD VDD pm1p2_svt_lp W=300.00n L=60.00n
MM50 net_0137 c net_0132 VDD pm1p2_svt_lp W=530.00n L=60.00n
MM29 c cn VDD VDD pm1p2_svt_lp W=650.00n L=60.00n
MM28 cn CK VDD VDD pm1p2_svt_lp W=450.00n L=60.00n
MM26 VDD s net109 VDD pm1p2_svt_lp W=300.00n L=60.00n
MM25 net109 c ps VDD pm1p2_svt_lp W=300.00n L=60.00n
MM20 Q s VDD VDD pm1p2_svt_lp W=650.00n L=60.00n m=2
MM4 net_0154 cn ps VDD pm1p2_svt_lp W=540.00n L=60.00n
MM14 net117 cn net_0132 VDD pm1p2_svt_lp W=300.00n L=60.00n
MM13 VDD net_0154 net117 VDD pm1p2_svt_lp W=300.00n L=60.00n
MM10 net_0137 sen net128 VDD pm1p2_svt_lp W=500n L=60.00n
MM8 net128 SI VDD VDD pm1p2_svt_lp W=500n L=60.00n
MM1 net_0154 net_0132 VDD VDD pm1p2_svt_lp W=540.00n L=60.00n
.ENDS

.SUBCKT SDFFNRX1H9R CKN D Q QN RDN SE SI VDD VSS
MM53 QN ps VSS VSS nm1p2_svt_lp W=290.00n L=60.00n
MM45 net_0137 sen net_0133 VSS nm1p2_svt_lp W=300.00n L=60.00n
MM46 net_0133 D net_0104 VSS nm1p2_svt_lp W=300.00n L=60.00n
MM3 net_0154 c ps VSS nm1p2_svt_lp W=300.00n L=60.00n
MM49 net_0137 cn net_0132 VSS nm1p2_svt_lp W=300.00n L=60.00n
MM44 net_0104 RDN VSS VSS nm1p2_svt_lp W=300.00n L=60.00n
MM42 VSS RDN net_0119 VSS nm1p2_svt_lp W=200.00n L=60.00n
MM51 sen SE VSS VSS nm1p2_svt_lp W=300.00n L=60.00n
MM39 s ps net_099 VSS nm1p2_svt_lp W=360.00n L=60.00n
MM40 net_099 RDN VSS VSS nm1p2_svt_lp W=360.00n L=60.00n
MM30 cn c VSS VSS nm1p2_svt_lp W=300.00n L=60.00n
MM27 c CKN VSS VSS nm1p2_svt_lp W=300.00n L=60.00n
MM24 net48 cn ps VSS nm1p2_svt_lp W=200.00n L=60.00n
MM23 VSS s net48 VSS nm1p2_svt_lp W=200.00n L=60.00n
MM19 Q s VSS VSS nm1p2_svt_lp W=290.00n L=60.00n
MM12 net52 c net_0132 VSS nm1p2_svt_lp W=200.00n L=60.00n
MM11 net_0119 net_0154 net52 VSS nm1p2_svt_lp W=200.00n L=60.00n
MM9 net_0137 SE net69 VSS nm1p2_svt_lp W=300.00n L=60.00n
MM7 net69 SI net_0104 VSS nm1p2_svt_lp W=300.00n L=60.00n
MM0 net_0154 net_0132 VSS VSS nm1p2_svt_lp W=300.00n L=60.00n
MM54 QN ps VDD VDD pm1p2_svt_lp W=440.00n L=60.00n
MM47 net_0137 SE net_0212 VDD pm1p2_svt_lp W=500.00n L=60.00n
MM48 net_0212 D VDD VDD pm1p2_svt_lp W=500.00n L=60.00n
MM43 net_0132 RDN VDD VDD pm1p2_svt_lp W=300.00n L=60.00n
MM52 sen SE VDD VDD pm1p2_svt_lp W=450.00n L=60.00n
MM38 s ps VDD VDD pm1p2_svt_lp W=390.00n L=60.00n
MM41 s RDN VDD VDD pm1p2_svt_lp W=390.00n L=60.00n
MM50 net_0137 c net_0132 VDD pm1p2_svt_lp W=450.00n L=60.00n
MM29 cn c VDD VDD pm1p2_svt_lp W=450.00n L=60.00n
MM28 c CKN VDD VDD pm1p2_svt_lp W=450.00n L=60.00n
MM26 VDD s net109 VDD pm1p2_svt_lp W=300.00n L=60.00n
MM25 net109 c ps VDD pm1p2_svt_lp W=300.00n L=60.00n
MM20 Q s VDD VDD pm1p2_svt_lp W=440.00n L=60.00n
MM4 net_0154 cn ps VDD pm1p2_svt_lp W=450.00n L=60.00n
MM14 net117 cn net_0132 VDD pm1p2_svt_lp W=300.00n L=60.00n
MM13 VDD net_0154 net117 VDD pm1p2_svt_lp W=300.00n L=60.00n
MM10 net_0137 sen net128 VDD pm1p2_svt_lp W=450.00n L=60.00n
MM8 net128 SI VDD VDD pm1p2_svt_lp W=450.00n L=60.00n
MM1 net_0154 net_0132 VDD VDD pm1p2_svt_lp W=450.00n L=60.00n
.ENDS

.SUBCKT SDFFNRX2H9R CKN D Q QN RDN SE SI VDD VSS
MM53 QN ps VSS VSS nm1p2_svt_lp W=430.00n L=60.00n
MM45 net_0137 sen net_0133 VSS nm1p2_svt_lp W=350.00n L=60.00n
MM46 net_0133 D net_0104 VSS nm1p2_svt_lp W=350.00n L=60.00n
MM3 net_0154 c ps VSS nm1p2_svt_lp W=300.00n L=60.00n
MM49 net_0137 cn net_0132 VSS nm1p2_svt_lp W=290.00n L=60.00n
MM44 net_0104 RDN VSS VSS nm1p2_svt_lp W=300.00n L=60.00n
MM42 VSS RDN net_0119 VSS nm1p2_svt_lp W=190.00n L=60.00n
MM51 sen SE VSS VSS nm1p2_svt_lp W=300.00n L=60.00n
MM39 s ps net_099 VSS nm1p2_svt_lp W=360.00n L=60.00n
MM40 net_099 RDN VSS VSS nm1p2_svt_lp W=360.00n L=60.00n
MM30 cn c VSS VSS nm1p2_svt_lp W=300.00n L=60.00n
MM27 c CKN VSS VSS nm1p2_svt_lp W=300.00n L=60.00n
MM24 net48 cn ps VSS nm1p2_svt_lp W=200.00n L=60.00n
MM23 VSS s net48 VSS nm1p2_svt_lp W=200.00n L=60.00n
MM19 Q s VSS VSS nm1p2_svt_lp W=430.00n L=60.00n
MM12 net52 c net_0132 VSS nm1p2_svt_lp W=190.00n L=60.00n
MM11 net_0119 net_0154 net52 VSS nm1p2_svt_lp W=190.00n L=60.00n
MM9 net_0137 SE net69 VSS nm1p2_svt_lp W=300.00n L=60.00n
MM7 net69 SI net_0104 VSS nm1p2_svt_lp W=300.00n L=60.00n
MM0 net_0154 net_0132 VSS VSS nm1p2_svt_lp W=300.00n L=60.00n
MM54 QN ps VDD VDD pm1p2_svt_lp W=650.00n L=60.00n
MM47 net_0137 SE net_0212 VDD pm1p2_svt_lp W=450.00n L=60.00n
MM48 net_0212 D VDD VDD pm1p2_svt_lp W=450.00n L=60.00n
MM43 net_0132 RDN VDD VDD pm1p2_svt_lp W=300.00n L=60.00n
MM52 sen SE VDD VDD pm1p2_svt_lp W=450.00n L=60.00n
MM38 s ps VDD VDD pm1p2_svt_lp W=390.00n L=60.00n
MM41 s RDN VDD VDD pm1p2_svt_lp W=390.00n L=60.00n
MM50 net_0137 c net_0132 VDD pm1p2_svt_lp W=445.00n L=60.00n
MM29 cn c VDD VDD pm1p2_svt_lp W=450.00n L=60.00n
MM28 c CKN VDD VDD pm1p2_svt_lp W=450.00n L=60.00n
MM26 VDD s net109 VDD pm1p2_svt_lp W=300.00n L=60.00n
MM25 net109 c ps VDD pm1p2_svt_lp W=300.00n L=60.00n
MM20 Q s VDD VDD pm1p2_svt_lp W=650.00n L=60.00n
MM4 net_0154 cn ps VDD pm1p2_svt_lp W=450.00n L=60.00n
MM14 net117 cn net_0132 VDD pm1p2_svt_lp W=300.00n L=60.00n
MM13 VDD net_0154 net117 VDD pm1p2_svt_lp W=300.00n L=60.00n
MM10 net_0137 sen net128 VDD pm1p2_svt_lp W=450.00n L=60.00n
MM8 net128 SI VDD VDD pm1p2_svt_lp W=450.00n L=60.00n
MM1 net_0154 net_0132 VDD VDD pm1p2_svt_lp W=450.00n L=60.00n
.ENDS

.SUBCKT SDFFNRX4H9R CKN D Q QN RDN SE SI VDD VSS
MM53 QN ps VSS VSS nm1p2_svt_lp W=860.00n L=60.00n
MM45 net_0137 sen net_0133 VSS nm1p2_svt_lp W=350.00n L=60.00n
MM46 net_0133 D net_0104 VSS nm1p2_svt_lp W=350.00n L=60.00n
MM3 net_0154 c ps VSS nm1p2_svt_lp W=300.00n L=60.00n
MM49 net_0137 cn net_0132 VSS nm1p2_svt_lp W=300.00n L=60.00n
MM44 net_0104 RDN VSS VSS nm1p2_svt_lp W=300.00n L=60.00n
MM42 VSS RDN net_0119 VSS nm1p2_svt_lp W=200.00n L=60.00n
MM51 sen SE VSS VSS nm1p2_svt_lp W=300.00n L=60.00n
MM39 s ps net_099 VSS nm1p2_svt_lp W=380.00n L=60.00n
MM40 net_099 RDN VSS VSS nm1p2_svt_lp W=380.00n L=60.00n
MM30 cn c VSS VSS nm1p2_svt_lp W=360.00n L=60.00n
MM27 c CKN VSS VSS nm1p2_svt_lp W=300.00n L=60.00n
MM24 net48 cn ps VSS nm1p2_svt_lp W=200.00n L=60.00n
MM23 VSS s net48 VSS nm1p2_svt_lp W=200.00n L=60.00n
MM19 Q s VSS VSS nm1p2_svt_lp W=860.00n L=60.00n
MM12 net52 c net_0132 VSS nm1p2_svt_lp W=200.00n L=60.00n
MM11 net_0119 net_0154 net52 VSS nm1p2_svt_lp W=200.00n L=60.00n
MM9 net_0137 SE net69 VSS nm1p2_svt_lp W=300.00n L=60.00n
MM7 net69 SI net_0104 VSS nm1p2_svt_lp W=300.00n L=60.00n
MM0 net_0154 net_0132 VSS VSS nm1p2_svt_lp W=300.00n L=60.00n
MM54 QN ps VDD VDD pm1p2_svt_lp W=1.3u L=60.00n
MM47 net_0137 SE net_0212 VDD pm1p2_svt_lp W=500.00n L=60.00n
MM48 net_0212 D VDD VDD pm1p2_svt_lp W=500.00n L=60.00n
MM43 net_0132 RDN VDD VDD pm1p2_svt_lp W=300.00n L=60.00n
MM52 sen SE VDD VDD pm1p2_svt_lp W=450.00n L=60.00n
MM38 s ps VDD VDD pm1p2_svt_lp W=350.00n L=60.00n
MM41 s RDN VDD VDD pm1p2_svt_lp W=300.00n L=60.00n
MM50 net_0137 c net_0132 VDD pm1p2_svt_lp W=450.00n L=60.00n
MM29 cn c VDD VDD pm1p2_svt_lp W=530.00n L=60.00n
MM28 c CKN VDD VDD pm1p2_svt_lp W=450.00n L=60.00n
MM26 VDD s net109 VDD pm1p2_svt_lp W=300.00n L=60.00n
MM25 net109 c ps VDD pm1p2_svt_lp W=300.00n L=60.00n
MM20 Q s VDD VDD pm1p2_svt_lp W=1.3u L=60.00n
MM4 net_0154 cn ps VDD pm1p2_svt_lp W=450.00n L=60.00n
MM14 net117 cn net_0132 VDD pm1p2_svt_lp W=300.00n L=60.00n
MM13 VDD net_0154 net117 VDD pm1p2_svt_lp W=300.00n L=60.00n
MM10 net_0137 sen net128 VDD pm1p2_svt_lp W=450.00n L=60.00n
MM8 net128 SI VDD VDD pm1p2_svt_lp W=450.00n L=60.00n
MM1 net_0154 net_0132 VDD VDD pm1p2_svt_lp W=450.00n L=60.00n
.ENDS

.SUBCKT SDFFTRX1H9R CK D Q QN RN SE SI VDD VSS
MM41 net_0127 SE net_0123 VSS nm1p2_svt_lp W=300.00n L=60.00n
MM43 net_0123 SI VSS VSS nm1p2_svt_lp W=300.00n L=60.00n
MM46 SEN SE VSS VSS nm1p2_svt_lp W=300.00n L=60.00n
MM52 QN ps VSS VSS nm1p2_svt_lp W=290.00n L=60.00n
MM3 m c ps VSS nm1p2_svt_lp W=350.00n L=60.00n
MM30 c cn VSS VSS nm1p2_svt_lp W=300.00n L=60.00n
MM27 cn CK VSS VSS nm1p2_svt_lp W=300.00n L=60.00n
MM38 net_0162 RN VSS VSS nm1p2_svt_lp W=410.00n L=60.00n
MM24 net48 cn ps VSS nm1p2_svt_lp W=200.00n L=60.00n
MM23 VSS s net48 VSS nm1p2_svt_lp W=200.00n L=60.00n
MM19 Q s VSS VSS nm1p2_svt_lp W=290.00n L=60.00n
MM17 s ps VSS VSS nm1p2_svt_lp W=260.00n L=60.00n
MM12 net52 c pm VSS nm1p2_svt_lp W=200.00n L=60.00n
MM11 VSS m net52 VSS nm1p2_svt_lp W=200.00n L=60.00n
MM48 net_0127 cn pm VSS nm1p2_svt_lp W=270.00n L=60.00n
MM40 net_0127 SEN net69 VSS nm1p2_svt_lp W=410.00n L=60.00n
MM7 net69 D net_0162 VSS nm1p2_svt_lp W=410.00n L=60.00n
MM0 m pm VSS VSS nm1p2_svt_lp W=350.00n L=60.00n
MM44 net_0202 SI VDD VDD pm1p2_svt_lp W=450.00n L=60.00n
MM45 net_0127 SEN net_0202 VDD pm1p2_svt_lp W=450.00n L=60.00n
MM47 SEN SE VDD VDD pm1p2_svt_lp W=450.00n L=60.00n
MM53 QN ps VDD VDD pm1p2_svt_lp W=440.00n L=60.00n
MM50 net_0178 SE VDD VDD pm1p2_svt_lp W=300.0n L=60.00n
MM51 net_0127 RN net_0178 VDD pm1p2_svt_lp W=300.0n L=60.00n
MM4 m cn ps VDD pm1p2_svt_lp W=530.00n L=60.00n
MM29 c cn VDD VDD pm1p2_svt_lp W=450.00n L=60.00n
MM28 cn CK VDD VDD pm1p2_svt_lp W=450.00n L=60.00n
MM37 net128 D VDD VDD pm1p2_svt_lp W=530.00n L=60.00n
MM26 VDD s net109 VDD pm1p2_svt_lp W=300.00n L=60.00n
MM25 net109 c ps VDD pm1p2_svt_lp W=300.00n L=60.00n
MM20 Q s VDD VDD pm1p2_svt_lp W=440.00n L=60.00n
MM18 s ps VDD VDD pm1p2_svt_lp W=390.00n L=60.00n
MM14 net117 cn pm VDD pm1p2_svt_lp W=300.00n L=60.00n
MM13 VDD m net117 VDD pm1p2_svt_lp W=300.00n L=60.00n
MM49 net_0127 c pm VDD pm1p2_svt_lp W=410.00n L=60.00n
MM39 net_0127 SE net128 VDD pm1p2_svt_lp W=530.00n L=60.00n
MM1 m pm VDD VDD pm1p2_svt_lp W=530.00n L=60.00n
.ENDS

.SUBCKT SDFFTRX2H9R CK D Q QN RN SE SI VDD VSS
MM41 net_0127 SE net_0123 VSS nm1p2_svt_lp W=300.00n L=60.00n
MM43 net_0123 SI VSS VSS nm1p2_svt_lp W=300.00n L=60.00n
MM46 SEN SE VSS VSS nm1p2_svt_lp W=300.00n L=60.00n
MM52 QN ps VSS VSS nm1p2_svt_lp W=430.00n L=60.00n
MM3 m c ps VSS nm1p2_svt_lp W=360.00n L=60.00n
MM30 c cn VSS VSS nm1p2_svt_lp W=340.00n L=60.00n
MM27 cn CK VSS VSS nm1p2_svt_lp W=340.00n L=60.00n
MM38 net_0162 RN VSS VSS nm1p2_svt_lp W=410.00n L=60.00n
MM24 net48 cn ps VSS nm1p2_svt_lp W=200.00n L=60.00n
MM23 VSS s net48 VSS nm1p2_svt_lp W=200.00n L=60.00n
MM19 Q s VSS VSS nm1p2_svt_lp W=430.00n L=60.00n
MM17 s ps VSS VSS nm1p2_svt_lp W=340.00n L=60.00n
MM12 net52 c pm VSS nm1p2_svt_lp W=200.00n L=60.00n
MM11 VSS m net52 VSS nm1p2_svt_lp W=200.00n L=60.00n
MM48 net_0127 cn pm VSS nm1p2_svt_lp W=270.00n L=60.00n
MM40 net_0127 SEN net69 VSS nm1p2_svt_lp W=410.00n L=60.00n
MM7 net69 D net_0162 VSS nm1p2_svt_lp W=410.00n L=60.00n
MM0 m pm VSS VSS nm1p2_svt_lp W=360.00n L=60.00n
MM44 net_0202 SI VDD VDD pm1p2_svt_lp W=450.00n L=60.00n
MM45 net_0127 SEN net_0202 VDD pm1p2_svt_lp W=450.00n L=60.00n
MM47 SEN SE VDD VDD pm1p2_svt_lp W=450.00n L=60.00n
MM53 QN ps VDD VDD pm1p2_svt_lp W=650.00n L=60.00n
MM50 net_0178 SE VDD VDD pm1p2_svt_lp W=300.0n L=60.00n
MM51 net_0127 RN net_0178 VDD pm1p2_svt_lp W=300.0n L=60.00n
MM4 m cn ps VDD pm1p2_svt_lp W=540.00n L=60.00n
MM29 c cn VDD VDD pm1p2_svt_lp W=500.00n L=60.00n
MM28 cn CK VDD VDD pm1p2_svt_lp W=500.00n L=60.00n
MM37 net128 D VDD VDD pm1p2_svt_lp W=530.00n L=60.00n
MM26 VDD s net109 VDD pm1p2_svt_lp W=300.00n L=60.00n
MM25 net109 c ps VDD pm1p2_svt_lp W=300.00n L=60.00n
MM20 Q s VDD VDD pm1p2_svt_lp W=650.00n L=60.00n
MM18 s ps VDD VDD pm1p2_svt_lp W=500.00n L=60.00n
MM14 net117 cn pm VDD pm1p2_svt_lp W=300.00n L=60.00n
MM13 VDD m net117 VDD pm1p2_svt_lp W=300.00n L=60.00n
MM49 net_0127 c pm VDD pm1p2_svt_lp W=410.00n L=60.00n
MM39 net_0127 SE net128 VDD pm1p2_svt_lp W=530.00n L=60.00n
MM1 m pm VDD VDD pm1p2_svt_lp W=540.00n L=60.00n
.ENDS

.SUBCKT SDFFTRX4H9R CK D Q QN RN SE SI VDD VSS
MM41 net_0127 SE net_0123 VSS nm1p2_svt_lp W=300.00n L=60.00n
MM43 net_0123 SI VSS VSS nm1p2_svt_lp W=300.00n L=60.00n
MM46 SEN SE VSS VSS nm1p2_svt_lp W=300.00n L=60.00n
MM52 QN ps VSS VSS nm1p2_svt_lp W=860.00n L=60.00n
MM3 m c ps VSS nm1p2_svt_lp W=390.00n L=60.00n
MM30 c cn VSS VSS nm1p2_svt_lp W=290.00n L=60.00n
MM27 cn CK VSS VSS nm1p2_svt_lp W=360.00n L=60.00n
MM38 net_0162 RN VSS VSS nm1p2_svt_lp W=410.00n L=60.00n
MM24 net48 cn ps VSS nm1p2_svt_lp W=200.00n L=60.00n
MM23 VSS s net48 VSS nm1p2_svt_lp W=200.00n L=60.00n
MM19 Q s VSS VSS nm1p2_svt_lp W=860.00n L=60.00n
MM17 s ps VSS VSS nm1p2_svt_lp W=360.00n L=60.00n
MM12 net52 c pm VSS nm1p2_svt_lp W=300.00n L=60.00n
MM11 VSS m net52 VSS nm1p2_svt_lp W=300.00n L=60.00n
MM48 net_0127 cn pm VSS nm1p2_svt_lp W=270.00n L=60.00n
MM40 net_0127 SEN net69 VSS nm1p2_svt_lp W=410.00n L=60.00n
MM7 net69 D net_0162 VSS nm1p2_svt_lp W=410.00n L=60.00n
MM0 m pm VSS VSS nm1p2_svt_lp W=390.00n L=60.00n
MM44 net_0202 SI VDD VDD pm1p2_svt_lp W=450.00n L=60.00n
MM45 net_0127 SEN net_0202 VDD pm1p2_svt_lp W=450.00n L=60.00n
MM47 SEN SE VDD VDD pm1p2_svt_lp W=450.00n L=60.00n
MM53 QN ps VDD VDD pm1p2_svt_lp W=1.3u L=60.00n
MM50 net_0178 SE VDD VDD pm1p2_svt_lp W=300.0n L=60.00n
MM51 net_0127 RN net_0178 VDD pm1p2_svt_lp W=300.0n L=60.00n
MM4 m cn ps VDD pm1p2_svt_lp W=540.00n L=60.00n
MM29 c cn VDD VDD pm1p2_svt_lp W=440.00n L=60.00n
MM28 cn CK VDD VDD pm1p2_svt_lp W=540.00n L=60.00n
MM37 net128 D VDD VDD pm1p2_svt_lp W=530.00n L=60.00n
MM26 VDD s net109 VDD pm1p2_svt_lp W=300.00n L=60.00n
MM25 net109 c ps VDD pm1p2_svt_lp W=300.00n L=60.00n
MM20 Q s VDD VDD pm1p2_svt_lp W=1.3u L=60.00n
MM18 s ps VDD VDD pm1p2_svt_lp W=540.00n L=60.00n
MM14 net117 cn pm VDD pm1p2_svt_lp W=450.00n L=60.00n
MM13 VDD m net117 VDD pm1p2_svt_lp W=450.00n L=60.00n
MM49 net_0127 c pm VDD pm1p2_svt_lp W=410.00n L=60.00n
MM39 net_0127 SE net128 VDD pm1p2_svt_lp W=530.00n L=60.00n
MM1 m pm VDD VDD pm1p2_svt_lp W=540.00n L=60.00n
.ENDS

.SUBCKT SDFFTRQX1H9R CK D Q RN SE SI VDD VSS
MM41 net_0127 SE net_0123 VSS nm1p2_svt_lp W=300.00n L=60.00n
MM43 net_0123 SI VSS VSS nm1p2_svt_lp W=300.00n L=60.00n
MM46 SEN SE VSS VSS nm1p2_svt_lp W=300.00n L=60.00n
MM3 m c ps VSS nm1p2_svt_lp W=350.00n L=60.00n
MM30 c cn VSS VSS nm1p2_svt_lp W=350.00n L=60.00n
MM27 cn CK VSS VSS nm1p2_svt_lp W=300.00n L=60.00n
MM38 net_0162 RN VSS VSS nm1p2_svt_lp W=380.00n L=60.00n
MM24 net48 cn ps VSS nm1p2_svt_lp W=200.00n L=60.00n
MM23 VSS s net48 VSS nm1p2_svt_lp W=200.00n L=60.00n
MM19 Q s VSS VSS nm1p2_svt_lp W=290.00n L=60.00n
MM17 s ps VSS VSS nm1p2_svt_lp W=260.00n L=60.00n
MM12 net52 c pm VSS nm1p2_svt_lp W=300.00n L=60.00n
MM11 VSS m net52 VSS nm1p2_svt_lp W=300.00n L=60.00n
MM48 net_0127 cn pm VSS nm1p2_svt_lp W=250.00n L=60.00n
MM40 net_0127 SEN net69 VSS nm1p2_svt_lp W=380.00n L=60.00n
MM7 net69 D net_0162 VSS nm1p2_svt_lp W=380.00n L=60.00n
MM0 m pm VSS VSS nm1p2_svt_lp W=350.00n L=60.00n
MM44 net_0202 SI VDD VDD pm1p2_svt_lp W=450.00n L=60.00n
MM45 net_0127 SEN net_0202 VDD pm1p2_svt_lp W=450.00n L=60.00n
MM47 SEN SE VDD VDD pm1p2_svt_lp W=450.00n L=60.00n
MM50 net_0178 SE VDD VDD pm1p2_svt_lp W=300.0n L=60.00n
MM51 net_0127 RN net_0178 VDD pm1p2_svt_lp W=300.0n L=60.00n
MM4 m cn ps VDD pm1p2_svt_lp W=530.00n L=60.00n
MM29 c cn VDD VDD pm1p2_svt_lp W=530.00n L=60.00n
MM28 cn CK VDD VDD pm1p2_svt_lp W=450.00n L=60.00n
MM37 net128 D VDD VDD pm1p2_svt_lp W=500.00n L=60.00n
MM26 VDD s net109 VDD pm1p2_svt_lp W=300.00n L=60.00n
MM25 net109 c ps VDD pm1p2_svt_lp W=300.00n L=60.00n
MM20 Q s VDD VDD pm1p2_svt_lp W=440.00n L=60.00n
MM18 s ps VDD VDD pm1p2_svt_lp W=390.00n L=60.00n
MM14 net117 cn pm VDD pm1p2_svt_lp W=450.00n L=60.00n
MM13 VDD m net117 VDD pm1p2_svt_lp W=450.00n L=60.00n
MM49 net_0127 c pm VDD pm1p2_svt_lp W=380.00n L=60.00n
MM39 net_0127 SE net128 VDD pm1p2_svt_lp W=500.00n L=60.00n
MM1 m pm VDD VDD pm1p2_svt_lp W=530.00n L=60.00n
.ENDS

.SUBCKT SDFFTRQX2H9R CK D Q RN SE SI VDD VSS
MM41 net_0127 SE net_0123 VSS nm1p2_svt_lp W=300.00n L=60.00n
MM43 net_0123 SI VSS VSS nm1p2_svt_lp W=300.00n L=60.00n
MM46 SEN SE VSS VSS nm1p2_svt_lp W=300.00n L=60.00n
MM3 m c ps VSS nm1p2_svt_lp W=360.00n L=60.00n
MM30 c cn VSS VSS nm1p2_svt_lp W=330.00n L=60.00n
MM27 cn CK VSS VSS nm1p2_svt_lp W=330.00n L=60.00n
MM38 net_0162 RN VSS VSS nm1p2_svt_lp W=380.00n L=60.00n
MM24 net48 cn ps VSS nm1p2_svt_lp W=200.00n L=60.00n
MM23 VSS s net48 VSS nm1p2_svt_lp W=200.00n L=60.00n
MM19 Q s VSS VSS nm1p2_svt_lp W=430.00n L=60.00n
MM17 s ps VSS VSS nm1p2_svt_lp W=340.00n L=60.00n
MM12 net52 c pm VSS nm1p2_svt_lp W=300.00n L=60.00n
MM11 VSS m net52 VSS nm1p2_svt_lp W=300.00n L=60.00n
MM48 net_0127 cn pm VSS nm1p2_svt_lp W=250.00n L=60.00n
MM40 net_0127 SEN net69 VSS nm1p2_svt_lp W=380.00n L=60.00n
MM7 net69 D net_0162 VSS nm1p2_svt_lp W=380.00n L=60.00n
MM0 m pm VSS VSS nm1p2_svt_lp W=360.00n L=60.00n
MM44 net_0202 SI VDD VDD pm1p2_svt_lp W=450.00n L=60.00n
MM45 net_0127 SEN net_0202 VDD pm1p2_svt_lp W=450.00n L=60.00n
MM47 SEN SE VDD VDD pm1p2_svt_lp W=450.00n L=60.00n
MM50 net_0178 SE VDD VDD pm1p2_svt_lp W=300.0n L=60.00n
MM51 net_0127 RN net_0178 VDD pm1p2_svt_lp W=300.0n L=60.00n
MM4 m cn ps VDD pm1p2_svt_lp W=540.00n L=60.00n
MM29 c cn VDD VDD pm1p2_svt_lp W=500.00n L=60.00n
MM28 cn CK VDD VDD pm1p2_svt_lp W=500.00n L=60.00n
MM37 net128 D VDD VDD pm1p2_svt_lp W=500.00n L=60.00n
MM26 VDD s net109 VDD pm1p2_svt_lp W=300.00n L=60.00n
MM25 net109 c ps VDD pm1p2_svt_lp W=300.00n L=60.00n
MM20 Q s VDD VDD pm1p2_svt_lp W=650.00n L=60.00n
MM18 s ps VDD VDD pm1p2_svt_lp W=500.00n L=60.00n
MM14 net117 cn pm VDD pm1p2_svt_lp W=450.00n L=60.00n
MM13 VDD m net117 VDD pm1p2_svt_lp W=450.00n L=60.00n
MM49 net_0127 c pm VDD pm1p2_svt_lp W=380.00n L=60.00n
MM39 net_0127 SE net128 VDD pm1p2_svt_lp W=500.00n L=60.00n
MM1 m pm VDD VDD pm1p2_svt_lp W=540.00n L=60.00n
.ENDS

.SUBCKT SDFFTRQX4H9R CK D Q RN SE SI VDD VSS
MM41 net_0127 SE net_0123 VSS nm1p2_svt_lp W=300.00n L=60.00n
MM43 net_0123 SI VSS VSS nm1p2_svt_lp W=300.00n L=60.00n
MM46 SEN SE VSS VSS nm1p2_svt_lp W=300.00n L=60.00n
MM3 m c ps VSS nm1p2_svt_lp W=370.00n L=60.00n
MM30 c cn VSS VSS nm1p2_svt_lp W=290.00n L=60.00n
MM27 cn CK VSS VSS nm1p2_svt_lp W=360.00n L=60.00n
MM38 net_0162 RN VSS VSS nm1p2_svt_lp W=380.00n L=60.00n
MM24 net48 cn ps VSS nm1p2_svt_lp W=200.00n L=60.00n
MM23 VSS s net48 VSS nm1p2_svt_lp W=200.00n L=60.00n
MM19 Q s VSS VSS nm1p2_svt_lp W=860.00n L=60.00n
MM17 s ps VSS VSS nm1p2_svt_lp W=360.00n L=60.00n
MM12 net52 c pm VSS nm1p2_svt_lp W=300.00n L=60.00n
MM11 VSS m net52 VSS nm1p2_svt_lp W=300.00n L=60.00n
MM48 net_0127 cn pm VSS nm1p2_svt_lp W=250.00n L=60.00n
MM40 net_0127 SEN net69 VSS nm1p2_svt_lp W=380.00n L=60.00n
MM7 net69 D net_0162 VSS nm1p2_svt_lp W=380.00n L=60.00n
MM0 m pm VSS VSS nm1p2_svt_lp W=390.00n L=60.00n
MM44 net_0202 SI VDD VDD pm1p2_svt_lp W=450.00n L=60.00n
MM45 net_0127 SEN net_0202 VDD pm1p2_svt_lp W=450.00n L=60.00n
MM47 SEN SE VDD VDD pm1p2_svt_lp W=450.00n L=60.00n
MM50 net_0178 SE VDD VDD pm1p2_svt_lp W=300.0n L=60.00n
MM51 net_0127 RN net_0178 VDD pm1p2_svt_lp W=300.0n L=60.00n
MM4 m cn ps VDD pm1p2_svt_lp W=540.00n L=60.00n
MM29 c cn VDD VDD pm1p2_svt_lp W=440.00n L=60.00n
MM28 cn CK VDD VDD pm1p2_svt_lp W=540.00n L=60.00n
MM37 net128 D VDD VDD pm1p2_svt_lp W=500.00n L=60.00n
MM26 VDD s net109 VDD pm1p2_svt_lp W=300.00n L=60.00n
MM25 net109 c ps VDD pm1p2_svt_lp W=300.00n L=60.00n
MM20 Q s VDD VDD pm1p2_svt_lp W=1.3u L=60.00n
MM18 s ps VDD VDD pm1p2_svt_lp W=540.00n L=60.00n
MM14 net117 cn pm VDD pm1p2_svt_lp W=450.00n L=60.00n
MM13 VDD m net117 VDD pm1p2_svt_lp W=450.00n L=60.00n
MM49 net_0127 c pm VDD pm1p2_svt_lp W=360.00n L=60.00n
MM39 net_0127 SE net128 VDD pm1p2_svt_lp W=500.00n L=60.00n
MM1 m pm VDD VDD pm1p2_svt_lp W=580.00n L=60.00n
.ENDS

.SUBCKT SDFFSX1H9R CK D Q QN SDN SE SI VDD VSS
MM51 N11 sen net_0129 VSS nm1p2_svt_lp W=300.00n L=60.00n
MM52 net_0129 D VSS VSS nm1p2_svt_lp W=300.00n L=60.00n
MM54 N11 SE net_0121 VSS nm1p2_svt_lp W=200.00n L=60.00n
MM55 net_0121 SI VSS VSS nm1p2_svt_lp W=200.00n L=60.00n
MM3 net_0154 c net43 VSS nm1p2_svt_lp W=290.00n L=60.00n
MM48 net_0132 SDN VSS VSS nm1p2_svt_lp W=400.00n L=60.00n
MM49 QN net43 VSS VSS nm1p2_svt_lp W=290.00n L=60.00n
MM39 s net43 VSS VSS nm1p2_svt_lp W=200.00n L=60.00n
MM56 sen SE VSS VSS nm1p2_svt_lp W=200.00n L=60.00n
MM30 c cn VSS VSS nm1p2_svt_lp W=200.00n L=60.00n
MM27 cn CK VSS VSS nm1p2_svt_lp W=200.00n L=60.00n
MM24 net48 cn net43 VSS nm1p2_svt_lp W=200.00n L=60.00n
MM23 net_0132 s net48 VSS nm1p2_svt_lp W=200.00n L=60.00n
MM19 Q s VSS VSS nm1p2_svt_lp W=290.00n L=60.00n
MM12 net52 c net_0181 VSS nm1p2_svt_lp W=200.00n L=60.00n
MM11 VSS net_0154 net52 VSS nm1p2_svt_lp W=200.00n L=60.00n
MM9 net_0181 cn N11 VSS nm1p2_svt_lp W=300.00n L=60.00n
MM0 net_0154 net_0181 net_0132 VSS nm1p2_svt_lp W=400.00n L=60.00n
MM57 N7 sen net_0204 VDD pm1p2_svt_lp W=300.00n L=60.00n
MM59 N7 SE net_0200 VDD pm1p2_svt_lp W=450.00n L=60.00n
MM60 net_0200 D VDD VDD pm1p2_svt_lp W=450.00n L=60.00n
MM61 net_0204 SI VDD VDD pm1p2_svt_lp W=300.00n L=60.00n
MM43 net_0154 SDN VDD VDD pm1p2_svt_lp W=300.00n L=60.00n
MM62 sen SE VDD VDD pm1p2_svt_lp W=300.00n L=60.00n
MM50 QN net43 VDD VDD pm1p2_svt_lp W=440.00n L=60.00n
MM38 s net43 VDD VDD pm1p2_svt_lp W=400.00n L=60.00n
MM41 net43 SDN VDD VDD pm1p2_svt_lp W=300.00n L=60.00n
MM29 c cn VDD VDD pm1p2_svt_lp W=300.00n L=60.00n
MM28 cn CK VDD VDD pm1p2_svt_lp W=300.00n L=60.00n
MM26 VDD s net109 VDD pm1p2_svt_lp W=300.00n L=60.00n
MM25 net109 c net43 VDD pm1p2_svt_lp W=300.00n L=60.00n
MM20 Q s VDD VDD pm1p2_svt_lp W=440.00n L=60.00n
MM4 net_0154 cn net43 VDD pm1p2_svt_lp W=440.00n L=60.00n
MM14 net117 cn net_0181 VDD pm1p2_svt_lp W=300.00n L=60.00n
MM13 VDD net_0154 net117 VDD pm1p2_svt_lp W=300.00n L=60.00n
MM10 net_0181 c N7 VDD pm1p2_svt_lp W=450.00n L=60.00n
MM1 net_0154 net_0181 VDD VDD pm1p2_svt_lp W=400.00n L=60.00n
.ENDS

.SUBCKT SDFFSX2H9R CK D Q QN SDN SE SI VDD VSS
MM51 N11 sen net_0129 VSS nm1p2_svt_lp W=300.00n L=60.00n
MM52 net_0129 D VSS VSS nm1p2_svt_lp W=300.00n L=60.00n
MM54 N11 SE net_0121 VSS nm1p2_svt_lp W=200.00n L=60.00n
MM55 net_0121 SI VSS VSS nm1p2_svt_lp W=200.00n L=60.00n
MM3 net_0154 c net43 VSS nm1p2_svt_lp W=420.00n L=60.00n
MM48 net_0132 SDN VSS VSS nm1p2_svt_lp W=430.00n L=60.00n
MM49 QN net43 VSS VSS nm1p2_svt_lp W=430.00n L=60.00n
MM39 s net43 VSS VSS nm1p2_svt_lp W=290.00n L=60.00n
MM56 sen SE VSS VSS nm1p2_svt_lp W=200.00n L=60.00n
MM30 c cn VSS VSS nm1p2_svt_lp W=200.00n L=60.00n
MM27 cn CK VSS VSS nm1p2_svt_lp W=200.00n L=60.00n
MM24 net48 cn net43 VSS nm1p2_svt_lp W=200.00n L=60.00n
MM23 net_0132 s net48 VSS nm1p2_svt_lp W=200.00n L=60.00n
MM19 Q s VSS VSS nm1p2_svt_lp W=430.00n L=60.00n
MM12 net52 c net_0181 VSS nm1p2_svt_lp W=200.00n L=60.00n
MM11 VSS net_0154 net52 VSS nm1p2_svt_lp W=200.00n L=60.00n
MM9 net_0181 cn N11 VSS nm1p2_svt_lp W=300.00n L=60.00n
MM0 net_0154 net_0181 net_0132 VSS nm1p2_svt_lp W=420.00n L=60.00n
MM57 N7 sen net_0204 VDD pm1p2_svt_lp W=300.00n L=60.00n
MM59 N7 SE net_0200 VDD pm1p2_svt_lp W=450.00n L=60.00n
MM60 net_0200 D VDD VDD pm1p2_svt_lp W=450.00n L=60.00n
MM61 net_0204 SI VDD VDD pm1p2_svt_lp W=300.00n L=60.00n
MM43 net_0154 SDN VDD VDD pm1p2_svt_lp W=300.00n L=60.00n
MM62 sen SE VDD VDD pm1p2_svt_lp W=300.00n L=60.00n
MM50 QN net43 VDD VDD pm1p2_svt_lp W=650.00n L=60.00n
MM38 s net43 VDD VDD pm1p2_svt_lp W=500.00n L=60.00n
MM41 net43 SDN VDD VDD pm1p2_svt_lp W=300.00n L=60.00n
MM29 c cn VDD VDD pm1p2_svt_lp W=300.00n L=60.00n
MM28 cn CK VDD VDD pm1p2_svt_lp W=300.00n L=60.00n
MM26 VDD s net109 VDD pm1p2_svt_lp W=300.00n L=60.00n
MM25 net109 c net43 VDD pm1p2_svt_lp W=300.00n L=60.00n
MM20 Q s VDD VDD pm1p2_svt_lp W=650.00n L=60.00n
MM4 net_0154 cn net43 VDD pm1p2_svt_lp W=650.00n L=60.00n
MM14 net117 cn net_0181 VDD pm1p2_svt_lp W=300.00n L=60.00n
MM13 VDD net_0154 net117 VDD pm1p2_svt_lp W=300.00n L=60.00n
MM10 net_0181 c N7 VDD pm1p2_svt_lp W=450.00n L=60.00n
MM1 net_0154 net_0181 VDD VDD pm1p2_svt_lp W=390.00n L=60.00n
.ENDS

.SUBCKT SDFFSX4H9R CK D Q QN SDN SE SI VDD VSS
MM51 N11 sen net_0129 VSS nm1p2_svt_lp W=300.00n L=60.00n
MM52 net_0129 D VSS VSS nm1p2_svt_lp W=300.00n L=60.00n
MM54 N11 SE net_0121 VSS nm1p2_svt_lp W=200.00n L=60.00n
MM55 net_0121 SI VSS VSS nm1p2_svt_lp W=200.00n L=60.00n
MM3 net_0154 c net43 VSS nm1p2_svt_lp W=430.00n L=60.00n
MM48 net_0132 SDN VSS VSS nm1p2_svt_lp W=430.00n L=60.00n
MM49 QN net43 VSS VSS nm1p2_svt_lp W=860.00n L=60.00n
MM39 s net43 VSS VSS nm1p2_svt_lp W=350.00n L=60.00n
MM56 sen SE VSS VSS nm1p2_svt_lp W=200.00n L=60.00n
MM30 c cn VSS VSS nm1p2_svt_lp W=200.00n L=60.00n
MM27 cn CK VSS VSS nm1p2_svt_lp W=200.00n L=60.00n
MM24 net48 cn net43 VSS nm1p2_svt_lp W=200.00n L=60.00n
MM23 net_0132 s net48 VSS nm1p2_svt_lp W=200.00n L=60.00n
MM19 Q s VSS VSS nm1p2_svt_lp W=860.00n L=60.00n
MM12 net52 c net_0181 VSS nm1p2_svt_lp W=200.00n L=60.00n
MM11 VSS net_0154 net52 VSS nm1p2_svt_lp W=200.00n L=60.00n
MM9 net_0181 cn N11 VSS nm1p2_svt_lp W=300.00n L=60.00n
MM0 net_0154 net_0181 net_0132 VSS nm1p2_svt_lp W=360.00n L=60.00n
MM57 N7 sen net_0204 VDD pm1p2_svt_lp W=300.00n L=60.00n
MM59 N7 SE net_0200 VDD pm1p2_svt_lp W=450.00n L=60.00n
MM60 net_0200 D VDD VDD pm1p2_svt_lp W=450.00n L=60.00n
MM61 net_0204 SI VDD VDD pm1p2_svt_lp W=300.00n L=60.00n
MM43 net_0154 SDN VDD VDD pm1p2_svt_lp W=300.00n L=60.00n
MM62 sen SE VDD VDD pm1p2_svt_lp W=300.00n L=60.00n
MM50 QN net43 VDD VDD pm1p2_svt_lp W=1.3u L=60.00n
MM38 s net43 VDD VDD pm1p2_svt_lp W=650.00n L=60.00n
MM41 net43 SDN VDD VDD pm1p2_svt_lp W=300.00n L=60.00n
MM29 c cn VDD VDD pm1p2_svt_lp W=300.00n L=60.00n
MM28 cn CK VDD VDD pm1p2_svt_lp W=300.00n L=60.00n
MM26 VDD s net109 VDD pm1p2_svt_lp W=300.00n L=60.00n
MM25 net109 c net43 VDD pm1p2_svt_lp W=300.00n L=60.00n
MM20 Q s VDD VDD pm1p2_svt_lp W=1.3u L=60.00n
MM4 net_0154 cn net43 VDD pm1p2_svt_lp W=625.00n L=60.00n
MM14 net117 cn net_0181 VDD pm1p2_svt_lp W=300.00n L=60.00n
MM13 VDD net_0154 net117 VDD pm1p2_svt_lp W=300.00n L=60.00n
MM10 net_0181 c N7 VDD pm1p2_svt_lp W=450.00n L=60.00n
MM1 net_0154 net_0181 VDD VDD pm1p2_svt_lp W=480.00n L=60.00n
.ENDS

.SUBCKT SDFFNSX1H9R CKN D Q QN SDN SE SI VDD VSS
MM51 N11 sen net_0129 VSS nm1p2_svt_lp W=220.00n L=60.00n
MM52 net_0129 D VSS VSS nm1p2_svt_lp W=220.00n L=60.00n
MM54 N11 SE net_0121 VSS nm1p2_svt_lp W=220.00n L=60.00n
MM55 net_0121 SI VSS VSS nm1p2_svt_lp W=220.00n L=60.00n
MM3 net_0154 c net43 VSS nm1p2_svt_lp W=430.00n L=60.00n
MM48 net_0132 SDN VSS VSS nm1p2_svt_lp W=200.00n L=60.00n
MM49 QN net43 VSS VSS nm1p2_svt_lp W=290.00n L=60.00n
MM39 s net43 VSS VSS nm1p2_svt_lp W=240.00n L=60.00n
MM56 sen SE VSS VSS nm1p2_svt_lp W=200.00n L=60.00n
MM30 cn c VSS VSS nm1p2_svt_lp W=250.00n L=60.00n
MM27 c CKN VSS VSS nm1p2_svt_lp W=200.00n L=60.00n
MM24 net48 cn net43 VSS nm1p2_svt_lp W=200.00n L=60.00n
MM23 net_0132 s net48 VSS nm1p2_svt_lp W=200.00n L=60.00n
MM19 Q s VSS VSS nm1p2_svt_lp W=290.00n L=60.00n
MM12 net52 c net_0181 VSS nm1p2_svt_lp W=200.00n L=60.00n
MM11 VSS net_0154 net52 VSS nm1p2_svt_lp W=200.00n L=60.00n
MM9 net_0181 cn N11 VSS nm1p2_svt_lp W=220.00n L=60.00n
MM0 net_0154 net_0181 net_0132 VSS nm1p2_svt_lp W=430.00n L=60.00n
MM57 N7 sen net_0204 VDD pm1p2_svt_lp W=480.00n L=60.00n
MM59 N7 SE net_0200 VDD pm1p2_svt_lp W=480.00n L=60.00n
MM60 net_0200 D VDD VDD pm1p2_svt_lp W=480.00n L=60.00n
MM61 net_0204 SI VDD VDD pm1p2_svt_lp W=480.00n L=60.00n
MM43 net_0154 SDN VDD VDD pm1p2_svt_lp W=300.00n L=60.00n
MM62 sen SE VDD VDD pm1p2_svt_lp W=300.00n L=60.00n
MM50 QN net43 VDD VDD pm1p2_svt_lp W=440.00n L=60.00n
MM38 s net43 VDD VDD pm1p2_svt_lp W=360.00n L=60.00n
MM41 net43 SDN VDD VDD pm1p2_svt_lp W=300.00n L=60.00n
MM29 cn c VDD VDD pm1p2_svt_lp W=380.00n L=60.00n
MM28 c CKN VDD VDD pm1p2_svt_lp W=300.00n L=60.00n
MM26 VDD s net109 VDD pm1p2_svt_lp W=300.00n L=60.00n
MM25 net109 c net43 VDD pm1p2_svt_lp W=300.00n L=60.00n
MM20 Q s VDD VDD pm1p2_svt_lp W=440.00n L=60.00n
MM4 net_0154 cn net43 VDD pm1p2_svt_lp W=500.00n L=60.00n
MM14 net117 cn net_0181 VDD pm1p2_svt_lp W=300.00n L=60.00n
MM13 VDD net_0154 net117 VDD pm1p2_svt_lp W=300.00n L=60.00n
MM10 net_0181 c N7 VDD pm1p2_svt_lp W=480.00n L=60.00n
MM1 net_0154 net_0181 VDD VDD pm1p2_svt_lp W=500.00n L=60.00n
.ENDS

.SUBCKT SDFFNSX2H9R CKN D Q QN SDN SE SI VDD VSS
MM51 N11 sen net_0129 VSS nm1p2_svt_lp W=220.00n L=60.00n
MM52 net_0129 D VSS VSS nm1p2_svt_lp W=220.00n L=60.00n
MM54 N11 SE net_0121 VSS nm1p2_svt_lp W=220.00n L=60.00n
MM55 net_0121 SI VSS VSS nm1p2_svt_lp W=220.00n L=60.00n
MM3 net_0154 c net43 VSS nm1p2_svt_lp W=430.00n L=60.00n
MM48 net_0132 SDN VSS VSS nm1p2_svt_lp W=250.00n L=60.00n
MM49 QN net43 VSS VSS nm1p2_svt_lp W=430.00n L=60.00n
MM39 s net43 VSS VSS nm1p2_svt_lp W=290.00n L=60.00n
MM56 sen SE VSS VSS nm1p2_svt_lp W=200.00n L=60.00n
MM30 cn c VSS VSS nm1p2_svt_lp W=290.00n L=60.00n
MM27 c CKN VSS VSS nm1p2_svt_lp W=200.00n L=60.00n
MM24 net48 cn net43 VSS nm1p2_svt_lp W=200.00n L=60.00n
MM23 net_0132 s net48 VSS nm1p2_svt_lp W=200.00n L=60.00n
MM19 Q s VSS VSS nm1p2_svt_lp W=430.00n L=60.00n
MM12 net52 c net_0181 VSS nm1p2_svt_lp W=200.00n L=60.00n
MM11 VSS net_0154 net52 VSS nm1p2_svt_lp W=200.00n L=60.00n
MM9 net_0181 cn N11 VSS nm1p2_svt_lp W=220.00n L=60.00n
MM0 net_0154 net_0181 net_0132 VSS nm1p2_svt_lp W=430.00n L=60.00n
MM57 N7 sen net_0204 VDD pm1p2_svt_lp W=480.00n L=60.00n
MM59 N7 SE net_0200 VDD pm1p2_svt_lp W=480.00n L=60.00n
MM60 net_0200 D VDD VDD pm1p2_svt_lp W=480.00n L=60.00n
MM61 net_0204 SI VDD VDD pm1p2_svt_lp W=480.00n L=60.00n
MM43 net_0154 SDN VDD VDD pm1p2_svt_lp W=300.00n L=60.00n
MM62 sen SE VDD VDD pm1p2_svt_lp W=300.00n L=60.00n
MM50 QN net43 VDD VDD pm1p2_svt_lp W=650.00n L=60.00n
MM38 s net43 VDD VDD pm1p2_svt_lp W=440.00n L=60.00n
MM41 net43 SDN VDD VDD pm1p2_svt_lp W=300.00n L=60.00n
MM29 cn c VDD VDD pm1p2_svt_lp W=440.00n L=60.00n
MM28 c CKN VDD VDD pm1p2_svt_lp W=300.00n L=60.00n
MM26 VDD s net109 VDD pm1p2_svt_lp W=300.00n L=60.00n
MM25 net109 c net43 VDD pm1p2_svt_lp W=300.00n L=60.00n
MM20 Q s VDD VDD pm1p2_svt_lp W=650.00n L=60.00n
MM4 net_0154 cn net43 VDD pm1p2_svt_lp W=500.00n L=60.00n
MM14 net117 cn net_0181 VDD pm1p2_svt_lp W=300.00n L=60.00n
MM13 VDD net_0154 net117 VDD pm1p2_svt_lp W=300.00n L=60.00n
MM10 net_0181 c N7 VDD pm1p2_svt_lp W=480.00n L=60.00n
MM1 net_0154 net_0181 VDD VDD pm1p2_svt_lp W=500.00n L=60.00n
.ENDS

.SUBCKT SDFFNSX4H9R CKN D Q QN SDN SE SI VDD VSS
MM51 N11 sen net_0129 VSS nm1p2_svt_lp W=250.00n L=60.00n
MM52 net_0129 D VSS VSS nm1p2_svt_lp W=250.00n L=60.00n
MM54 N11 SE net_0121 VSS nm1p2_svt_lp W=250.00n L=60.00n
MM55 net_0121 SI VSS VSS nm1p2_svt_lp W=250.00n L=60.00n
MM3 net_0154 c net43 VSS nm1p2_svt_lp W=430.00n L=60.00n
MM48 net_0132 SDN VSS VSS nm1p2_svt_lp W=430.00n L=60.00n
MM49 QN net43 VSS VSS nm1p2_svt_lp W=860.00n L=60.00n
MM39 s net43 VSS VSS nm1p2_svt_lp W=380.00n L=60.00n
MM56 sen SE VSS VSS nm1p2_svt_lp W=200.00n L=60.00n
MM30 cn c VSS VSS nm1p2_svt_lp W=390.00n L=60.00n
MM27 c CKN VSS VSS nm1p2_svt_lp W=270.00n L=60.00n
MM24 net48 cn net43 VSS nm1p2_svt_lp W=200.00n L=60.00n
MM23 net_0132 s net48 VSS nm1p2_svt_lp W=200.00n L=60.00n
MM19 Q s VSS VSS nm1p2_svt_lp W=860.00n L=60.00n
MM12 net52 c net_0181 VSS nm1p2_svt_lp W=200.00n L=60.00n
MM11 VSS net_0154 net52 VSS nm1p2_svt_lp W=200.00n L=60.00n
MM9 net_0181 cn N11 VSS nm1p2_svt_lp W=250.00n L=60.00n
MM0 net_0154 net_0181 net_0132 VSS nm1p2_svt_lp W=430.00n L=60.00n
MM57 N7 sen net_0204 VDD pm1p2_svt_lp W=480.00n L=60.00n
MM59 N7 SE net_0200 VDD pm1p2_svt_lp W=480.00n L=60.00n
MM60 net_0200 D VDD VDD pm1p2_svt_lp W=480.00n L=60.00n
MM61 net_0204 SI VDD VDD pm1p2_svt_lp W=480.00n L=60.00n
MM43 net_0154 SDN VDD VDD pm1p2_svt_lp W=300.00n L=60.00n
MM62 sen SE VDD VDD pm1p2_svt_lp W=300.00n L=60.00n
MM50 QN net43 VDD VDD pm1p2_svt_lp W=1.3u L=60.00n
MM38 s net43 VDD VDD pm1p2_svt_lp W=540.00n L=60.00n
MM41 net43 SDN VDD VDD pm1p2_svt_lp W=300.00n L=60.00n
MM29 cn c VDD VDD pm1p2_svt_lp W=470.00n L=60.00n
MM28 c CKN VDD VDD pm1p2_svt_lp W=430.00n L=60.00n
MM26 VDD s net109 VDD pm1p2_svt_lp W=300.00n L=60.00n
MM25 net109 c net43 VDD pm1p2_svt_lp W=300.00n L=60.00n
MM20 Q s VDD VDD pm1p2_svt_lp W=1.3u L=60.00n
MM4 net_0154 cn net43 VDD pm1p2_svt_lp W=500.00n L=60.00n
MM14 net117 cn net_0181 VDD pm1p2_svt_lp W=300.00n L=60.00n
MM13 VDD net_0154 net117 VDD pm1p2_svt_lp W=300.00n L=60.00n
MM10 net_0181 c N7 VDD pm1p2_svt_lp W=480.00n L=60.00n
MM1 net_0154 net_0181 VDD VDD pm1p2_svt_lp W=500.00n L=60.00n
.ENDS

.SUBCKT SDFFTSX1H9R CK D Q QN SE SI SN VDD VSS
MM39 QN PS VSS VSS nm1p2_svt_lp W=290.00n L=60.00n
MM45 N74 SE net0128 VSS nm1p2_svt_lp W=200.00n L=60.00n
MM46 net0128 SI VSS VSS nm1p2_svt_lp W=200.00n L=60.00n
MM48 N74 cn PM VSS nm1p2_svt_lp W=270.00n L=60.00n
MM43 SNN SN VSS VSS nm1p2_svt_lp W=200.00n L=60.00n
MM52 SEN SE VSS VSS nm1p2_svt_lp W=200.00n L=60.00n
MM3 M c PS VSS nm1p2_svt_lp W=270.00n L=60.00n
MM42 net69 SNN VSS VSS nm1p2_svt_lp W=200.00n L=60.00n
MM30 c cn VSS VSS nm1p2_svt_lp W=250.00n L=60.00n
MM27 cn CK VSS VSS nm1p2_svt_lp W=200.00n L=60.00n
MM24 net48 cn PS VSS nm1p2_svt_lp W=200.00n L=60.00n
MM23 VSS S net48 VSS nm1p2_svt_lp W=200.00n L=60.00n
MM19 Q S VSS VSS nm1p2_svt_lp W=290.00n L=60.00n
MM17 S PS VSS VSS nm1p2_svt_lp W=240.00n L=60.00n
MM12 net52 c PM VSS nm1p2_svt_lp W=200.00n L=60.00n
MM11 VSS M net52 VSS nm1p2_svt_lp W=200.00n L=60.00n
MM9 N74 SEN net69 VSS nm1p2_svt_lp W=250.00n L=60.00n
MM7 net69 D VSS VSS nm1p2_svt_lp W=250.00n L=60.00n
MM0 M PM VSS VSS nm1p2_svt_lp W=270.00n L=60.00n
MM41 net_0231 SNN VDD VDD pm1p2_svt_lp W=400.00n L=60.00n
MM40 QN PS VDD VDD pm1p2_svt_lp W=440.00n L=60.00n
MM44 SNN SN VDD VDD pm1p2_svt_lp W=300.00n L=60.00n
MM50 net0207 SI VDD VDD pm1p2_svt_lp W=300.00n L=60.00n
MM51 N74 SEN net0207 VDD pm1p2_svt_lp W=300.00n L=60.00n
MM54 N74 c PM VDD pm1p2_svt_lp W=400.00n L=60.00n
MM4 M cn PS VDD pm1p2_svt_lp W=400.00n L=60.00n
MM29 c cn VDD VDD pm1p2_svt_lp W=380.00n L=60.00n
MM28 cn CK VDD VDD pm1p2_svt_lp W=300.00n L=60.00n
MM26 VDD S net109 VDD pm1p2_svt_lp W=300.00n L=60.00n
MM25 net109 c PS VDD pm1p2_svt_lp W=300.00n L=60.00n
MM20 Q S VDD VDD pm1p2_svt_lp W=440.00n L=60.00n
MM18 S PS VDD VDD pm1p2_svt_lp W=360.00n L=60.00n
MM14 net117 cn PM VDD pm1p2_svt_lp W=300.00n L=60.00n
MM13 VDD M net117 VDD pm1p2_svt_lp W=300.00n L=60.00n
MM10 N74 SE net128 VDD pm1p2_svt_lp W=400.00n L=60.00n
MM8 net128 D net_0231 VDD pm1p2_svt_lp W=400.00n L=60.00n
MM56 SEN SE VDD VDD pm1p2_svt_lp W=300.00n L=60.00n
MM1 M PM VDD VDD pm1p2_svt_lp W=400.00n L=60.00n
.ENDS

.SUBCKT SDFFTSX2H9R CK D Q QN SE SI SN VDD VSS
MM39 QN PS VSS VSS nm1p2_svt_lp W=430.00n L=60.00n
MM45 N74 SE net0128 VSS nm1p2_svt_lp W=200.00n L=60.00n
MM46 net0128 SI VSS VSS nm1p2_svt_lp W=200.00n L=60.00n
MM48 N74 cn PM VSS nm1p2_svt_lp W=360.00n L=60.00n
MM43 SNN SN VSS VSS nm1p2_svt_lp W=200.00n L=60.00n
MM52 SEN SE VSS VSS nm1p2_svt_lp W=200.00n L=60.00n
MM3 M c PS VSS nm1p2_svt_lp W=390.00n L=60.00n
MM42 net69 SNN VSS VSS nm1p2_svt_lp W=200.00n L=60.00n
MM30 c cn VSS VSS nm1p2_svt_lp W=380.00n L=60.00n
MM27 cn CK VSS VSS nm1p2_svt_lp W=290.00n L=60.00n
MM24 net48 cn PS VSS nm1p2_svt_lp W=200.00n L=60.00n
MM23 VSS S net48 VSS nm1p2_svt_lp W=200.00n L=60.00n
MM19 Q S VSS VSS nm1p2_svt_lp W=430.00n L=60.00n
MM17 S PS VSS VSS nm1p2_svt_lp W=290.00n L=60.00n
MM12 net52 c PM VSS nm1p2_svt_lp W=200.00n L=60.00n
MM11 VSS M net52 VSS nm1p2_svt_lp W=200.00n L=60.00n
MM9 N74 SEN net69 VSS nm1p2_svt_lp W=380.00n L=60.00n
MM7 net69 D VSS VSS nm1p2_svt_lp W=380.00n L=60.00n
MM0 M PM VSS VSS nm1p2_svt_lp W=390.00n L=60.00n
MM41 net_0231 SNN VDD VDD pm1p2_svt_lp W=600.0n L=60.00n
MM40 QN PS VDD VDD pm1p2_svt_lp W=650.00n L=60.00n
MM44 SNN SN VDD VDD pm1p2_svt_lp W=300.00n L=60.00n
MM50 net0207 SI VDD VDD pm1p2_svt_lp W=300.00n L=60.00n
MM51 N74 SEN net0207 VDD pm1p2_svt_lp W=300.00n L=60.00n
MM54 N74 c PM VDD pm1p2_svt_lp W=540.00n L=60.00n
MM4 M cn PS VDD pm1p2_svt_lp W=580.00n L=60.00n
MM29 c cn VDD VDD pm1p2_svt_lp W=570.00n L=60.00n
MM28 cn CK VDD VDD pm1p2_svt_lp W=440.00n L=60.00n
MM26 VDD S net109 VDD pm1p2_svt_lp W=300.00n L=60.00n
MM25 net109 c PS VDD pm1p2_svt_lp W=300.00n L=60.00n
MM20 Q S VDD VDD pm1p2_svt_lp W=650.00n L=60.00n
MM18 S PS VDD VDD pm1p2_svt_lp W=440.00n L=60.00n
MM14 net117 cn PM VDD pm1p2_svt_lp W=300.00n L=60.00n
MM13 VDD M net117 VDD pm1p2_svt_lp W=300.00n L=60.00n
MM10 N74 SE net128 VDD pm1p2_svt_lp W=600.0n L=60.00n
MM8 net128 D net_0231 VDD pm1p2_svt_lp W=600.0n L=60.00n
MM56 SEN SE VDD VDD pm1p2_svt_lp W=300.00n L=60.00n
MM1 M PM VDD VDD pm1p2_svt_lp W=580.00n L=60.00n
.ENDS

.SUBCKT SDFFTSX4H9R CK D Q QN SE SI SN VDD VSS
MM39 QN PS VSS VSS nm1p2_svt_lp W=860.00n L=60.00n
MM45 N74 SE net0128 VSS nm1p2_svt_lp W=200.00n L=60.00n
MM46 net0128 SI VSS VSS nm1p2_svt_lp W=200.00n L=60.00n
MM48 N74 cn PM VSS nm1p2_svt_lp W=400.00n L=60.00n
MM43 SNN SN VSS VSS nm1p2_svt_lp W=200.00n L=60.00n
MM52 SEN SE VSS VSS nm1p2_svt_lp W=200.00n L=60.00n
MM3 M c PS VSS nm1p2_svt_lp W=430.00n L=60.00n
MM42 net69 SNN VSS VSS nm1p2_svt_lp W=250.00n L=60.00n
MM30 c cn VSS VSS nm1p2_svt_lp W=430.00n L=60.00n
MM27 cn CK VSS VSS nm1p2_svt_lp W=290.00n L=60.00n
MM24 net48 cn PS VSS nm1p2_svt_lp W=200.00n L=60.00n
MM23 VSS S net48 VSS nm1p2_svt_lp W=200.00n L=60.00n
MM19 Q S VSS VSS nm1p2_svt_lp W=860.00n L=60.00n
MM17 S PS VSS VSS nm1p2_svt_lp W=360.00n L=60.00n
MM12 net52 c PM VSS nm1p2_svt_lp W=200.00n L=60.00n
MM11 VSS M net52 VSS nm1p2_svt_lp W=200.00n L=60.00n
MM9 N74 SEN net69 VSS nm1p2_svt_lp W=430.00n L=60.00n
MM7 net69 D VSS VSS nm1p2_svt_lp W=430.00n L=60.00n
MM0 M PM VSS VSS nm1p2_svt_lp W=430.00n L=60.00n
MM41 net_0231 SNN VDD VDD pm1p2_svt_lp W=650.00n L=60.00n
MM40 QN PS VDD VDD pm1p2_svt_lp W=1.3u L=60.00n
MM44 SNN SN VDD VDD pm1p2_svt_lp W=300.00n L=60.00n
MM50 net0207 SI VDD VDD pm1p2_svt_lp W=300.00n L=60.00n
MM51 N74 SEN net0207 VDD pm1p2_svt_lp W=300.00n L=60.00n
MM54 N74 c PM VDD pm1p2_svt_lp W=600.0n L=60.00n
MM4 M cn PS VDD pm1p2_svt_lp W=650.00n L=60.00n
MM29 c cn VDD VDD pm1p2_svt_lp W=650.00n L=60.00n
MM28 cn CK VDD VDD pm1p2_svt_lp W=440.00n L=60.00n
MM26 VDD S net109 VDD pm1p2_svt_lp W=300.00n L=60.00n
MM25 net109 c PS VDD pm1p2_svt_lp W=300.00n L=60.00n
MM20 Q S VDD VDD pm1p2_svt_lp W=1.3u L=60.00n
MM18 S PS VDD VDD pm1p2_svt_lp W=540.00n L=60.00n
MM14 net117 cn PM VDD pm1p2_svt_lp W=300.00n L=60.00n
MM13 VDD M net117 VDD pm1p2_svt_lp W=300.00n L=60.00n
MM10 N74 SE net128 VDD pm1p2_svt_lp W=650.00n L=60.00n
MM8 net128 D net_0231 VDD pm1p2_svt_lp W=650.00n L=60.00n
MM56 SEN SE VDD VDD pm1p2_svt_lp W=300.00n L=60.00n
MM1 M PM VDD VDD pm1p2_svt_lp W=650.00n L=60.00n
.ENDS

.SUBCKT SDFFRSX1H9R CK D Q QN RDN SDN SE SI VDD VSS
MM58 sen SE VSS VSS nm1p2_svt_lp W=200.00n L=60.00n
MM45 R RDN VSS VSS nm1p2_svt_lp W=200.00n L=60.00n
MM47 net_0154 R L VSS nm1p2_svt_lp W=200.00n L=60.00n
MM3 net_0154 c net43 VSS nm1p2_svt_lp W=250.00n L=60.00n
MM48 L SDN VSS VSS nm1p2_svt_lp W=290.00n L=60.00n
MM49 QN net43 VSS VSS nm1p2_svt_lp W=290.00n L=60.00n
MM39 s net43 VSS VSS nm1p2_svt_lp W=290.00n L=60.00n
MM56 net_0140 cn net_0139 VSS nm1p2_svt_lp W=200.00n L=60.00n
MM51 net_0140 sen net_0144 VSS nm1p2_svt_lp W=260.00n L=60.00n
MM40 net43 R L VSS nm1p2_svt_lp W=200.00n L=60.00n
MM52 net_0144 D VSS VSS nm1p2_svt_lp W=260.00n L=60.00n
MM9 net_0140 SE net_0156 VSS nm1p2_svt_lp W=260.00n L=60.00n
MM7 net_0156 SI VSS VSS nm1p2_svt_lp W=260.00n L=60.00n
MM30 c cn VSS VSS nm1p2_svt_lp W=200.00n L=60.00n
MM27 cn CK VSS VSS nm1p2_svt_lp W=200.00n L=60.00n
MM24 net48 cn net43 VSS nm1p2_svt_lp W=200.00n L=60.00n
MM23 L s net48 VSS nm1p2_svt_lp W=200.00n L=60.00n
MM19 Q s VSS VSS nm1p2_svt_lp W=290.00n L=60.00n
MM12 net52 c net_0139 VSS nm1p2_svt_lp W=200.00n L=60.00n
MM11 VSS net_0154 net52 VSS nm1p2_svt_lp W=200.00n L=60.00n
MM0 net_0154 net_0139 L VSS nm1p2_svt_lp W=280.00n L=60.00n
MM59 sen SE VDD VDD pm1p2_svt_lp W=300.00n L=60.00n
MM46 R RDN VDD VDD pm1p2_svt_lp W=300.00n L=60.00n
MM43 net_0154 SDN VDD VDD pm1p2_svt_lp W=300.00n L=60.00n
MM10 net_0140 sen net_0223 VDD pm1p2_svt_lp W=330.00n L=60.00n
MM50 QN net43 VDD VDD pm1p2_svt_lp W=440.00n L=60.00n
MM57 net_0140 c net_0139 VDD pm1p2_svt_lp W=300.00n L=60.00n
MM38 s net43 VDD VDD pm1p2_svt_lp W=400.00n L=60.00n
MM41 net43 SDN VDD VDD pm1p2_svt_lp W=300.00n L=60.00n
MM44 H R VDD VDD pm1p2_svt_lp W=420.00n L=60.00n
MM29 c cn VDD VDD pm1p2_svt_lp W=300.00n L=60.00n
MM28 cn CK VDD VDD pm1p2_svt_lp W=300.00n L=60.00n
MM26 H s net109 VDD pm1p2_svt_lp W=300.00n L=60.00n
MM25 net109 c net43 VDD pm1p2_svt_lp W=300.00n L=60.00n
MM20 Q s VDD VDD pm1p2_svt_lp W=440.00n L=60.00n
MM4 net_0154 cn net43 VDD pm1p2_svt_lp W=380.00n L=60.00n
MM14 net117 cn net_0139 VDD pm1p2_svt_lp W=300.00n L=60.00n
MM13 VDD net_0154 net117 VDD pm1p2_svt_lp W=300.00n L=60.00n
MM54 net_0140 SE net_0231 VDD pm1p2_svt_lp W=330.00n L=60.00n
MM55 net_0231 D VDD VDD pm1p2_svt_lp W=330.00n L=60.00n
MM8 net_0223 SI VDD VDD pm1p2_svt_lp W=330.00n L=60.00n
MM1 net_0154 net_0139 H VDD pm1p2_svt_lp W=440.00n L=60.00n
.ENDS

.SUBCKT SDFFRSX2H9R CK D Q QN RDN SDN SE SI VDD VSS
MM58 sen SE VSS VSS nm1p2_svt_lp W=200.00n L=60.00n
MM45 R RDN VSS VSS nm1p2_svt_lp W=200.00n L=60.00n
MM47 net_0154 R L VSS nm1p2_svt_lp W=280.00n L=60.00n
MM3 net_0154 c net43 VSS nm1p2_svt_lp W=250.00n L=60.00n
MM48 L SDN VSS VSS nm1p2_svt_lp W=360.00n L=60.00n
MM49 QN net43 VSS VSS nm1p2_svt_lp W=430.00n L=60.00n
MM39 s net43 VSS VSS nm1p2_svt_lp W=390.00n L=60.00n
MM56 net_0140 cn net_0139 VSS nm1p2_svt_lp W=200.00n L=60.00n
MM51 net_0140 sen net_0144 VSS nm1p2_svt_lp W=220.00n L=60.00n
MM40 net43 R L VSS nm1p2_svt_lp W=280.00n L=60.00n
MM52 net_0144 D VSS VSS nm1p2_svt_lp W=220.00n L=60.00n
MM9 net_0140 SE net_0156 VSS nm1p2_svt_lp W=220.00n L=60.00n
MM7 net_0156 SI VSS VSS nm1p2_svt_lp W=220.00n L=60.00n
MM30 c cn VSS VSS nm1p2_svt_lp W=200.00n L=60.00n
MM27 cn CK VSS VSS nm1p2_svt_lp W=200.00n L=60.00n
MM24 net48 cn net43 VSS nm1p2_svt_lp W=200.00n L=60.00n
MM23 L s net48 VSS nm1p2_svt_lp W=200.00n L=60.00n
MM19 Q s VSS VSS nm1p2_svt_lp W=430.00n L=60.00n
MM12 net52 c net_0139 VSS nm1p2_svt_lp W=200.00n L=60.00n
MM11 VSS net_0154 net52 VSS nm1p2_svt_lp W=200.00n L=60.00n
MM0 net_0154 net_0139 L VSS nm1p2_svt_lp W=360.00n L=60.00n
MM59 sen SE VDD VDD pm1p2_svt_lp W=300.00n L=60.00n
MM46 R RDN VDD VDD pm1p2_svt_lp W=300.00n L=60.00n
MM43 net_0154 SDN VDD VDD pm1p2_svt_lp W=300.00n L=60.00n
MM10 net_0140 sen net_0223 VDD pm1p2_svt_lp W=300.00n L=60.00n
MM50 QN net43 VDD VDD pm1p2_svt_lp W=650.00n L=60.00n
MM57 net_0140 c net_0139 VDD pm1p2_svt_lp W=300.00n L=60.00n
MM38 s net43 VDD VDD pm1p2_svt_lp W=500.00n L=60.00n
MM41 net43 SDN VDD VDD pm1p2_svt_lp W=300.00n L=60.00n
MM44 H R VDD VDD pm1p2_svt_lp W=510.00n L=60.00n
MM29 c cn VDD VDD pm1p2_svt_lp W=300.00n L=60.00n
MM28 cn CK VDD VDD pm1p2_svt_lp W=300.00n L=60.00n
MM26 H s net109 VDD pm1p2_svt_lp W=300.00n L=60.00n
MM25 net109 c net43 VDD pm1p2_svt_lp W=300.00n L=60.00n
MM20 Q s VDD VDD pm1p2_svt_lp W=650.00n L=60.00n
MM4 net_0154 cn net43 VDD pm1p2_svt_lp W=380.00n L=60.00n
MM14 net117 cn net_0139 VDD pm1p2_svt_lp W=300.00n L=60.00n
MM13 VDD net_0154 net117 VDD pm1p2_svt_lp W=300.00n L=60.00n
MM54 net_0140 SE net_0231 VDD pm1p2_svt_lp W=300.00n L=60.00n
MM55 net_0231 D VDD VDD pm1p2_svt_lp W=300.00n L=60.00n
MM8 net_0223 SI VDD VDD pm1p2_svt_lp W=300.00n L=60.00n
MM1 net_0154 net_0139 H VDD pm1p2_svt_lp W=600.00n L=60.00n
.ENDS

.SUBCKT SDFFRSX4H9R CK D Q QN RDN SDN SE SI VDD VSS
MM58 sen SE VSS VSS nm1p2_svt_lp W=200.00n L=60.00n
MM45 R RDN VSS VSS nm1p2_svt_lp W=200.00n L=60.00n
MM47 net_0154 R L VSS nm1p2_svt_lp W=280.00n L=60.00n
MM3 net_0154 c net43 VSS nm1p2_svt_lp W=250.00n L=60.00n
MM48 L SDN VSS VSS nm1p2_svt_lp W=320.00n L=60.00n
MM49 QN net43 VSS VSS nm1p2_svt_lp W=430.00n L=60.00n m=2
MM39 s net43 VSS VSS nm1p2_svt_lp W=430.00n L=60.00n
MM56 net_0140 cn net_0139 VSS nm1p2_svt_lp W=430.00n L=60.00n
MM51 net_0140 sen net_0144 VSS nm1p2_svt_lp W=400.00n L=60.00n
MM40 net43 R L VSS nm1p2_svt_lp W=280.00n L=60.00n
MM52 net_0144 D VSS VSS nm1p2_svt_lp W=400.00n L=60.00n
MM9 net_0140 SE net_0156 VSS nm1p2_svt_lp W=400.00n L=60.00n
MM7 net_0156 SI VSS VSS nm1p2_svt_lp W=400.00n L=60.00n
MM30 c cn VSS VSS nm1p2_svt_lp W=430.00n L=60.00n
MM27 cn CK VSS VSS nm1p2_svt_lp W=300.00n L=60.00n
MM24 net48 cn net43 VSS nm1p2_svt_lp W=200.00n L=60.00n
MM23 L s net48 VSS nm1p2_svt_lp W=200.00n L=60.00n
MM19 Q s VSS VSS nm1p2_svt_lp W=430.00n L=60.00n m=2
MM12 net52 c net_0139 VSS nm1p2_svt_lp W=200.00n L=60.00n
MM11 VSS net_0154 net52 VSS nm1p2_svt_lp W=200.00n L=60.00n
MM0 net_0154 net_0139 L VSS nm1p2_svt_lp W=360.00n L=60.00n
MM59 sen SE VDD VDD pm1p2_svt_lp W=300.00n L=60.00n
MM46 R RDN VDD VDD pm1p2_svt_lp W=300.00n L=60.00n
MM43 net_0154 SDN VDD VDD pm1p2_svt_lp W=300.00n L=60.00n
MM10 net_0140 sen net_0223 VDD pm1p2_svt_lp W=500.00n L=60.00n
MM50 QN net43 VDD VDD pm1p2_svt_lp W=650.00n L=60.00n m=2
MM57 net_0140 c net_0139 VDD pm1p2_svt_lp W=580.00n L=60.00n
MM38 s net43 VDD VDD pm1p2_svt_lp W=600.00n L=60.00n
MM41 net43 SDN VDD VDD pm1p2_svt_lp W=300.00n L=60.00n
MM44 H R VDD VDD pm1p2_svt_lp W=520.00n L=60.00n
MM29 c cn VDD VDD pm1p2_svt_lp W=620.00n L=60.00n
MM28 cn CK VDD VDD pm1p2_svt_lp W=450.00n L=60.00n
MM26 H s net109 VDD pm1p2_svt_lp W=300.00n L=60.00n
MM25 net109 c net43 VDD pm1p2_svt_lp W=300.00n L=60.00n
MM20 Q s VDD VDD pm1p2_svt_lp W=650.00n L=60.00n m=2
MM4 net_0154 cn net43 VDD pm1p2_svt_lp W=380.00n L=60.00n
MM14 net117 cn net_0139 VDD pm1p2_svt_lp W=300.00n L=60.00n
MM13 VDD net_0154 net117 VDD pm1p2_svt_lp W=300.00n L=60.00n
MM54 net_0140 SE net_0231 VDD pm1p2_svt_lp W=500.00n L=60.00n
MM55 net_0231 D VDD VDD pm1p2_svt_lp W=500.00n L=60.00n
MM8 net_0223 SI VDD VDD pm1p2_svt_lp W=500.00n L=60.00n
MM1 net_0154 net_0139 H VDD pm1p2_svt_lp W=650.00n L=60.00n
.ENDS

.SUBCKT SDFFNRSX1H9R CKN D Q QN RDN SDN SE SI VDD VSS
MM58 sen SE VSS VSS nm1p2_svt_lp W=300.00n L=60.00n
MM45 R RDN VSS VSS nm1p2_svt_lp W=270.00n L=60.00n
MM47 net_0154 R L VSS nm1p2_svt_lp W=200.00n L=60.00n
MM3 net_0154 c net43 VSS nm1p2_svt_lp W=340.00n L=60.00n
MM48 L SDN VSS VSS nm1p2_svt_lp W=340.00n L=60.00n
MM49 QN net43 VSS VSS nm1p2_svt_lp W=290.00n L=60.00n
MM39 s net43 VSS VSS nm1p2_svt_lp W=380.00n L=60.00n
MM56 net_0140 cn net_0139 VSS nm1p2_svt_lp W=300.00n L=60.00n
MM51 net_0140 sen net_0144 VSS nm1p2_svt_lp W=300.00n L=60.00n
MM40 net43 R L VSS nm1p2_svt_lp W=200.00n L=60.00n
MM52 net_0144 D VSS VSS nm1p2_svt_lp W=300.00n L=60.00n
MM9 net_0140 SE net_0156 VSS nm1p2_svt_lp W=300.00n L=60.00n
MM7 net_0156 SI VSS VSS nm1p2_svt_lp W=300.00n L=60.00n
MM30 cn c VSS VSS nm1p2_svt_lp W=360.00n L=60.00n
MM27 c CKN VSS VSS nm1p2_svt_lp W=270.00n L=60.00n
MM24 net48 cn net43 VSS nm1p2_svt_lp W=200.00n L=60.00n
MM23 L s net48 VSS nm1p2_svt_lp W=200.00n L=60.00n
MM19 Q s VSS VSS nm1p2_svt_lp W=290.00n L=60.00n
MM12 net52 c net_0139 VSS nm1p2_svt_lp W=200.00n L=60.00n
MM11 VSS net_0154 net52 VSS nm1p2_svt_lp W=200.00n L=60.00n
MM0 net_0154 net_0139 L VSS nm1p2_svt_lp W=360.00n L=60.00n
MM59 sen SE VDD VDD pm1p2_svt_lp W=450.00n L=60.00n
MM46 R RDN VDD VDD pm1p2_svt_lp W=430.00n L=60.00n
MM43 net_0154 SDN VDD VDD pm1p2_svt_lp W=300.00n L=60.00n
MM10 net_0140 sen net_0223 VDD pm1p2_svt_lp W=450.00n L=60.00n
MM50 QN net43 VDD VDD pm1p2_svt_lp W=440.00n L=60.00n
MM57 net_0140 c net_0139 VDD pm1p2_svt_lp W=450.00n L=60.00n
MM38 s net43 VDD VDD pm1p2_svt_lp W=390.00n L=60.00n
MM41 net43 SDN VDD VDD pm1p2_svt_lp W=300.00n L=60.00n
MM44 H R VDD VDD pm1p2_svt_lp W=500.00n L=60.00n
MM29 cn c VDD VDD pm1p2_svt_lp W=540.00n L=60.00n
MM28 c CKN VDD VDD pm1p2_svt_lp W=430.00n L=60.00n
MM26 H s net109 VDD pm1p2_svt_lp W=300.00n L=60.00n
MM25 net109 c net43 VDD pm1p2_svt_lp W=300.00n L=60.00n
MM20 Q s VDD VDD pm1p2_svt_lp W=440.00n L=60.00n
MM4 net_0154 cn net43 VDD pm1p2_svt_lp W=500.00n L=60.00n
MM14 net117 cn net_0139 VDD pm1p2_svt_lp W=300.00n L=60.00n
MM13 VDD net_0154 net117 VDD pm1p2_svt_lp W=300.00n L=60.00n
MM54 net_0140 SE net_0231 VDD pm1p2_svt_lp W=540.00n L=60.00n
MM55 net_0231 D VDD VDD pm1p2_svt_lp W=540.00n L=60.00n
MM8 net_0223 SI VDD VDD pm1p2_svt_lp W=450.00n L=60.00n
MM1 net_0154 net_0139 H VDD pm1p2_svt_lp W=500.00n L=60.00n
.ENDS

.SUBCKT SDFFNRSX2H9R CKN D Q QN RDN SDN SE SI VDD VSS
MM58 sen SE VSS VSS nm1p2_svt_lp W=300.00n L=60.00n
MM45 R RDN VSS VSS nm1p2_svt_lp W=270.00n L=60.00n
MM47 net_0154 R L VSS nm1p2_svt_lp W=200.00n L=60.00n
MM3 net_0154 c net43 VSS nm1p2_svt_lp W=340.00n L=60.00n
MM48 L SDN VSS VSS nm1p2_svt_lp W=340.00n L=60.00n
MM49 QN net43 VSS VSS nm1p2_svt_lp W=430.00n L=60.00n
MM39 s net43 VSS VSS nm1p2_svt_lp W=380.00n L=60.00n
MM56 net_0140 cn net_0139 VSS nm1p2_svt_lp W=300.00n L=60.00n
MM51 net_0140 sen net_0144 VSS nm1p2_svt_lp W=300.00n L=60.00n
MM40 net43 R L VSS nm1p2_svt_lp W=200.00n L=60.00n
MM52 net_0144 D VSS VSS nm1p2_svt_lp W=300.00n L=60.00n
MM9 net_0140 SE net_0156 VSS nm1p2_svt_lp W=300.00n L=60.00n
MM7 net_0156 SI VSS VSS nm1p2_svt_lp W=300.00n L=60.00n
MM30 cn c VSS VSS nm1p2_svt_lp W=360.00n L=60.00n
MM27 c CKN VSS VSS nm1p2_svt_lp W=270.00n L=60.00n
MM24 net48 cn net43 VSS nm1p2_svt_lp W=200.00n L=60.00n
MM23 L s net48 VSS nm1p2_svt_lp W=200.00n L=60.00n
MM19 Q s VSS VSS nm1p2_svt_lp W=430.00n L=60.00n
MM12 net52 c net_0139 VSS nm1p2_svt_lp W=200.00n L=60.00n
MM11 VSS net_0154 net52 VSS nm1p2_svt_lp W=200.00n L=60.00n
MM0 net_0154 net_0139 L VSS nm1p2_svt_lp W=360.00n L=60.00n
MM59 sen SE VDD VDD pm1p2_svt_lp W=450.00n L=60.00n
MM46 R RDN VDD VDD pm1p2_svt_lp W=430.00n L=60.00n
MM43 net_0154 SDN VDD VDD pm1p2_svt_lp W=300.00n L=60.00n
MM10 net_0140 sen net_0223 VDD pm1p2_svt_lp W=450.00n L=60.00n
MM50 QN net43 VDD VDD pm1p2_svt_lp W=650.00n L=60.00n
MM57 net_0140 c net_0139 VDD pm1p2_svt_lp W=450.00n L=60.00n
MM38 s net43 VDD VDD pm1p2_svt_lp W=390.00n L=60.00n
MM41 net43 SDN VDD VDD pm1p2_svt_lp W=300.00n L=60.00n
MM44 H R VDD VDD pm1p2_svt_lp W=500.00n L=60.00n
MM29 cn c VDD VDD pm1p2_svt_lp W=540.00n L=60.00n
MM28 c CKN VDD VDD pm1p2_svt_lp W=430.00n L=60.00n
MM26 H s net109 VDD pm1p2_svt_lp W=300.00n L=60.00n
MM25 net109 c net43 VDD pm1p2_svt_lp W=300.00n L=60.00n
MM20 Q s VDD VDD pm1p2_svt_lp W=650.00n L=60.00n
MM4 net_0154 cn net43 VDD pm1p2_svt_lp W=500.00n L=60.00n
MM14 net117 cn net_0139 VDD pm1p2_svt_lp W=300.00n L=60.00n
MM13 VDD net_0154 net117 VDD pm1p2_svt_lp W=300.00n L=60.00n
MM54 net_0140 SE net_0231 VDD pm1p2_svt_lp W=540.00n L=60.00n
MM55 net_0231 D VDD VDD pm1p2_svt_lp W=540.00n L=60.00n
MM8 net_0223 SI VDD VDD pm1p2_svt_lp W=450.00n L=60.00n
MM1 net_0154 net_0139 H VDD pm1p2_svt_lp W=500.00n L=60.00n
.ENDS

.SUBCKT SDFFNRSX4H9R CKN D Q QN RDN SDN SE SI VDD VSS
MM58 sen SE VSS VSS nm1p2_svt_lp W=300.00n L=60.00n
MM45 R RDN VSS VSS nm1p2_svt_lp W=270.00n L=60.00n
MM47 net_0154 R L VSS nm1p2_svt_lp W=200.00n L=60.00n
MM3 net_0154 c net43 VSS nm1p2_svt_lp W=350.00n L=60.00n
MM48 L SDN VSS VSS nm1p2_svt_lp W=360.00n L=60.00n
MM49 QN net43 VSS VSS nm1p2_svt_lp W=860.00n L=60.00n
MM39 s net43 VSS VSS nm1p2_svt_lp W=380.00n L=60.00n
MM56 net_0140 cn net_0139 VSS nm1p2_svt_lp W=300.00n L=60.00n
MM51 net_0140 sen net_0144 VSS nm1p2_svt_lp W=320.00n L=60.00n
MM40 net43 R L VSS nm1p2_svt_lp W=200.00n L=60.00n
MM52 net_0144 D VSS VSS nm1p2_svt_lp W=320.00n L=60.00n
MM9 net_0140 SE net_0156 VSS nm1p2_svt_lp W=300.00n L=60.00n
MM7 net_0156 SI VSS VSS nm1p2_svt_lp W=300.00n L=60.00n
MM30 cn c VSS VSS nm1p2_svt_lp W=360.00n L=60.00n
MM27 c CKN VSS VSS nm1p2_svt_lp W=270.00n L=60.00n
MM24 net48 cn net43 VSS nm1p2_svt_lp W=200.00n L=60.00n
MM23 L s net48 VSS nm1p2_svt_lp W=200.00n L=60.00n
MM19 Q s VSS VSS nm1p2_svt_lp W=860.00n L=60.00n
MM12 net52 c net_0139 VSS nm1p2_svt_lp W=200.00n L=60.00n
MM11 VSS net_0154 net52 VSS nm1p2_svt_lp W=200.00n L=60.00n
MM0 net_0154 net_0139 L VSS nm1p2_svt_lp W=360.00n L=60.00n
MM59 sen SE VDD VDD pm1p2_svt_lp W=450.00n L=60.00n
MM46 R RDN VDD VDD pm1p2_svt_lp W=430.00n L=60.00n
MM43 net_0154 SDN VDD VDD pm1p2_svt_lp W=300.00n L=60.00n
MM10 net_0140 sen net_0223 VDD pm1p2_svt_lp W=450.00n L=60.00n
MM50 QN net43 VDD VDD pm1p2_svt_lp W=1.3u L=60.00n
MM57 net_0140 c net_0139 VDD pm1p2_svt_lp W=450.00n L=60.00n
MM38 s net43 VDD VDD pm1p2_svt_lp W=390.00n L=60.00n
MM41 net43 SDN VDD VDD pm1p2_svt_lp W=300.00n L=60.00n
MM44 H R VDD VDD pm1p2_svt_lp W=540.00n L=60.00n
MM29 cn c VDD VDD pm1p2_svt_lp W=540.00n L=60.00n
MM28 c CKN VDD VDD pm1p2_svt_lp W=430.00n L=60.00n
MM26 H s net109 VDD pm1p2_svt_lp W=300.00n L=60.00n
MM25 net109 c net43 VDD pm1p2_svt_lp W=300.00n L=60.00n
MM20 Q s VDD VDD pm1p2_svt_lp W=1.3u L=60.00n
MM4 net_0154 cn net43 VDD pm1p2_svt_lp W=540.00n L=60.00n
MM14 net117 cn net_0139 VDD pm1p2_svt_lp W=300.00n L=60.00n
MM13 VDD net_0154 net117 VDD pm1p2_svt_lp W=300.00n L=60.00n
MM54 net_0140 SE net_0231 VDD pm1p2_svt_lp W=540.00n L=60.00n
MM55 net_0231 D VDD VDD pm1p2_svt_lp W=540.00n L=60.00n
MM8 net_0223 SI VDD VDD pm1p2_svt_lp W=450.00n L=60.00n
MM1 net_0154 net_0139 H VDD pm1p2_svt_lp W=540.00n L=60.00n
.ENDS

.SUBCKT SDFFTRSX1H9R CK D Q QN RN SE SI SN VDD VSS
MM45 net0370 SE net201 VSS nm1p2_svt_lp W=300.00n L=60.00n
MM46 net201 SI VSS VSS nm1p2_svt_lp W=300.00n L=60.00n
MM47 net0172 RN VSS VSS nm1p2_svt_lp W=390.00n L=60.00n
MM48 net0370 SEN net213 VSS nm1p2_svt_lp W=340.00n L=60.00n
MM49 net213 D net205 VSS nm1p2_svt_lp W=390.00n L=60.00n
MM43 SNN SN VSS VSS nm1p2_svt_lp W=300.00n L=60.00n
MM39 QN OS VSS VSS nm1p2_svt_lp W=290.00n L=60.00n
MM62 OS c net181 VSS nm1p2_svt_lp W=260.00n L=60.00n
MM63 net181 S VSS VSS nm1p2_svt_lp W=260.00n L=60.00n
MM61 M cn net193 VSS nm1p2_svt_lp W=300.00n L=60.00n
MM58 SEN SE VSS VSS nm1p2_svt_lp W=300.00n L=60.00n
MM70 net205 SN net0172 VSS nm1p2_svt_lp W=390.00n L=60.00n
MM60 net193 net0370 VSS VSS nm1p2_svt_lp W=300.00n L=60.00n
MM30 c cn VSS VSS nm1p2_svt_lp W=230.00n L=60.00n
MM27 cn CK VSS VSS nm1p2_svt_lp W=230.00n L=60.00n
MM24 net172 cn OS VSS nm1p2_svt_lp W=200.00n L=60.00n
MM23 VSS NET64 net172 VSS nm1p2_svt_lp W=200.00n L=60.00n
MM69 net213 SNN net0172 VSS nm1p2_svt_lp W=300.00n L=60.00n
MM19 Q NET64 VSS VSS nm1p2_svt_lp W=290.00n L=60.00n
MM17 NET64 OS VSS VSS nm1p2_svt_lp W=260.00n L=60.00n
MM12 net240 c M VSS nm1p2_svt_lp W=200.00n L=60.00n
MM11 VSS S net240 VSS nm1p2_svt_lp W=200.00n L=60.00n
MM0 S M VSS VSS nm1p2_svt_lp W=300.00n L=60.00n
MM66 net0418 SNN net296 VDD pm1p2_svt_lp W=590.00n L=60.00n
MM50 net288 SI VDD VDD pm1p2_svt_lp W=420.00n L=60.00n
MM51 net0370 SEN net288 VDD pm1p2_svt_lp W=420.00n L=60.00n
MM52 net296 D VDD VDD pm1p2_svt_lp W=590.00n L=60.00n
MM53 net0370 SE net0418 VDD pm1p2_svt_lp W=590.00n L=60.00n
MM44 SNN SN VDD VDD pm1p2_svt_lp W=450.00n L=60.00n
MM40 QN OS VDD VDD pm1p2_svt_lp W=440.00n L=60.00n
MM64 net268 S VDD VDD pm1p2_svt_lp W=390.00n L=60.00n
MM65 OS cn net268 VDD pm1p2_svt_lp W=390.00n L=60.00n
MM67 net0418 RN VDD VDD pm1p2_svt_lp W=450.00n L=60.00n
MM59 SEN SE VDD VDD pm1p2_svt_lp W=450.00n L=60.00n
MM29 c cn VDD VDD pm1p2_svt_lp W=360.00n L=60.00n
MM28 cn CK VDD VDD pm1p2_svt_lp W=360.00n L=60.00n
MM26 VDD NET64 net253 VDD pm1p2_svt_lp W=300.00n L=60.00n
MM25 net253 c OS VDD pm1p2_svt_lp W=300.00n L=60.00n
MM20 Q NET64 VDD VDD pm1p2_svt_lp W=440.00n L=60.00n
MM18 NET64 OS VDD VDD pm1p2_svt_lp W=390.00n L=60.00n
MM14 net313 cn M VDD pm1p2_svt_lp W=300.00n L=60.00n
MM13 VDD S net313 VDD pm1p2_svt_lp W=300.00n L=60.00n
MM55 net280 net0370 VDD VDD pm1p2_svt_lp W=450.00n L=60.00n
MM56 M c net280 VDD pm1p2_svt_lp W=450.00n L=60.00n
MM1 S M VDD VDD pm1p2_svt_lp W=450.00n L=60.00n
.ENDS

.SUBCKT SDFFTRSX2H9R CK D Q QN RN SE SI SN VDD VSS
MM45 net0370 SE net201 VSS nm1p2_svt_lp W=270.00n L=60.00n
MM46 net201 SI VSS VSS nm1p2_svt_lp W=270.00n L=60.00n
MM47 net0172 RN VSS VSS nm1p2_svt_lp W=350.00n L=60.00n
MM48 net0370 SEN net213 VSS nm1p2_svt_lp W=350.00n L=60.00n
MM49 net213 D net205 VSS nm1p2_svt_lp W=350.00n L=60.00n
MM43 SNN SN VSS VSS nm1p2_svt_lp W=290.00n L=60.00n
MM39 QN OS VSS VSS nm1p2_svt_lp W=430.00n L=60.00n
MM62 OS c net181 VSS nm1p2_svt_lp W=400.00n L=60.00n
MM63 net181 S VSS VSS nm1p2_svt_lp W=400.00n L=60.00n
MM61 M cn net193 VSS nm1p2_svt_lp W=260.00n L=60.00n
MM58 SEN SE VSS VSS nm1p2_svt_lp W=290.00n L=60.00n
MM70 net205 SN net0172 VSS nm1p2_svt_lp W=350.00n L=60.00n
MM60 net193 net0370 VSS VSS nm1p2_svt_lp W=260.00n L=60.00n
MM30 c cn VSS VSS nm1p2_svt_lp W=200.00n L=60.00n
MM27 cn CK VSS VSS nm1p2_svt_lp W=200.00n L=60.00n
MM24 net172 cn OS VSS nm1p2_svt_lp W=200.00n L=60.00n
MM23 VSS NET64 net172 VSS nm1p2_svt_lp W=200.00n L=60.00n
MM69 net213 SNN net0172 VSS nm1p2_svt_lp W=300.00n L=60.00n
MM19 Q NET64 VSS VSS nm1p2_svt_lp W=430.00n L=60.00n
MM17 NET64 OS VSS VSS nm1p2_svt_lp W=300.00n L=60.00n
MM12 net240 c M VSS nm1p2_svt_lp W=200.00n L=60.00n
MM11 VSS S net240 VSS nm1p2_svt_lp W=200.00n L=60.00n
MM0 S M VSS VSS nm1p2_svt_lp W=360.00n L=60.00n
MM66 net0418 SNN net296 VDD pm1p2_svt_lp W=590.00n L=60.00n
MM50 net288 SI VDD VDD pm1p2_svt_lp W=410.00n L=60.00n
MM51 net0370 SEN net288 VDD pm1p2_svt_lp W=410.00n L=60.00n
MM52 net296 D VDD VDD pm1p2_svt_lp W=590.00n L=60.00n
MM53 net0370 SE net0418 VDD pm1p2_svt_lp W=590.00n L=60.00n
MM44 SNN SN VDD VDD pm1p2_svt_lp W=440.00n L=60.00n
MM40 QN OS VDD VDD pm1p2_svt_lp W=650.00n L=60.00n
MM64 net268 S VDD VDD pm1p2_svt_lp W=480.00n L=60.00n
MM65 OS cn net268 VDD pm1p2_svt_lp W=480.00n L=60.00n
MM67 net0418 RN VDD VDD pm1p2_svt_lp W=400.00n L=60.00n
MM59 SEN SE VDD VDD pm1p2_svt_lp W=440.00n L=60.00n
MM29 c cn VDD VDD pm1p2_svt_lp W=300.00n L=60.00n
MM28 cn CK VDD VDD pm1p2_svt_lp W=300.00n L=60.00n
MM26 VDD NET64 net253 VDD pm1p2_svt_lp W=300.00n L=60.00n
MM25 net253 c OS VDD pm1p2_svt_lp W=300.00n L=60.00n
MM20 Q NET64 VDD VDD pm1p2_svt_lp W=650.00n L=60.00n
MM18 NET64 OS VDD VDD pm1p2_svt_lp W=450.00n L=60.00n
MM14 net313 cn M VDD pm1p2_svt_lp W=300.00n L=60.00n
MM13 VDD S net313 VDD pm1p2_svt_lp W=300.00n L=60.00n
MM55 net280 net0370 VDD VDD pm1p2_svt_lp W=390.00n L=60.00n
MM56 M c net280 VDD pm1p2_svt_lp W=390.00n L=60.00n
MM1 S M VDD VDD pm1p2_svt_lp W=540.00n L=60.00n
.ENDS

.SUBCKT SDFFTRS4H9R CK D Q QN RN SE SI SN VDD VSS
MM45 net0370 SE net201 VSS nm1p2_svt_lp W=300.00n L=60.00n
MM46 net201 SI VSS VSS nm1p2_svt_lp W=300.00n L=60.00n
MM47 net0172 RN VSS VSS nm1p2_svt_lp W=350.00n L=60.00n
MM48 net0370 SEN net213 VSS nm1p2_svt_lp W=350.00n L=60.00n
MM49 net213 D net205 VSS nm1p2_svt_lp W=350.00n L=60.00n
MM43 SNN SN VSS VSS nm1p2_svt_lp W=290.00n L=60.00n
MM39 QN OS VSS VSS nm1p2_svt_lp W=860.00n L=60.00n
MM62 OS c net181 VSS nm1p2_svt_lp W=450.00n L=60.00n
MM63 net181 S VSS VSS nm1p2_svt_lp W=450.00n L=60.00n
MM61 M cn net193 VSS nm1p2_svt_lp W=260.00n L=60.00n
MM58 SEN SE VSS VSS nm1p2_svt_lp W=290.00n L=60.00n
MM70 net205 SN net0172 VSS nm1p2_svt_lp W=350.00n L=60.00n
MM60 net193 net0370 VSS VSS nm1p2_svt_lp W=260.00n L=60.00n
MM30 c cn VSS VSS nm1p2_svt_lp W=260.00n L=60.00n
MM27 cn CK VSS VSS nm1p2_svt_lp W=200.00n L=60.00n
MM24 net172 cn OS VSS nm1p2_svt_lp W=200.00n L=60.00n
MM23 VSS NET64 net172 VSS nm1p2_svt_lp W=200.00n L=60.00n
MM69 net213 SNN net0172 VSS nm1p2_svt_lp W=300.00n L=60.00n
MM19 Q NET64 VSS VSS nm1p2_svt_lp W=860.00n L=60.00n
MM17 NET64 OS VSS VSS nm1p2_svt_lp W=360.00n L=60.00n
MM12 net240 c M VSS nm1p2_svt_lp W=200.00n L=60.00n
MM11 VSS S net240 VSS nm1p2_svt_lp W=200.00n L=60.00n
MM0 S M VSS VSS nm1p2_svt_lp W=360.00n L=60.00n
MM66 net0418 SNN net296 VDD pm1p2_svt_lp W=590.00n L=60.00n
MM50 net288 SI VDD VDD pm1p2_svt_lp W=450.00n L=60.00n
MM51 net0370 SEN net288 VDD pm1p2_svt_lp W=450.00n L=60.00n
MM52 net296 D VDD VDD pm1p2_svt_lp W=590.00n L=60.00n
MM53 net0370 SE net0418 VDD pm1p2_svt_lp W=590.00n L=60.00n
MM44 SNN SN VDD VDD pm1p2_svt_lp W=440.00n L=60.00n
MM40 QN OS VDD VDD pm1p2_svt_lp W=1.3u L=60.00n
MM64 net268 S VDD VDD pm1p2_svt_lp W=570.00n L=60.00n
MM65 OS cn net268 VDD pm1p2_svt_lp W=570.00n L=60.00n
MM67 net0418 RN VDD VDD pm1p2_svt_lp W=400.00n L=60.00n
MM59 SEN SE VDD VDD pm1p2_svt_lp W=440.00n L=60.00n
MM29 c cn VDD VDD pm1p2_svt_lp W=390.00n L=60.00n
MM28 cn CK VDD VDD pm1p2_svt_lp W=300.00n L=60.00n
MM26 VDD NET64 net253 VDD pm1p2_svt_lp W=300.00n L=60.00n
MM25 net253 c OS VDD pm1p2_svt_lp W=300.00n L=60.00n
MM20 Q NET64 VDD VDD pm1p2_svt_lp W=1.3u L=60.00n
MM18 NET64 OS VDD VDD pm1p2_svt_lp W=540.00n L=60.00n
MM14 net313 cn M VDD pm1p2_svt_lp W=300.00n L=60.00n
MM13 VDD S net313 VDD pm1p2_svt_lp W=300.00n L=60.00n
MM55 net280 net0370 VDD VDD pm1p2_svt_lp W=390.00n L=60.00n
MM56 M c net280 VDD pm1p2_svt_lp W=390.00n L=60.00n
MM1 S M VDD VDD pm1p2_svt_lp W=540.00n L=60.00n
.ENDS

.SUBCKT ESDFFX1H9R CK D E Q QN SE SI VDD VSS
MM39 ps c net_0155 VSS nm1p2_svt_lp W=300.00n L=60.00n
MM65 net_0155 m VSS VSS nm1p2_svt_lp W=300.00n L=60.00n
MM68 QN s VSS VSS nm1p2_svt_lp W=290.00n L=60.00n
MM60 sen SE VSS VSS nm1p2_svt_lp W=200.00n L=60.00n
MM46 net_0152 SI VSS VSS nm1p2_svt_lp W=200.00n L=60.00n
MM45 net0171 SE net_0152 VSS nm1p2_svt_lp W=200.00n L=60.00n
MM40 net0171 s net_0149 VSS nm1p2_svt_lp W=420.00n L=60.00n
MM41 net_0149 en net_0164 VSS nm1p2_svt_lp W=420.00n L=60.00n
MM58 net_0164 sen VSS VSS nm1p2_svt_lp W=420.00n L=60.00n
MM63 pm cn net0171 VSS nm1p2_svt_lp W=400.00n L=60.00n
MM31 en E VSS VSS nm1p2_svt_lp W=200.00n L=60.00n
MM30 c cn VSS VSS nm1p2_svt_lp W=300.00n L=60.00n
MM27 cn CK VSS VSS nm1p2_svt_lp W=200.00n L=60.00n
MM24 net48 cn ps VSS nm1p2_svt_lp W=200.00n L=60.00n
MM23 VSS s net48 VSS nm1p2_svt_lp W=200.00n L=60.00n
MM22 Q ps VSS VSS nm1p2_svt_lp W=290.00n L=60.00n
MM17 s ps VSS VSS nm1p2_svt_lp W=300.00n L=60.00n
MM12 net52 c pm VSS nm1p2_svt_lp W=200.00n L=60.00n
MM11 VSS m net52 VSS nm1p2_svt_lp W=200.00n L=60.00n
MM9 net0171 D net69 VSS nm1p2_svt_lp W=420.00n L=60.00n
MM7 net69 E net_0164 VSS nm1p2_svt_lp W=420.00n L=60.00n
MM0 m pm VSS VSS nm1p2_svt_lp W=400.00n L=60.00n
MM66 ps cn net_0153 VDD pm1p2_svt_lp W=300.00n L=60.00n
MM67 net_0153 m VDD VDD pm1p2_svt_lp W=300.00n L=60.00n
MM64 pm c net_0157 VDD pm1p2_svt_lp W=570.00n L=60.00n
MM69 QN s VDD VDD pm1p2_svt_lp W=440.00n L=60.00n
MM53 net0267 SE VDD VDD pm1p2_svt_lp W=500.00n L=60.00n
MM61 sen SE VDD VDD pm1p2_svt_lp W=300.00n L=60.00n
MM51 net_0157 sen net_0247 VDD pm1p2_svt_lp W=300.00n L=60.00n
MM50 net_0247 SI VDD VDD pm1p2_svt_lp W=300.00n L=60.00n
MM37 net_0157 s net_0228 VDD pm1p2_svt_lp W=500.00n L=60.00n
MM38 net_0228 E net0267 VDD pm1p2_svt_lp W=500.00n L=60.00n
MM32 en E VDD VDD pm1p2_svt_lp W=300.00n L=60.00n
MM29 c cn VDD VDD pm1p2_svt_lp W=450.00n L=60.00n
MM28 cn CK VDD VDD pm1p2_svt_lp W=300.00n L=60.00n
MM26 VDD s net109 VDD pm1p2_svt_lp W=300.00n L=60.00n
MM25 net109 c ps VDD pm1p2_svt_lp W=300.00n L=60.00n
MM21 Q ps VDD VDD pm1p2_svt_lp W=440.00n L=60.00n
MM18 s ps VDD VDD pm1p2_svt_lp W=420.00n L=60.00n
MM14 net117 cn pm VDD pm1p2_svt_lp W=300.00n L=60.00n
MM13 VDD m net117 VDD pm1p2_svt_lp W=300.00n L=60.00n
MM10 net_0157 D net128 VDD pm1p2_svt_lp W=500.00n L=60.00n
MM8 net128 en net0267 VDD pm1p2_svt_lp W=500.00n L=60.00n
MM1 m pm VDD VDD pm1p2_svt_lp W=600.00n L=60.00n
.ENDS

.SUBCKT ESDFFX2H9R CK D E Q QN SE SI VDD VSS
MM39 ps c net_0155 VSS nm1p2_svt_lp W=400.00n L=60.00n
MM65 net_0155 m VSS VSS nm1p2_svt_lp W=400.00n L=60.00n
MM68 QN s VSS VSS nm1p2_svt_lp W=430.00n L=60.00n
MM60 sen SE VSS VSS nm1p2_svt_lp W=200.00n L=60.00n
MM46 net_0152 SI VSS VSS nm1p2_svt_lp W=200.00n L=60.00n
MM45 net0171 SE net_0152 VSS nm1p2_svt_lp W=200.00n L=60.00n
MM40 net0171 s net_0149 VSS nm1p2_svt_lp W=400.00n L=60.00n
MM41 net_0149 en net_0164 VSS nm1p2_svt_lp W=400.00n L=60.00n
MM58 net_0164 sen VSS VSS nm1p2_svt_lp W=400.00n L=60.00n
MM63 pm cn net0171 VSS nm1p2_svt_lp W=400.00n L=60.00n
MM31 en E VSS VSS nm1p2_svt_lp W=200.00n L=60.00n
MM30 c cn VSS VSS nm1p2_svt_lp W=300.00n L=60.00n
MM27 cn CK VSS VSS nm1p2_svt_lp W=200.00n L=60.00n
MM24 net48 cn ps VSS nm1p2_svt_lp W=200.00n L=60.00n
MM23 VSS s net48 VSS nm1p2_svt_lp W=200.00n L=60.00n
MM22 Q ps VSS VSS nm1p2_svt_lp W=430.00n L=60.00n
MM17 s ps VSS VSS nm1p2_svt_lp W=290.00n L=60.00n
MM12 net52 c pm VSS nm1p2_svt_lp W=200.00n L=60.00n
MM11 VSS m net52 VSS nm1p2_svt_lp W=200.00n L=60.00n
MM9 net0171 D net69 VSS nm1p2_svt_lp W=400.00n L=60.00n
MM7 net69 E net_0164 VSS nm1p2_svt_lp W=400.00n L=60.00n
MM0 m pm VSS VSS nm1p2_svt_lp W=430.00n L=60.00n
MM66 ps cn net_0153 VDD pm1p2_svt_lp W=400.00n L=60.00n
MM67 net_0153 m VDD VDD pm1p2_svt_lp W=400.00n L=60.00n
MM64 pm c net_0157 VDD pm1p2_svt_lp W=570.00n L=60.00n
MM69 QN s VDD VDD pm1p2_svt_lp W=650.00n L=60.00n
MM53 net0267 SE VDD VDD pm1p2_svt_lp W=570.00n L=60.00n
MM61 sen SE VDD VDD pm1p2_svt_lp W=300.00n L=60.00n
MM51 net_0157 sen net_0247 VDD pm1p2_svt_lp W=300.00n L=60.00n
MM50 net_0247 SI VDD VDD pm1p2_svt_lp W=300.00n L=60.00n
MM37 net_0157 s net_0228 VDD pm1p2_svt_lp W=570.00n L=60.00n
MM38 net_0228 E net0267 VDD pm1p2_svt_lp W=570.00n L=60.00n
MM32 en E VDD VDD pm1p2_svt_lp W=300.00n L=60.00n
MM29 c cn VDD VDD pm1p2_svt_lp W=450.00n L=60.00n
MM28 cn CK VDD VDD pm1p2_svt_lp W=300.00n L=60.00n
MM26 VDD s net109 VDD pm1p2_svt_lp W=300.00n L=60.00n
MM25 net109 c ps VDD pm1p2_svt_lp W=300.00n L=60.00n
MM21 Q ps VDD VDD pm1p2_svt_lp W=650.00n L=60.00n
MM18 s ps VDD VDD pm1p2_svt_lp W=420.00n L=60.00n
MM14 net117 cn pm VDD pm1p2_svt_lp W=300.00n L=60.00n
MM13 VDD m net117 VDD pm1p2_svt_lp W=300.00n L=60.00n
MM10 net_0157 D net128 VDD pm1p2_svt_lp W=570.00n L=60.00n
MM8 net128 en net0267 VDD pm1p2_svt_lp W=570.00n L=60.00n
MM1 m pm VDD VDD pm1p2_svt_lp W=650.00n L=60.00n
.ENDS

.SUBCKT ESDFFX4H9R CK D E Q QN SE SI VDD VSS
MM39 ps c net_0155 VSS nm1p2_svt_lp W=400.00n L=60.00n
MM65 net_0155 m VSS VSS nm1p2_svt_lp W=400.00n L=60.00n
MM68 QN s VSS VSS nm1p2_svt_lp W=860.00n L=60.00n
MM60 sen SE VSS VSS nm1p2_svt_lp W=200.00n L=60.00n
MM46 net_0152 SI VSS VSS nm1p2_svt_lp W=200.00n L=60.00n
MM45 net0171 SE net_0152 VSS nm1p2_svt_lp W=200.00n L=60.00n
MM40 net0171 s net_0149 VSS nm1p2_svt_lp W=400.00n L=60.00n
MM41 net_0149 en net_0164 VSS nm1p2_svt_lp W=400.00n L=60.00n
MM58 net_0164 sen VSS VSS nm1p2_svt_lp W=400.00n L=60.00n
MM63 pm cn net0171 VSS nm1p2_svt_lp W=400.00n L=60.00n
MM31 en E VSS VSS nm1p2_svt_lp W=200.00n L=60.00n
MM30 c cn VSS VSS nm1p2_svt_lp W=300.00n L=60.00n
MM27 cn CK VSS VSS nm1p2_svt_lp W=200.00n L=60.00n
MM24 net48 cn ps VSS nm1p2_svt_lp W=200.00n L=60.00n
MM23 VSS s net48 VSS nm1p2_svt_lp W=200.00n L=60.00n
MM22 Q ps VSS VSS nm1p2_svt_lp W=860.00n L=60.00n
MM17 s ps VSS VSS nm1p2_svt_lp W=390.00n L=60.00n
MM12 net52 c pm VSS nm1p2_svt_lp W=200.00n L=60.00n
MM11 VSS m net52 VSS nm1p2_svt_lp W=200.00n L=60.00n
MM9 net0171 D net69 VSS nm1p2_svt_lp W=400.00n L=60.00n
MM7 net69 E net_0164 VSS nm1p2_svt_lp W=400.00n L=60.00n
MM0 m pm VSS VSS nm1p2_svt_lp W=430.00n L=60.00n
MM66 ps cn net_0153 VDD pm1p2_svt_lp W=440.00n L=60.00n
MM67 net_0153 m VDD VDD pm1p2_svt_lp W=440.00n L=60.00n
MM64 pm c net_0157 VDD pm1p2_svt_lp W=570.00n L=60.00n
MM69 QN s VDD VDD pm1p2_svt_lp W=1.3u L=60.00n
MM53 net0267 SE VDD VDD pm1p2_svt_lp W=570.00n L=60.00n
MM61 sen SE VDD VDD pm1p2_svt_lp W=300.00n L=60.00n
MM51 net_0157 sen net_0247 VDD pm1p2_svt_lp W=300.00n L=60.00n
MM50 net_0247 SI VDD VDD pm1p2_svt_lp W=300.00n L=60.00n
MM37 net_0157 s net_0228 VDD pm1p2_svt_lp W=570.00n L=60.00n
MM38 net_0228 E net0267 VDD pm1p2_svt_lp W=570.00n L=60.00n
MM32 en E VDD VDD pm1p2_svt_lp W=300.00n L=60.00n
MM29 c cn VDD VDD pm1p2_svt_lp W=450.00n L=60.00n
MM28 cn CK VDD VDD pm1p2_svt_lp W=300.00n L=60.00n
MM26 VDD s net109 VDD pm1p2_svt_lp W=300.00n L=60.00n
MM25 net109 c ps VDD pm1p2_svt_lp W=300.00n L=60.00n
MM21 Q ps VDD VDD pm1p2_svt_lp W=1.3u L=60.00n
MM18 s ps VDD VDD pm1p2_svt_lp W=500.00n L=60.00n
MM14 net117 cn pm VDD pm1p2_svt_lp W=300.00n L=60.00n
MM13 VDD m net117 VDD pm1p2_svt_lp W=300.00n L=60.00n
MM10 net_0157 D net128 VDD pm1p2_svt_lp W=570.00n L=60.00n
MM8 net128 en net0267 VDD pm1p2_svt_lp W=570.00n L=60.00n
MM1 m pm VDD VDD pm1p2_svt_lp W=650.00n L=60.00n
.ENDS

.SUBCKT ESDFFRX1H9R CK D E Q QN RDN SE SI VDD VSS
MM39 ps c net_0155 VSS nm1p2_svt_lp W=390.00n L=60.00n
MM65 net_0155 m VSS VSS nm1p2_svt_lp W=390.00n L=60.00n
MM68 net0157 RDN VSS VSS nm1p2_svt_lp W=310.00n L=60.00n
MM73 QN s VSS VSS nm1p2_svt_lp W=290.00n L=60.00n
MM60 sen SE VSS VSS nm1p2_svt_lp W=200.00n L=60.00n
MM70 VSS RDN net0183 VSS nm1p2_svt_lp W=200.00n L=60.00n
MM46 net_0152 SE net0157 VSS nm1p2_svt_lp W=250.00n L=60.00n
MM45 net0171 SI net_0152 VSS nm1p2_svt_lp W=250.00n L=60.00n
MM40 net0171 s net_0149 VSS nm1p2_svt_lp W=310.00n L=60.00n
MM41 net_0149 en net_0164 VSS nm1p2_svt_lp W=310.00n L=60.00n
MM71 VSS RDN net0163 VSS nm1p2_svt_lp W=200.00n L=60.00n
MM58 net_0164 sen net0157 VSS nm1p2_svt_lp W=275.00n L=60.00n
MM63 pm cn net0171 VSS nm1p2_svt_lp W=430.00n L=60.00n
MM31 en E VSS VSS nm1p2_svt_lp W=200.00n L=60.00n
MM30 c cn VSS VSS nm1p2_svt_lp W=250.00n L=60.00n
MM27 cn CK VSS VSS nm1p2_svt_lp W=200.00n L=60.00n
MM24 net48 cn ps VSS nm1p2_svt_lp W=200.00n L=60.00n
MM23 net0163 s net48 VSS nm1p2_svt_lp W=200.00n L=60.00n
MM22 Q ps VSS VSS nm1p2_svt_lp W=290.00n L=60.00n
MM17 s ps VSS VSS nm1p2_svt_lp W=240.00n L=60.00n
MM12 net52 c pm VSS nm1p2_svt_lp W=200.00n L=60.00n
MM11 net0183 m net52 VSS nm1p2_svt_lp W=200.00n L=60.00n
MM9 net0171 D net69 VSS nm1p2_svt_lp W=310.00n L=60.00n
MM7 net69 E net_0164 VSS nm1p2_svt_lp W=310.00n L=60.00n
MM0 m pm VSS VSS nm1p2_svt_lp W=270.00n L=60.00n
MM66 ps cn net_0153 VDD pm1p2_svt_lp W=415.00n L=60.00n
MM67 net_0153 m VDD VDD pm1p2_svt_lp W=415.00n L=60.00n
MM64 pm c net_0157 VDD pm1p2_svt_lp W=520.00n L=60.00n
MM74 QN s VDD VDD pm1p2_svt_lp W=440.00n L=60.00n
MM53 net0267 SE VDD VDD pm1p2_svt_lp W=355.00n L=60.00n
MM61 sen SE VDD VDD pm1p2_svt_lp W=300.00n L=60.00n
MM51 net_0157 SI net_0247 VDD pm1p2_svt_lp W=300.00n L=60.00n
MM50 net_0247 sen VDD VDD pm1p2_svt_lp W=300.00n L=60.00n
MM37 net_0157 s net_0228 VDD pm1p2_svt_lp W=390.00n L=60.00n
MM38 net_0228 E net0267 VDD pm1p2_svt_lp W=390.00n L=60.00n
MM69 pm RDN VDD VDD pm1p2_svt_lp W=300.0n L=60.00n
MM72 ps RDN VDD VDD pm1p2_svt_lp W=300.0n L=60.00n
MM32 en E VDD VDD pm1p2_svt_lp W=300.00n L=60.00n
MM29 c cn VDD VDD pm1p2_svt_lp W=380.00n L=60.00n
MM28 cn CK VDD VDD pm1p2_svt_lp W=300.00n L=60.00n
MM26 VDD s net109 VDD pm1p2_svt_lp W=300.00n L=60.00n
MM25 net109 c ps VDD pm1p2_svt_lp W=300.00n L=60.00n
MM21 Q ps VDD VDD pm1p2_svt_lp W=440.00n L=60.00n
MM18 s ps VDD VDD pm1p2_svt_lp W=360.00n L=60.00n
MM14 net117 cn pm VDD pm1p2_svt_lp W=300.00n L=60.00n
MM13 VDD m net117 VDD pm1p2_svt_lp W=300.00n L=60.00n
MM10 net_0157 D net128 VDD pm1p2_svt_lp W=390.00n L=60.00n
MM8 net128 en net0267 VDD pm1p2_svt_lp W=390.00n L=60.00n
MM1 m pm VDD VDD pm1p2_svt_lp W=400.00n L=60.00n
.ENDS

.SUBCKT ESDFFRX2H9R CK D E Q QN RDN SE SI VDD VSS
MM39 ps c net_0155 VSS nm1p2_svt_lp W=390.00n L=60.00n
MM65 net_0155 m VSS VSS nm1p2_svt_lp W=390.00n L=60.00n
MM68 net0157 RDN VSS VSS nm1p2_svt_lp W=310.00n L=60.00n
MM73 QN s VSS VSS nm1p2_svt_lp W=430.00n L=60.00n
MM60 sen SE VSS VSS nm1p2_svt_lp W=200.00n L=60.00n
MM70 VSS RDN net0183 VSS nm1p2_svt_lp W=200.00n L=60.00n
MM46 net_0152 SE net0157 VSS nm1p2_svt_lp W=250.00n L=60.00n
MM45 net0171 SI net_0152 VSS nm1p2_svt_lp W=250.00n L=60.00n
MM40 net0171 s net_0149 VSS nm1p2_svt_lp W=310.00n L=60.00n
MM41 net_0149 en net_0164 VSS nm1p2_svt_lp W=310.00n L=60.00n
MM71 VSS RDN net0163 VSS nm1p2_svt_lp W=200.00n L=60.00n
MM58 net_0164 sen net0157 VSS nm1p2_svt_lp W=275.00n L=60.00n
MM63 pm cn net0171 VSS nm1p2_svt_lp W=430.00n L=60.00n
MM31 en E VSS VSS nm1p2_svt_lp W=200.00n L=60.00n
MM30 c cn VSS VSS nm1p2_svt_lp W=290.00n L=60.00n
MM27 cn CK VSS VSS nm1p2_svt_lp W=200.00n L=60.00n
MM24 net48 cn ps VSS nm1p2_svt_lp W=200.00n L=60.00n
MM23 net0163 s net48 VSS nm1p2_svt_lp W=200.00n L=60.00n
MM22 Q ps VSS VSS nm1p2_svt_lp W=430.00n L=60.00n
MM17 s ps VSS VSS nm1p2_svt_lp W=290.00n L=60.00n
MM12 net52 c pm VSS nm1p2_svt_lp W=200.00n L=60.00n
MM11 net0183 m net52 VSS nm1p2_svt_lp W=200.00n L=60.00n
MM9 net0171 D net69 VSS nm1p2_svt_lp W=310.00n L=60.00n
MM7 net69 E net_0164 VSS nm1p2_svt_lp W=310.00n L=60.00n
MM0 m pm VSS VSS nm1p2_svt_lp W=360.00n L=60.00n
MM66 ps cn net_0153 VDD pm1p2_svt_lp W=415.00n L=60.00n
MM67 net_0153 m VDD VDD pm1p2_svt_lp W=415.00n L=60.00n
MM64 pm c net_0157 VDD pm1p2_svt_lp W=520.00n L=60.00n
MM74 QN s VDD VDD pm1p2_svt_lp W=650.00n L=60.00n
MM53 net0267 SE VDD VDD pm1p2_svt_lp W=355.00n L=60.00n
MM61 sen SE VDD VDD pm1p2_svt_lp W=300.00n L=60.00n
MM51 net_0157 SI net_0247 VDD pm1p2_svt_lp W=300.00n L=60.00n
MM50 net_0247 sen VDD VDD pm1p2_svt_lp W=300.00n L=60.00n
MM37 net_0157 s net_0228 VDD pm1p2_svt_lp W=390.00n L=60.00n
MM38 net_0228 E net0267 VDD pm1p2_svt_lp W=390.00n L=60.00n
MM69 pm RDN VDD VDD pm1p2_svt_lp W=300.0n L=60.00n
MM72 ps RDN VDD VDD pm1p2_svt_lp W=300.0n L=60.00n
MM32 en E VDD VDD pm1p2_svt_lp W=300.00n L=60.00n
MM29 c cn VDD VDD pm1p2_svt_lp W=440.00n L=60.00n
MM28 cn CK VDD VDD pm1p2_svt_lp W=300.00n L=60.00n
MM26 VDD s net109 VDD pm1p2_svt_lp W=300.00n L=60.00n
MM25 net109 c ps VDD pm1p2_svt_lp W=300.00n L=60.00n
MM21 Q ps VDD VDD pm1p2_svt_lp W=650.00n L=60.00n
MM18 s ps VDD VDD pm1p2_svt_lp W=440.00n L=60.00n
MM14 net117 cn pm VDD pm1p2_svt_lp W=300.00n L=60.00n
MM13 VDD m net117 VDD pm1p2_svt_lp W=300.00n L=60.00n
MM10 net_0157 D net128 VDD pm1p2_svt_lp W=390.00n L=60.00n
MM8 net128 en net0267 VDD pm1p2_svt_lp W=390.00n L=60.00n
MM1 m pm VDD VDD pm1p2_svt_lp W=540.00n L=60.00n
.ENDS

.SUBCKT ESDFFRX4H9R CK D E Q QN RDN SE SI VDD VSS
MM39 ps c net_0155 VSS nm1p2_svt_lp W=360.00n L=60.00n
MM65 net_0155 m VSS VSS nm1p2_svt_lp W=360.00n L=60.00n
MM68 net0157 RDN VSS VSS nm1p2_svt_lp W=310.00n L=60.00n
MM73 QN s VSS VSS nm1p2_svt_lp W=860.00n L=60.00n
MM60 sen SE VSS VSS nm1p2_svt_lp W=200.00n L=60.00n
MM70 VSS RDN net0183 VSS nm1p2_svt_lp W=200.00n L=60.00n
MM46 net_0152 SE net0157 VSS nm1p2_svt_lp W=250.00n L=60.00n
MM45 net0171 SI net_0152 VSS nm1p2_svt_lp W=250.00n L=60.00n
MM40 net0171 s net_0149 VSS nm1p2_svt_lp W=310.00n L=60.00n
MM41 net_0149 en net_0164 VSS nm1p2_svt_lp W=310.00n L=60.00n
MM71 VSS RDN net0163 VSS nm1p2_svt_lp W=200.00n L=60.00n
MM58 net_0164 sen net0157 VSS nm1p2_svt_lp W=275.00n L=60.00n
MM63 pm cn net0171 VSS nm1p2_svt_lp W=430.00n L=60.00n
MM31 en E VSS VSS nm1p2_svt_lp W=200.00n L=60.00n
MM30 c cn VSS VSS nm1p2_svt_lp W=400.00n L=60.00n
MM27 cn CK VSS VSS nm1p2_svt_lp W=290.00n L=60.00n
MM24 net48 cn ps VSS nm1p2_svt_lp W=200.00n L=60.00n
MM23 net0163 s net48 VSS nm1p2_svt_lp W=200.00n L=60.00n
MM22 Q ps VSS VSS nm1p2_svt_lp W=860.00n L=60.00n
MM17 s ps VSS VSS nm1p2_svt_lp W=360.00n L=60.00n
MM12 net52 c pm VSS nm1p2_svt_lp W=200.00n L=60.00n
MM11 net0183 m net52 VSS nm1p2_svt_lp W=200.00n L=60.00n
MM9 net0171 D net69 VSS nm1p2_svt_lp W=310.00n L=60.00n
MM7 net69 E net_0164 VSS nm1p2_svt_lp W=310.00n L=60.00n
MM0 m pm VSS VSS nm1p2_svt_lp W=400.00n L=60.00n
MM66 ps cn net_0153 VDD pm1p2_svt_lp W=470.00n L=60.00n
MM67 net_0153 m VDD VDD pm1p2_svt_lp W=470.00n L=60.00n
MM64 pm c net_0157 VDD pm1p2_svt_lp W=520.00n L=60.00n
MM74 QN s VDD VDD pm1p2_svt_lp W=1.3u L=60.00n
MM53 net0267 SE VDD VDD pm1p2_svt_lp W=355.00n L=60.00n
MM61 sen SE VDD VDD pm1p2_svt_lp W=300.00n L=60.00n
MM51 net_0157 SI net_0247 VDD pm1p2_svt_lp W=300.00n L=60.00n
MM50 net_0247 sen VDD VDD pm1p2_svt_lp W=300.00n L=60.00n
MM37 net_0157 s net_0228 VDD pm1p2_svt_lp W=390.00n L=60.00n
MM38 net_0228 E net0267 VDD pm1p2_svt_lp W=390.00n L=60.00n
MM69 pm RDN VDD VDD pm1p2_svt_lp W=300.0n L=60.00n
MM72 ps RDN VDD VDD pm1p2_svt_lp W=300.0n L=60.00n
MM32 en E VDD VDD pm1p2_svt_lp W=300.00n L=60.00n
MM29 c cn VDD VDD pm1p2_svt_lp W=650.00n L=60.00n
MM28 cn CK VDD VDD pm1p2_svt_lp W=440.00n L=60.00n
MM26 VDD s net109 VDD pm1p2_svt_lp W=300.00n L=60.00n
MM25 net109 c ps VDD pm1p2_svt_lp W=300.00n L=60.00n
MM21 Q ps VDD VDD pm1p2_svt_lp W=1.3u L=60.00n
MM18 s ps VDD VDD pm1p2_svt_lp W=540.00n L=60.00n
MM14 net117 cn pm VDD pm1p2_svt_lp W=300.00n L=60.00n
MM13 VDD m net117 VDD pm1p2_svt_lp W=300.00n L=60.00n
MM10 net_0157 D net128 VDD pm1p2_svt_lp W=390.00n L=60.00n
MM8 net128 en net0267 VDD pm1p2_svt_lp W=390.00n L=60.00n
MM1 m pm VDD VDD pm1p2_svt_lp W=600.00n L=60.00n
.ENDS

.SUBCKT ESDFFRQX1H9R CK D E Q RDN SE SI VDD VSS
MM39 ps c net_0155 VSS nm1p2_svt_lp W=390.00n L=60.00n
MM65 net_0155 m VSS VSS nm1p2_svt_lp W=390.00n L=60.00n
MM68 net0157 RDN VSS VSS nm1p2_svt_lp W=310.00n L=60.00n
MM60 sen SE VSS VSS nm1p2_svt_lp W=200.00n L=60.00n
MM70 VSS RDN net0183 VSS nm1p2_svt_lp W=200.00n L=60.00n
MM46 net_0152 SE net0157 VSS nm1p2_svt_lp W=240.00n L=60.00n
MM45 net0171 SI net_0152 VSS nm1p2_svt_lp W=240.00n L=60.00n
MM40 net0171 s net_0149 VSS nm1p2_svt_lp W=310.00n L=60.00n
MM41 net_0149 en net_0164 VSS nm1p2_svt_lp W=310.00n L=60.00n
MM71 VSS RDN net0163 VSS nm1p2_svt_lp W=200.00n L=60.00n
MM58 net_0164 sen net0157 VSS nm1p2_svt_lp W=300.00n L=60.00n
MM63 pm cn net0171 VSS nm1p2_svt_lp W=400.00n L=60.00n
MM31 en E VSS VSS nm1p2_svt_lp W=200.00n L=60.00n
MM30 c cn VSS VSS nm1p2_svt_lp W=300.00n L=60.00n
MM27 cn CK VSS VSS nm1p2_svt_lp W=200.00n L=60.00n
MM24 net48 cn ps VSS nm1p2_svt_lp W=200.00n L=60.00n
MM23 net0163 s net48 VSS nm1p2_svt_lp W=200.00n L=60.00n
MM22 Q ps VSS VSS nm1p2_svt_lp W=290.00n L=60.00n
MM17 s ps VSS VSS nm1p2_svt_lp W=200.00n L=60.00n
MM12 net52 c pm VSS nm1p2_svt_lp W=200.00n L=60.00n
MM11 net0183 m net52 VSS nm1p2_svt_lp W=200.00n L=60.00n
MM9 net0171 D net69 VSS nm1p2_svt_lp W=310.00n L=60.00n
MM7 net69 E net_0164 VSS nm1p2_svt_lp W=310.00n L=60.00n
MM0 m pm VSS VSS nm1p2_svt_lp W=430.00n L=60.00n
MM66 ps cn net_0153 VDD pm1p2_svt_lp W=385.00n L=60.00n
MM67 net_0153 m VDD VDD pm1p2_svt_lp W=385.00n L=60.00n
MM64 pm c net_0157 VDD pm1p2_svt_lp W=520.00n L=60.00n
MM53 net0267 SE VDD VDD pm1p2_svt_lp W=370.00n L=60.00n
MM61 sen SE VDD VDD pm1p2_svt_lp W=300.00n L=60.00n
MM51 net_0157 SI net_0247 VDD pm1p2_svt_lp W=300.00n L=60.00n
MM50 net_0247 sen VDD VDD pm1p2_svt_lp W=300.00n L=60.00n
MM37 net_0157 s net_0228 VDD pm1p2_svt_lp W=380.00n L=60.00n
MM38 net_0228 E net0267 VDD pm1p2_svt_lp W=380.00n L=60.00n
MM69 pm RDN VDD VDD pm1p2_svt_lp W=300.0n L=60.00n
MM72 ps RDN VDD VDD pm1p2_svt_lp W=300.0n L=60.00n
MM32 en E VDD VDD pm1p2_svt_lp W=300.00n L=60.00n
MM29 c cn VDD VDD pm1p2_svt_lp W=450.00n L=60.00n
MM28 cn CK VDD VDD pm1p2_svt_lp W=300.00n L=60.00n
MM26 VDD s net109 VDD pm1p2_svt_lp W=300.00n L=60.00n
MM25 net109 c ps VDD pm1p2_svt_lp W=300.00n L=60.00n
MM21 Q ps VDD VDD pm1p2_svt_lp W=440.00n L=60.00n
MM18 s ps VDD VDD pm1p2_svt_lp W=300.00n L=60.00n
MM14 net117 cn pm VDD pm1p2_svt_lp W=300.00n L=60.00n
MM13 VDD m net117 VDD pm1p2_svt_lp W=300.00n L=60.00n
MM10 net_0157 D net128 VDD pm1p2_svt_lp W=390.00n L=60.00n
MM8 net128 en net0267 VDD pm1p2_svt_lp W=390.00n L=60.00n
MM1 m pm VDD VDD pm1p2_svt_lp W=650.00n L=60.00n
.ENDS

.SUBCKT ESDFFRQX2H9R CK D E Q RDN SE SI VDD VSS
MM39 ps c net_0155 VSS nm1p2_svt_lp W=390.00n L=60.00n
MM65 net_0155 m VSS VSS nm1p2_svt_lp W=400.00n L=60.00n
MM68 net0157 RDN VSS VSS nm1p2_svt_lp W=310.00n L=60.00n
MM60 sen SE VSS VSS nm1p2_svt_lp W=200.00n L=60.00n
MM70 VSS RDN net0183 VSS nm1p2_svt_lp W=200.00n L=60.00n
MM46 net_0152 SE net0157 VSS nm1p2_svt_lp W=240.00n L=60.00n
MM45 net0171 SI net_0152 VSS nm1p2_svt_lp W=240.00n L=60.00n
MM40 net0171 s net_0149 VSS nm1p2_svt_lp W=310.00n L=60.00n
MM41 net_0149 en net_0164 VSS nm1p2_svt_lp W=310.00n L=60.00n
MM71 VSS RDN net0163 VSS nm1p2_svt_lp W=200.00n L=60.00n
MM58 net_0164 sen net0157 VSS nm1p2_svt_lp W=290.00n L=60.00n
MM63 pm cn net0171 VSS nm1p2_svt_lp W=400.00n L=60.00n
MM31 en E VSS VSS nm1p2_svt_lp W=200.00n L=60.00n
MM30 c cn VSS VSS nm1p2_svt_lp W=300.00n L=60.00n
MM27 cn CK VSS VSS nm1p2_svt_lp W=200.00n L=60.00n
MM24 net48 cn ps VSS nm1p2_svt_lp W=200.00n L=60.00n
MM23 net0163 s net48 VSS nm1p2_svt_lp W=200.00n L=60.00n
MM22 Q ps VSS VSS nm1p2_svt_lp W=430.00n L=60.00n
MM17 s ps VSS VSS nm1p2_svt_lp W=200.00n L=60.00n
MM12 net52 c pm VSS nm1p2_svt_lp W=200.00n L=60.00n
MM11 net0183 m net52 VSS nm1p2_svt_lp W=200.00n L=60.00n
MM9 net0171 D net69 VSS nm1p2_svt_lp W=310.00n L=60.00n
MM7 net69 E net_0164 VSS nm1p2_svt_lp W=310.00n L=60.00n
MM0 m pm VSS VSS nm1p2_svt_lp W=430.00n L=60.00n
MM66 ps cn net_0153 VDD pm1p2_svt_lp W=415.00n L=60.00n
MM67 net_0153 m VDD VDD pm1p2_svt_lp W=415.00n L=60.00n
MM64 pm c net_0157 VDD pm1p2_svt_lp W=520.00n L=60.00n
MM53 net0267 SE VDD VDD pm1p2_svt_lp W=380.00n L=60.00n
MM61 sen SE VDD VDD pm1p2_svt_lp W=300.00n L=60.00n
MM51 net_0157 SI net_0247 VDD pm1p2_svt_lp W=300.00n L=60.00n
MM50 net_0247 sen VDD VDD pm1p2_svt_lp W=300.00n L=60.00n
MM37 net_0157 s net_0228 VDD pm1p2_svt_lp W=380.00n L=60.00n
MM38 net_0228 E net0267 VDD pm1p2_svt_lp W=380.00n L=60.00n
MM69 pm RDN VDD VDD pm1p2_svt_lp W=300.0n L=60.00n
MM72 ps RDN VDD VDD pm1p2_svt_lp W=300.0n L=60.00n
MM32 en E VDD VDD pm1p2_svt_lp W=300.00n L=60.00n
MM29 c cn VDD VDD pm1p2_svt_lp W=450.00n L=60.00n
MM28 cn CK VDD VDD pm1p2_svt_lp W=300.00n L=60.00n
MM26 VDD s net109 VDD pm1p2_svt_lp W=300.00n L=60.00n
MM25 net109 c ps VDD pm1p2_svt_lp W=300.00n L=60.00n
MM21 Q ps VDD VDD pm1p2_svt_lp W=650.00n L=60.00n
MM18 s ps VDD VDD pm1p2_svt_lp W=300.00n L=60.00n
MM14 net117 cn pm VDD pm1p2_svt_lp W=300.00n L=60.00n
MM13 VDD m net117 VDD pm1p2_svt_lp W=300.00n L=60.00n
MM10 net_0157 D net128 VDD pm1p2_svt_lp W=390.00n L=60.00n
MM8 net128 en net0267 VDD pm1p2_svt_lp W=390.00n L=60.00n
MM1 m pm VDD VDD pm1p2_svt_lp W=650.00n L=60.00n
.ENDS

.SUBCKT ESDFFRQX4H9R CK D E Q RDN SE SI VDD VSS
MM39 ps c net_0155 VSS nm1p2_svt_lp W=390.00n L=60.00n
MM65 net_0155 m VSS VSS nm1p2_svt_lp W=400.00n L=60.00n
MM68 net0157 RDN VSS VSS nm1p2_svt_lp W=310.00n L=60.00n
MM60 sen SE VSS VSS nm1p2_svt_lp W=200.00n L=60.00n
MM70 VSS RDN net0183 VSS nm1p2_svt_lp W=200.00n L=60.00n
MM46 net_0152 SE net0157 VSS nm1p2_svt_lp W=240.00n L=60.00n
MM45 net0171 SI net_0152 VSS nm1p2_svt_lp W=240.00n L=60.00n
MM40 net0171 s net_0149 VSS nm1p2_svt_lp W=310.00n L=60.00n
MM41 net_0149 en net_0164 VSS nm1p2_svt_lp W=310.00n L=60.00n
MM71 VSS RDN net0163 VSS nm1p2_svt_lp W=200.00n L=60.00n
MM58 net_0164 sen net0157 VSS nm1p2_svt_lp W=300.00n L=60.00n
MM63 pm cn net0171 VSS nm1p2_svt_lp W=400.00n L=60.00n
MM31 en E VSS VSS nm1p2_svt_lp W=200.00n L=60.00n
MM30 c cn VSS VSS nm1p2_svt_lp W=300.00n L=60.00n
MM27 cn CK VSS VSS nm1p2_svt_lp W=200.00n L=60.00n
MM24 net48 cn ps VSS nm1p2_svt_lp W=200.00n L=60.00n
MM23 net0163 s net48 VSS nm1p2_svt_lp W=200.00n L=60.00n
MM22 Q ps VSS VSS nm1p2_svt_lp W=860.00n L=60.00n
MM17 s ps VSS VSS nm1p2_svt_lp W=200.00n L=60.00n
MM12 net52 c pm VSS nm1p2_svt_lp W=200.00n L=60.00n
MM11 net0183 m net52 VSS nm1p2_svt_lp W=200.00n L=60.00n
MM9 net0171 D net69 VSS nm1p2_svt_lp W=300.00n L=60.00n
MM7 net69 E net_0164 VSS nm1p2_svt_lp W=310.00n L=60.00n
MM0 m pm VSS VSS nm1p2_svt_lp W=430.00n L=60.00n
MM66 ps cn net_0153 VDD pm1p2_svt_lp W=415.00n L=60.00n
MM67 net_0153 m VDD VDD pm1p2_svt_lp W=415.00n L=60.00n
MM64 pm c net_0157 VDD pm1p2_svt_lp W=520.00n L=60.00n
MM53 net0267 SE VDD VDD pm1p2_svt_lp W=390.00n L=60.00n
MM61 sen SE VDD VDD pm1p2_svt_lp W=300.00n L=60.00n
MM51 net_0157 SI net_0247 VDD pm1p2_svt_lp W=300.00n L=60.00n
MM50 net_0247 sen VDD VDD pm1p2_svt_lp W=300.00n L=60.00n
MM37 net_0157 s net_0228 VDD pm1p2_svt_lp W=380.00n L=60.00n
MM38 net_0228 E net0267 VDD pm1p2_svt_lp W=380.00n L=60.00n
MM69 pm RDN VDD VDD pm1p2_svt_lp W=300.0n L=60.00n
MM72 ps RDN VDD VDD pm1p2_svt_lp W=300.0n L=60.00n
MM32 en E VDD VDD pm1p2_svt_lp W=300.00n L=60.00n
MM29 c cn VDD VDD pm1p2_svt_lp W=450.00n L=60.00n
MM28 cn CK VDD VDD pm1p2_svt_lp W=300.00n L=60.00n
MM26 VDD s net109 VDD pm1p2_svt_lp W=300.00n L=60.00n
MM25 net109 c ps VDD pm1p2_svt_lp W=300.00n L=60.00n
MM21 Q ps VDD VDD pm1p2_svt_lp W=1.3u L=60.00n
MM18 s ps VDD VDD pm1p2_svt_lp W=300.00n L=60.00n
MM14 net117 cn pm VDD pm1p2_svt_lp W=300.00n L=60.00n
MM13 VDD m net117 VDD pm1p2_svt_lp W=300.00n L=60.00n
MM10 net_0157 D net128 VDD pm1p2_svt_lp W=390.00n L=60.00n
MM8 net128 en net0267 VDD pm1p2_svt_lp W=390.00n L=60.00n
MM1 m pm VDD VDD pm1p2_svt_lp W=650.00n L=60.00n
.ENDS

.SUBCKT ESDFFTRX1H9R CK D E Q QN RN SE SI VDD VSS
MM55 m c s VSS nm1p2_svt_lp W=430.00n L=60.00n
MM60 sen SE VSS VSS nm1p2_svt_lp W=200.00n L=60.00n
MM46 net_0152 SI VSS VSS nm1p2_svt_lp W=200.00n L=60.00n
MM45 net_0157 SE net_0152 VSS nm1p2_svt_lp W=200.00n L=60.00n
MM62 net_0157 cn pm VSS nm1p2_svt_lp W=400.00n L=60.00n
MM40 net_0157 sen net_0149 VSS nm1p2_svt_lp W=430.00n L=60.00n
MM41 net_0149 s net_0164 VSS nm1p2_svt_lp W=430.00n L=60.00n
MM59 net0172 E net0175 VSS nm1p2_svt_lp W=430.00n L=60.00n
MM42 net0175 RN VSS VSS nm1p2_svt_lp W=430.00n L=60.00n
MM58 net_0164 en net0175 VSS nm1p2_svt_lp W=430.00n L=60.00n
MM64 QN s VSS VSS nm1p2_svt_lp W=290.00n L=60.00n
MM31 en E VSS VSS nm1p2_svt_lp W=200.00n L=60.00n
MM30 c cn VSS VSS nm1p2_svt_lp W=240.00n L=60.00n
MM27 cn CK VSS VSS nm1p2_svt_lp W=200.00n L=60.00n
MM24 net48 cn s VSS nm1p2_svt_lp W=200.00n L=60.00n
MM23 VSS sp net48 VSS nm1p2_svt_lp W=200.00n L=60.00n
MM22 Q sp VSS VSS nm1p2_svt_lp W=290.00n L=60.00n
MM17 sp s VSS VSS nm1p2_svt_lp W=280.00n L=60.00n
MM12 net52 c pm VSS nm1p2_svt_lp W=200.00n L=60.00n
MM11 VSS m net52 VSS nm1p2_svt_lp W=200.00n L=60.00n
MM9 net_0157 sen net69 VSS nm1p2_svt_lp W=430.00n L=60.00n
MM7 net69 D net0172 VSS nm1p2_svt_lp W=430.00n L=60.00n
MM0 m pm VSS VSS nm1p2_svt_lp W=430.00n L=60.00n
MM56 m cn s VDD pm1p2_svt_lp W=650.00n L=60.00n
MM54 net0255 SE VDD VDD pm1p2_svt_lp W=200.00n L=60.00n
MM53 net0267 E VDD VDD pm1p2_svt_lp W=500.00n L=60.00n
MM61 sen SE VDD VDD pm1p2_svt_lp W=300.00n L=60.00n
MM51 net_0157 sen net_0247 VDD pm1p2_svt_lp W=300.00n L=60.00n
MM50 net_0247 SI VDD VDD pm1p2_svt_lp W=300.00n L=60.00n
MM63 net_0157 c pm VDD pm1p2_svt_lp W=600.00n L=60.00n
MM37 net_0157 SE net_0228 VDD pm1p2_svt_lp W=500.00n L=60.00n
MM38 net_0228 s net0267 VDD pm1p2_svt_lp W=500.00n L=60.00n
MM39 net_0157 RN net0255 VDD pm1p2_svt_lp W=200.00n L=60.00n
MM57 net0279 en VDD VDD pm1p2_svt_lp W=500.00n L=60.00n
MM65 QN s VDD VDD pm1p2_svt_lp W=440.00n L=60.00n
MM32 en E VDD VDD pm1p2_svt_lp W=300.00n L=60.00n
MM29 c cn VDD VDD pm1p2_svt_lp W=360.00n L=60.00n
MM28 cn CK VDD VDD pm1p2_svt_lp W=300.00n L=60.00n
MM26 VDD sp net109 VDD pm1p2_svt_lp W=300.00n L=60.00n
MM25 net109 c s VDD pm1p2_svt_lp W=300.00n L=60.00n
MM21 Q sp VDD VDD pm1p2_svt_lp W=440.00n L=60.00n
MM18 sp s VDD VDD pm1p2_svt_lp W=420.00n L=60.00n
MM14 net117 cn pm VDD pm1p2_svt_lp W=300.00n L=60.00n
MM13 VDD m net117 VDD pm1p2_svt_lp W=300.00n L=60.00n
MM10 net_0157 SE net128 VDD pm1p2_svt_lp W=500.00n L=60.00n
MM8 net128 D net0279 VDD pm1p2_svt_lp W=500.00n L=60.00n
MM1 m pm VDD VDD pm1p2_svt_lp W=650.00n L=60.00n
.ENDS

.SUBCKT ESDFFTRX2H9R CK D E Q QN RN SE SI VDD VSS
MM55 m c s VSS nm1p2_svt_lp W=430.00n L=60.00n
MM60 sen SE VSS VSS nm1p2_svt_lp W=200.00n L=60.00n
MM46 net_0152 SI VSS VSS nm1p2_svt_lp W=200.00n L=60.00n
MM45 net_0157 SE net_0152 VSS nm1p2_svt_lp W=200.00n L=60.00n
MM62 net_0157 cn pm VSS nm1p2_svt_lp W=400.00n L=60.00n
MM40 net_0157 sen net_0149 VSS nm1p2_svt_lp W=430.00n L=60.00n
MM41 net_0149 s net_0164 VSS nm1p2_svt_lp W=430.00n L=60.00n
MM59 net0172 E net0175 VSS nm1p2_svt_lp W=430.00n L=60.00n
MM42 net0175 RN VSS VSS nm1p2_svt_lp W=430.00n L=60.00n
MM58 net_0164 en net0175 VSS nm1p2_svt_lp W=430.00n L=60.00n
MM64 QN s VSS VSS nm1p2_svt_lp W=430.00n L=60.00n
MM31 en E VSS VSS nm1p2_svt_lp W=200.00n L=60.00n
MM30 c cn VSS VSS nm1p2_svt_lp W=240.00n L=60.00n
MM27 cn CK VSS VSS nm1p2_svt_lp W=200.00n L=60.00n
MM24 net48 cn s VSS nm1p2_svt_lp W=200.00n L=60.00n
MM23 VSS sp net48 VSS nm1p2_svt_lp W=200.00n L=60.00n
MM22 Q sp VSS VSS nm1p2_svt_lp W=430.00n L=60.00n
MM17 sp s VSS VSS nm1p2_svt_lp W=300.00n L=60.00n
MM12 net52 c pm VSS nm1p2_svt_lp W=200.00n L=60.00n
MM11 VSS m net52 VSS nm1p2_svt_lp W=200.00n L=60.00n
MM9 net_0157 sen net69 VSS nm1p2_svt_lp W=430.00n L=60.00n
MM7 net69 D net0172 VSS nm1p2_svt_lp W=430.00n L=60.00n
MM0 m pm VSS VSS nm1p2_svt_lp W=430.00n L=60.00n
MM56 m cn s VDD pm1p2_svt_lp W=650.00n L=60.00n
MM54 net0255 SE VDD VDD pm1p2_svt_lp W=200.00n L=60.00n
MM53 net0267 E VDD VDD pm1p2_svt_lp W=500.00n L=60.00n
MM61 sen SE VDD VDD pm1p2_svt_lp W=300.00n L=60.00n
MM51 net_0157 sen net_0247 VDD pm1p2_svt_lp W=300.00n L=60.00n
MM50 net_0247 SI VDD VDD pm1p2_svt_lp W=300.00n L=60.00n
MM63 net_0157 c pm VDD pm1p2_svt_lp W=600.00n L=60.00n
MM37 net_0157 SE net_0228 VDD pm1p2_svt_lp W=500.00n L=60.00n
MM38 net_0228 s net0267 VDD pm1p2_svt_lp W=500.00n L=60.00n
MM39 net_0157 RN net0255 VDD pm1p2_svt_lp W=200.00n L=60.00n
MM57 net0279 en VDD VDD pm1p2_svt_lp W=500.00n L=60.00n
MM65 QN s VDD VDD pm1p2_svt_lp W=650.00n L=60.00n
MM32 en E VDD VDD pm1p2_svt_lp W=300.00n L=60.00n
MM29 c cn VDD VDD pm1p2_svt_lp W=360.00n L=60.00n
MM28 cn CK VDD VDD pm1p2_svt_lp W=300.00n L=60.00n
MM26 VDD sp net109 VDD pm1p2_svt_lp W=300.00n L=60.00n
MM25 net109 c s VDD pm1p2_svt_lp W=300.00n L=60.00n
MM21 Q sp VDD VDD pm1p2_svt_lp W=650.00n L=60.00n
MM18 sp s VDD VDD pm1p2_svt_lp W=420.00n L=60.00n
MM14 net117 cn pm VDD pm1p2_svt_lp W=300.00n L=60.00n
MM13 VDD m net117 VDD pm1p2_svt_lp W=300.00n L=60.00n
MM10 net_0157 SE net128 VDD pm1p2_svt_lp W=500.00n L=60.00n
MM8 net128 D net0279 VDD pm1p2_svt_lp W=500.00n L=60.00n
MM1 m pm VDD VDD pm1p2_svt_lp W=650.00n L=60.00n
.ENDS

.SUBCKT ESDFFTRX4H9R CK D E Q QN RN SE SI VDD VSS
MM55 m c s VSS nm1p2_svt_lp W=430.00n L=60.00n
MM60 sen SE VSS VSS nm1p2_svt_lp W=200.00n L=60.00n
MM46 net_0152 SI VSS VSS nm1p2_svt_lp W=200.00n L=60.00n
MM45 net_0157 SE net_0152 VSS nm1p2_svt_lp W=200.00n L=60.00n
MM62 net_0157 cn pm VSS nm1p2_svt_lp W=400.00n L=60.00n
MM40 net_0157 sen net_0149 VSS nm1p2_svt_lp W=430.00n L=60.00n
MM41 net_0149 s net_0164 VSS nm1p2_svt_lp W=430.00n L=60.00n
MM59 net0172 E net0175 VSS nm1p2_svt_lp W=430.00n L=60.00n
MM42 net0175 RN VSS VSS nm1p2_svt_lp W=430.00n L=60.00n
MM58 net_0164 en net0175 VSS nm1p2_svt_lp W=430.00n L=60.00n
MM64 QN s VSS VSS nm1p2_svt_lp W=860.00n L=60.00n
MM31 en E VSS VSS nm1p2_svt_lp W=200.00n L=60.00n
MM30 c cn VSS VSS nm1p2_svt_lp W=300.00n L=60.00n
MM27 cn CK VSS VSS nm1p2_svt_lp W=200.00n L=60.00n
MM24 net48 cn s VSS nm1p2_svt_lp W=200.00n L=60.00n
MM23 VSS sp net48 VSS nm1p2_svt_lp W=200.00n L=60.00n
MM22 Q sp VSS VSS nm1p2_svt_lp W=860.00n L=60.00n
MM17 sp s VSS VSS nm1p2_svt_lp W=400.00n L=60.00n
MM12 net52 c pm VSS nm1p2_svt_lp W=200.00n L=60.00n
MM11 VSS m net52 VSS nm1p2_svt_lp W=200.00n L=60.00n
MM9 net_0157 sen net69 VSS nm1p2_svt_lp W=430.00n L=60.00n
MM7 net69 D net0172 VSS nm1p2_svt_lp W=430.00n L=60.00n
MM0 m pm VSS VSS nm1p2_svt_lp W=430.00n L=60.00n
MM56 m cn s VDD pm1p2_svt_lp W=650.00n L=60.00n
MM54 net0255 SE VDD VDD pm1p2_svt_lp W=200.00n L=60.00n
MM53 net0267 E VDD VDD pm1p2_svt_lp W=500.00n L=60.00n
MM61 sen SE VDD VDD pm1p2_svt_lp W=300.00n L=60.00n
MM51 net_0157 sen net_0247 VDD pm1p2_svt_lp W=300.00n L=60.00n
MM50 net_0247 SI VDD VDD pm1p2_svt_lp W=300.00n L=60.00n
MM63 net_0157 c pm VDD pm1p2_svt_lp W=600.00n L=60.00n
MM37 net_0157 SE net_0228 VDD pm1p2_svt_lp W=500.00n L=60.00n
MM38 net_0228 s net0267 VDD pm1p2_svt_lp W=500.00n L=60.00n
MM39 net_0157 RN net0255 VDD pm1p2_svt_lp W=200.00n L=60.00n
MM57 net0279 en VDD VDD pm1p2_svt_lp W=500.00n L=60.00n
MM65 QN s VDD VDD pm1p2_svt_lp W=1.3u L=60.00n
MM32 en E VDD VDD pm1p2_svt_lp W=300.00n L=60.00n
MM29 c cn VDD VDD pm1p2_svt_lp W=450.00n L=60.00n
MM28 cn CK VDD VDD pm1p2_svt_lp W=300.00n L=60.00n
MM26 VDD sp net109 VDD pm1p2_svt_lp W=300.00n L=60.00n
MM25 net109 c s VDD pm1p2_svt_lp W=300.00n L=60.00n
MM21 Q sp VDD VDD pm1p2_svt_lp W=1.3u L=60.00n
MM18 sp s VDD VDD pm1p2_svt_lp W=480.00n L=60.00n
MM14 net117 cn pm VDD pm1p2_svt_lp W=300.00n L=60.00n
MM13 VDD m net117 VDD pm1p2_svt_lp W=300.00n L=60.00n
MM10 net_0157 SE net128 VDD pm1p2_svt_lp W=500.00n L=60.00n
MM8 net128 D net0279 VDD pm1p2_svt_lp W=500.00n L=60.00n
MM1 m pm VDD VDD pm1p2_svt_lp W=650.00n L=60.00n
.ENDS

.SUBCKT ESDFFTRQX1H9R CK D E Q RN SE SI VDD VSS
MM55 m c s VSS nm1p2_svt_lp W=430.00n L=60.00n
MM60 sen SE VSS VSS nm1p2_svt_lp W=200.00n L=60.00n
MM46 net_0152 SI VSS VSS nm1p2_svt_lp W=200.00n L=60.00n
MM45 net_0157 SE net_0152 VSS nm1p2_svt_lp W=200.00n L=60.00n
MM62 net_0157 cn pm VSS nm1p2_svt_lp W=400.00n L=60.00n
MM40 net_0157 sen net_0149 VSS nm1p2_svt_lp W=430.00n L=60.00n
MM41 net_0149 s net_0164 VSS nm1p2_svt_lp W=430.00n L=60.00n
MM59 net0172 E net0175 VSS nm1p2_svt_lp W=430.00n L=60.00n
MM42 net0175 RN VSS VSS nm1p2_svt_lp W=430.00n L=60.00n
MM58 net_0164 en net0175 VSS nm1p2_svt_lp W=430.00n L=60.00n
MM31 en E VSS VSS nm1p2_svt_lp W=200.00n L=60.00n
MM30 c cn VSS VSS nm1p2_svt_lp W=240.00n L=60.00n
MM27 cn CK VSS VSS nm1p2_svt_lp W=200.00n L=60.00n
MM24 net48 cn s VSS nm1p2_svt_lp W=200.00n L=60.00n
MM23 VSS sp net48 VSS nm1p2_svt_lp W=200.00n L=60.00n
MM22 Q sp VSS VSS nm1p2_svt_lp W=290.00n L=60.00n
MM17 sp s VSS VSS nm1p2_svt_lp W=220.00n L=60.00n
MM12 net52 c pm VSS nm1p2_svt_lp W=200.00n L=60.00n
MM11 VSS m net52 VSS nm1p2_svt_lp W=200.00n L=60.00n
MM9 net_0157 sen net69 VSS nm1p2_svt_lp W=430.00n L=60.00n
MM7 net69 D net0172 VSS nm1p2_svt_lp W=430.00n L=60.00n
MM0 m pm VSS VSS nm1p2_svt_lp W=430.00n L=60.00n
MM56 m cn s VDD pm1p2_svt_lp W=650.00n L=60.00n
MM54 net0255 SE VDD VDD pm1p2_svt_lp W=200.00n L=60.00n
MM53 net0267 E VDD VDD pm1p2_svt_lp W=500.00n L=60.00n
MM61 sen SE VDD VDD pm1p2_svt_lp W=300.00n L=60.00n
MM51 net_0157 sen net_0247 VDD pm1p2_svt_lp W=300.00n L=60.00n
MM50 net_0247 SI VDD VDD pm1p2_svt_lp W=300.00n L=60.00n
MM63 net_0157 c pm VDD pm1p2_svt_lp W=600.00n L=60.00n
MM37 net_0157 SE net_0228 VDD pm1p2_svt_lp W=500.00n L=60.00n
MM38 net_0228 s net0267 VDD pm1p2_svt_lp W=500.00n L=60.00n
MM39 net_0157 RN net0255 VDD pm1p2_svt_lp W=200.00n L=60.00n
MM57 net0279 en VDD VDD pm1p2_svt_lp W=500.00n L=60.00n
MM32 en E VDD VDD pm1p2_svt_lp W=300.00n L=60.00n
MM29 c cn VDD VDD pm1p2_svt_lp W=360.00n L=60.00n
MM28 cn CK VDD VDD pm1p2_svt_lp W=300.00n L=60.00n
MM26 VDD sp net109 VDD pm1p2_svt_lp W=300.00n L=60.00n
MM25 net109 c s VDD pm1p2_svt_lp W=300.00n L=60.00n
MM21 Q sp VDD VDD pm1p2_svt_lp W=440.00n L=60.00n
MM18 sp s VDD VDD pm1p2_svt_lp W=360.00n L=60.00n
MM14 net117 cn pm VDD pm1p2_svt_lp W=300.00n L=60.00n
MM13 VDD m net117 VDD pm1p2_svt_lp W=300.00n L=60.00n
MM10 net_0157 SE net128 VDD pm1p2_svt_lp W=500.00n L=60.00n
MM8 net128 D net0279 VDD pm1p2_svt_lp W=500.00n L=60.00n
MM1 m pm VDD VDD pm1p2_svt_lp W=650.00n L=60.00n
.ENDS

.SUBCKT ESDFFTRQX2H9R CK D E Q RN SE SI VDD VSS
MM55 m c s VSS nm1p2_svt_lp W=430.00n L=60.00n
MM60 sen SE VSS VSS nm1p2_svt_lp W=200.00n L=60.00n
MM46 net_0152 SI VSS VSS nm1p2_svt_lp W=200.00n L=60.00n
MM45 net_0157 SE net_0152 VSS nm1p2_svt_lp W=200.00n L=60.00n
MM62 net_0157 cn pm VSS nm1p2_svt_lp W=400.00n L=60.00n
MM40 net_0157 sen net_0149 VSS nm1p2_svt_lp W=430.00n L=60.00n
MM41 net_0149 s net_0164 VSS nm1p2_svt_lp W=430.00n L=60.00n
MM59 net0172 E net0175 VSS nm1p2_svt_lp W=430.00n L=60.00n
MM42 net0175 RN VSS VSS nm1p2_svt_lp W=430.00n L=60.00n
MM58 net_0164 en net0175 VSS nm1p2_svt_lp W=430.00n L=60.00n
MM31 en E VSS VSS nm1p2_svt_lp W=200.00n L=60.00n
MM30 c cn VSS VSS nm1p2_svt_lp W=240.00n L=60.00n
MM27 cn CK VSS VSS nm1p2_svt_lp W=200.00n L=60.00n
MM24 net48 cn s VSS nm1p2_svt_lp W=200.00n L=60.00n
MM23 VSS sp net48 VSS nm1p2_svt_lp W=200.00n L=60.00n
MM22 Q sp VSS VSS nm1p2_svt_lp W=430.00n L=60.00n
MM17 sp s VSS VSS nm1p2_svt_lp W=240.00n L=60.00n
MM12 net52 c pm VSS nm1p2_svt_lp W=200.00n L=60.00n
MM11 VSS m net52 VSS nm1p2_svt_lp W=200.00n L=60.00n
MM9 net_0157 sen net69 VSS nm1p2_svt_lp W=430.00n L=60.00n
MM7 net69 D net0172 VSS nm1p2_svt_lp W=430.00n L=60.00n
MM0 m pm VSS VSS nm1p2_svt_lp W=430.00n L=60.00n
MM56 m cn s VDD pm1p2_svt_lp W=650.00n L=60.00n
MM54 net0255 SE VDD VDD pm1p2_svt_lp W=200.00n L=60.00n
MM53 net0267 E VDD VDD pm1p2_svt_lp W=500.00n L=60.00n
MM61 sen SE VDD VDD pm1p2_svt_lp W=300.00n L=60.00n
MM51 net_0157 sen net_0247 VDD pm1p2_svt_lp W=300.00n L=60.00n
MM50 net_0247 SI VDD VDD pm1p2_svt_lp W=300.00n L=60.00n
MM63 net_0157 c pm VDD pm1p2_svt_lp W=600.00n L=60.00n
MM37 net_0157 SE net_0228 VDD pm1p2_svt_lp W=500.00n L=60.00n
MM38 net_0228 s net0267 VDD pm1p2_svt_lp W=500.00n L=60.00n
MM39 net_0157 RN net0255 VDD pm1p2_svt_lp W=200.00n L=60.00n
MM57 net0279 en VDD VDD pm1p2_svt_lp W=500.00n L=60.00n
MM32 en E VDD VDD pm1p2_svt_lp W=300.00n L=60.00n
MM29 c cn VDD VDD pm1p2_svt_lp W=360.00n L=60.00n
MM28 cn CK VDD VDD pm1p2_svt_lp W=300.00n L=60.00n
MM26 VDD sp net109 VDD pm1p2_svt_lp W=300.00n L=60.00n
MM25 net109 c s VDD pm1p2_svt_lp W=300.00n L=60.00n
MM21 Q sp VDD VDD pm1p2_svt_lp W=650.00n L=60.00n
MM18 sp s VDD VDD pm1p2_svt_lp W=420.00n L=60.00n
MM14 net117 cn pm VDD pm1p2_svt_lp W=300.00n L=60.00n
MM13 VDD m net117 VDD pm1p2_svt_lp W=300.00n L=60.00n
MM10 net_0157 SE net128 VDD pm1p2_svt_lp W=500.00n L=60.00n
MM8 net128 D net0279 VDD pm1p2_svt_lp W=500.00n L=60.00n
MM1 m pm VDD VDD pm1p2_svt_lp W=650.00n L=60.00n
.ENDS

.SUBCKT ESDFFTRQX4H9R CK D E Q RN SE SI VDD VSS
MM55 m c s VSS nm1p2_svt_lp W=430.00n L=60.00n
MM60 sen SE VSS VSS nm1p2_svt_lp W=200.00n L=60.00n
MM46 net_0152 SI VSS VSS nm1p2_svt_lp W=200.00n L=60.00n
MM45 net_0157 SE net_0152 VSS nm1p2_svt_lp W=200.00n L=60.00n
MM62 net_0157 cn pm VSS nm1p2_svt_lp W=400.00n L=60.00n
MM40 net_0157 sen net_0149 VSS nm1p2_svt_lp W=430.00n L=60.00n
MM41 net_0149 s net_0164 VSS nm1p2_svt_lp W=430.00n L=60.00n
MM59 net0172 E net0175 VSS nm1p2_svt_lp W=430.00n L=60.00n
MM42 net0175 RN VSS VSS nm1p2_svt_lp W=430.00n L=60.00n
MM58 net_0164 en net0175 VSS nm1p2_svt_lp W=430.00n L=60.00n
MM31 en E VSS VSS nm1p2_svt_lp W=200.00n L=60.00n
MM30 c cn VSS VSS nm1p2_svt_lp W=300.00n L=60.00n
MM27 cn CK VSS VSS nm1p2_svt_lp W=200.00n L=60.00n
MM24 net48 cn s VSS nm1p2_svt_lp W=200.00n L=60.00n
MM23 VSS sp net48 VSS nm1p2_svt_lp W=200.00n L=60.00n
MM22 Q sp VSS VSS nm1p2_svt_lp W=860.00n L=60.00n
MM17 sp s VSS VSS nm1p2_svt_lp W=310.00n L=60.00n
MM12 net52 c pm VSS nm1p2_svt_lp W=200.00n L=60.00n
MM11 VSS m net52 VSS nm1p2_svt_lp W=200.00n L=60.00n
MM9 net_0157 sen net69 VSS nm1p2_svt_lp W=430.00n L=60.00n
MM7 net69 D net0172 VSS nm1p2_svt_lp W=430.00n L=60.00n
MM0 m pm VSS VSS nm1p2_svt_lp W=430.00n L=60.00n
MM56 m cn s VDD pm1p2_svt_lp W=650.00n L=60.00n
MM54 net0255 SE VDD VDD pm1p2_svt_lp W=200.00n L=60.00n
MM53 net0267 E VDD VDD pm1p2_svt_lp W=500.00n L=60.00n
MM61 sen SE VDD VDD pm1p2_svt_lp W=300.00n L=60.00n
MM51 net_0157 sen net_0247 VDD pm1p2_svt_lp W=300.00n L=60.00n
MM50 net_0247 SI VDD VDD pm1p2_svt_lp W=300.00n L=60.00n
MM63 net_0157 c pm VDD pm1p2_svt_lp W=600.00n L=60.00n
MM37 net_0157 SE net_0228 VDD pm1p2_svt_lp W=500.00n L=60.00n
MM38 net_0228 s net0267 VDD pm1p2_svt_lp W=500.00n L=60.00n
MM39 net_0157 RN net0255 VDD pm1p2_svt_lp W=200.00n L=60.00n
MM57 net0279 en VDD VDD pm1p2_svt_lp W=500.00n L=60.00n
MM32 en E VDD VDD pm1p2_svt_lp W=300.00n L=60.00n
MM29 c cn VDD VDD pm1p2_svt_lp W=450.00n L=60.00n
MM28 cn CK VDD VDD pm1p2_svt_lp W=300.00n L=60.00n
MM26 VDD sp net109 VDD pm1p2_svt_lp W=300.00n L=60.00n
MM25 net109 c s VDD pm1p2_svt_lp W=300.00n L=60.00n
MM21 Q sp VDD VDD pm1p2_svt_lp W=1.3u L=60.00n
MM18 sp s VDD VDD pm1p2_svt_lp W=500.00n L=60.00n
MM14 net117 cn pm VDD pm1p2_svt_lp W=300.00n L=60.00n
MM13 VDD m net117 VDD pm1p2_svt_lp W=300.00n L=60.00n
MM10 net_0157 SE net128 VDD pm1p2_svt_lp W=500.00n L=60.00n
MM8 net128 D net0279 VDD pm1p2_svt_lp W=500.00n L=60.00n
MM1 m pm VDD VDD pm1p2_svt_lp W=650.00n L=60.00n
.ENDS
