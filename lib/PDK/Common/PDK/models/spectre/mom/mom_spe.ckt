simulator lang = spectre

// * release version    : 1.2
// *
// *  release date       : 03/15/2025
// *
// *  simulation tool    : synopsys hspice version n-2017.12-sp2
// *
// *  mom capacitor   :
// *
// *        *-----------------------------------------------------------*
// *        |                 type                     |   mom subckt   |
// *        *-----------------------------------------------------------*
// *        |                mom                       |   mom_2t       |
// *        *-----------------------------------------------------------*
// *
// * (remark: shielding option: 0=non-shielding, 1=poly-shielding, 2=metal-shielding)
// *
// *****************************************************************
// *                       55nm mom capacitor 2t                   *
// *****************************************************************
// * a=port1, b=port2
subckt mom_2t (a b )
parameters
+lf       = 1u
+nf       = 6
+bm       = 1
+tm       = 3
+mr       = 1
+mismod_mom = 1

// * mom capacitor model parameters

parameters nm       = tm-bm+1
// *mismatch parameter
+dc0_mis  = 1.025*(a11+a12+a13)*sigma_mis_mom*mismod_mom

+a11      = 3.45e-7*geo_fac*geo_fac
+a12      = 3.105e-6*geo_fac
+a13      = 2.2425e-4

+geo_fac  = 1/sqrt(lf*nf*mr*nm)

// *****base model parameter*****
+ctc1     = 2.89e-6
+cvc1     = 1.43665e-9     cvc2     = 1.90679e-9
+tcoef    = 1.0+ctc1*(temp-25.0)

+cf       = max((((((0.207291*nm-4.85047e-2)*lf*1e6+(1.05962e-2*nm-4.827941e-4))*nf-((9.935717e-3*nm+7.69893e-2)*lf*1e6+(1.65152e-3*nm-8.03382e-2)))*(bm==1)+(((0.199407*nm-3.597274e-3)*lf*1e6+(1.34357e-2*nm-0.018116))*nf-((1.965032e-3*nm+0.169599)*lf*1e6+(2.51922e-2*nm-0.306621)))*(bm>1)))*1.04*1e-15,1e-18)

// *equivalent circuit
cab a b capacitor c = mr*cf*(1+dc0_mis)*(1+dmom_mnx)*tcoef*(1.0+v(a,b)*(cvc1+cvc2*v(a,b)))/2

ends mom_2t

// *****************************************************************

// *
// *  release version    : 1.0
// *
// *  release date       : 09/30/2024
// *
// *  simulation tool    : synopsys hspice version n-2017.12-sp2
// *
// *  mom capacitor   :
// *
// *        *-----------------------------------------------------------*
// *        |                 type                     |   mom subckt   |
// *        *-----------------------------------------------------------*
// *        |                mom                       |   mom_3t       |
// *        *-----------------------------------------------------------*
// *
// * (remark: shielding option: 0=non-shielding, 1=poly-shielding, 2=metal-shielding)
// *
// *****************************************************************
// *                       55nm mom capacitor 3t                   *
// *****************************************************************
// * a=port1, b=port2
subckt mom_3t (a b p )
parameters
+lf       = 1u
+nf       = 6
+bm       = 1
+tm       = 3
+mr       = 1
+mismod_mom = 1
+shielding = 0

// * mom capacitor model parameters

parameters nm       = tm-bm+1
// *mismatch parameter
+dc0_mis  = 1.025*(a11+a12+a13)*sigma_mis_mom*mismod_mom

+a11      = 3.45e-7*geo_fac*geo_fac
+a12      = 3.105e-6*geo_fac
+a13      = 2.2425e-4

+geo_fac  = 1/sqrt(lf*nf*mr*nm)

// *****base model parameter*****
+ctc1     = 2.89e-6
+cvc1     = 1.43665e-9     cvc2     = 1.90679e-9
+tcoef    = 1.0+ctc1*(temp-25.0)

+cf       = max((((((0.207291*nm-4.85047e-2)*lf*1e6+(1.05962e-2*nm-4.827941e-4))*nf-((9.935717e-3*nm+7.69893e-2)*lf*1e6+(1.65152e-3*nm-8.03382e-2)))*(bm==1)+(((0.199407*nm-3.597274e-3)*lf*1e6+(1.34357e-2*nm-0.018116))*nf-((1.965032e-3*nm+0.169599)*lf*1e6+(2.51922e-2*nm-0.306621)))*(bm>1)))*1.04*1e-15,1e-18)
+cpara    = max((((0.00598*pwr(bm,-0.7316))*lf*1e6*nf*((shielding==0)+(4.1*pwr(bm,-0.85))*(shielding==1))+(-0.0037594*bm+0.0273)*lf*1e6*nf*(shielding==2))+0.2)*1e-15,1e-18)
// *equivalent circuit
cab a b capacitor c = mr*cf*(1+dc0_mis)*(1+dmom_mnx)*tcoef*(1.0+v(a,b)*(cvc1+cvc2*v(a,b)))/2
cap a p capacitor c = cpara*mr*tcoef*(1.0+v(a,p)*(cvc1+cvc2*v(a,p)))/2
cbp b p capacitor c = cpara*mr*tcoef*(1.0+v(b,p)*(cvc1+cvc2*v(b,p)))/2

ends mom_3t
