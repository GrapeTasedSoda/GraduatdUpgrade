* MAC16 full-chip LVS schematic (flattened from /home/user/MAC16_work/out/apr/mac16_apr.v)
.SUBCKT mac16 mode inA inB in_ready clk rst_n sum_out carry out_ready VDD VSS
Xu_mac16_top_mode_reg_reg u_mac16_top_mode_reg VDD VSS clk mode n837 DFFRPQX0P5H9R
Xu_mac16_top_mode_reg_d1_reg u_mac16_top_mode_reg_d1 VDD VSS clk u_mac16_top_mode_reg n837 DFFRPQX0P5H9R
Xu_mac16_top_u_inB_in_done_reg u_mac16_top_inB_done VDD VSS clk u_mac16_top_u_inB_N48 HFSNET_13 DFFRPQX0P5H9R
Xu_mac16_top_u_inB_data_out_reg_0_ u_mac16_top_inB_par__0_ VDD VSS u_mac16_top_u_inB_net803 inB HFSNET_10 DFFRPQX0P5H9R
Xu_mac16_top_u_inB_cnt_reg_0_ u_mac16_top_u_inB_cnt__0_ VDD VSS clk u_mac16_top_u_inB_N49 HFSNET_32 DFFRPQX0P5H9R
Xu_mac16_top_u_inB_cnt_reg_1_ u_mac16_top_u_inB_cnt__1_ VDD VSS clk u_mac16_top_u_inB_N50 HFSNET_32 DFFRPQX0P5H9R
Xu_mac16_top_u_inB_cnt_reg_2_ u_mac16_top_u_inB_cnt__2_ VDD VSS clk u_mac16_top_u_inB_N51 HFSNET_32 DFFRPQX0P5H9R
Xu_mac16_top_u_inB_cnt_reg_3_ u_mac16_top_u_inB_cnt__3_ VDD VSS clk u_mac16_top_u_inB_N52 HFSNET_32 DFFRPQX0P5H9R
Xu_mac16_top_u_inB_shift_reg_reg_0_ u_mac16_top_u_inB_shift_reg__0_ VDD VSS clk u_mac16_top_u_inB_N33 HFSNET_25 DFFRPQX0P5H9R
Xu_mac16_top_u_inB_data_out_reg_1_ u_mac16_top_inB_par__1_ VDD VSS u_mac16_top_u_inB_net803 copt_net_63 HFSNET_25 DFFRPQX0P5H9R
Xu_mac16_top_u_inB_shift_reg_reg_1_ u_mac16_top_u_inB_shift_reg__1_ VDD VSS clk u_mac16_top_u_inB_N34 HFSNET_25 DFFRPQX0P5H9R
Xu_mac16_top_u_inB_data_out_reg_2_ u_mac16_top_inB_par__2_ VDD VSS u_mac16_top_u_inB_net803 copt_net_64 HFSNET_25 DFFRPQX0P5H9R
Xu_mac16_top_u_inB_shift_reg_reg_2_ u_mac16_top_u_inB_shift_reg__2_ VDD VSS clk u_mac16_top_u_inB_N35 HFSNET_25 DFFRPQX0P5H9R
Xu_mac16_top_u_inB_data_out_reg_3_ u_mac16_top_inB_par__3_ VDD VSS u_mac16_top_u_inB_net803 copt_net_65 HFSNET_25 DFFRPQX0P5H9R
Xu_mac16_top_u_inB_shift_reg_reg_3_ u_mac16_top_u_inB_shift_reg__3_ VDD VSS clk u_mac16_top_u_inB_N36 HFSNET_25 DFFRPQX0P5H9R
Xu_mac16_top_u_inB_data_out_reg_4_ u_mac16_top_inB_par__4_ VDD VSS u_mac16_top_u_inB_net803 copt_net_66 HFSNET_25 DFFRPQX0P5H9R
Xu_mac16_top_u_inB_shift_reg_reg_4_ u_mac16_top_u_inB_shift_reg__4_ VDD VSS clk u_mac16_top_u_inB_N37 HFSNET_25 DFFRPQX0P5H9R
Xu_mac16_top_u_inB_data_out_reg_5_ u_mac16_top_inB_par__5_ VDD VSS u_mac16_top_u_inB_net803 copt_net_67 HFSNET_25 DFFRPQX0P5H9R
Xu_mac16_top_u_inB_shift_reg_reg_5_ u_mac16_top_u_inB_shift_reg__5_ VDD VSS clk u_mac16_top_u_inB_N38 HFSNET_25 DFFRPQX0P5H9R
Xu_mac16_top_u_inB_data_out_reg_6_ u_mac16_top_inB_par__6_ VDD VSS u_mac16_top_u_inB_net803 copt_net_73 HFSNET_25 DFFRPQX0P5H9R
Xu_mac16_top_u_inB_shift_reg_reg_6_ u_mac16_top_u_inB_shift_reg__6_ VDD VSS clk u_mac16_top_u_inB_N39 HFSNET_25 DFFRPQX0P5H9R
Xu_mac16_top_u_inB_data_out_reg_7_ u_mac16_top_inB_par__7_ VDD VSS u_mac16_top_u_inB_net803 copt_net_81 HFSNET_25 DFFRPQX0P5H9R
Xu_mac16_top_u_inB_shift_reg_reg_7_ u_mac16_top_u_inB_shift_reg__7_ VDD VSS clk u_mac16_top_u_inB_N40 HFSNET_25 DFFRPQX0P5H9R
Xu_mac16_top_u_inB_data_out_reg_8_ u_mac16_top_inB_par__8_ VDD VSS u_mac16_top_u_inB_net803 copt_net_76 HFSNET_25 DFFRPQX0P5H9R
Xu_mac16_top_u_inB_shift_reg_reg_8_ u_mac16_top_u_inB_shift_reg__8_ VDD VSS clk u_mac16_top_u_inB_N41 HFSNET_25 DFFRPQX0P5H9R
Xu_mac16_top_u_inB_data_out_reg_9_ u_mac16_top_inB_par__9_ VDD VSS u_mac16_top_u_inB_net803 copt_net_86 HFSNET_10 DFFRPQX0P5H9R
Xu_mac16_top_u_inB_shift_reg_reg_9_ u_mac16_top_u_inB_shift_reg__9_ VDD VSS clk u_mac16_top_u_inB_N42 HFSNET_10 DFFRPQX0P5H9R
Xu_mac16_top_u_inB_data_out_reg_10_ u_mac16_top_inB_par__10_ VDD VSS u_mac16_top_u_inB_net803 copt_net_78 HFSNET_10 DFFRPQX0P5H9R
Xu_mac16_top_u_inB_shift_reg_reg_10_ u_mac16_top_u_inB_shift_reg__10_ VDD VSS clk u_mac16_top_u_inB_N43 HFSNET_10 DFFRPQX0P5H9R
Xu_mac16_top_u_inB_data_out_reg_11_ u_mac16_top_inB_par__11_ VDD VSS u_mac16_top_u_inB_net803 copt_net_68 HFSNET_10 DFFRPQX0P5H9R
Xu_mac16_top_u_inB_shift_reg_reg_11_ u_mac16_top_u_inB_shift_reg__11_ VDD VSS clk u_mac16_top_u_inB_N44 HFSNET_13 DFFRPQX0P5H9R
Xu_mac16_top_u_inB_data_out_reg_12_ u_mac16_top_inB_par__12_ VDD VSS u_mac16_top_u_inB_net803 copt_net_82 HFSNET_10 DFFRPQX0P5H9R
Xu_mac16_top_u_inB_shift_reg_reg_12_ u_mac16_top_u_inB_shift_reg__12_ VDD VSS clk u_mac16_top_u_inB_N45 HFSNET_13 DFFRPQX0P5H9R
Xu_mac16_top_u_inB_data_out_reg_13_ u_mac16_top_inB_par__13_ VDD VSS u_mac16_top_u_inB_net803 copt_net_89 HFSNET_10 DFFRPQX0P5H9R
Xu_mac16_top_u_inB_shift_reg_reg_13_ u_mac16_top_u_inB_shift_reg__13_ VDD VSS clk u_mac16_top_u_inB_N46 HFSNET_13 DFFRPQX0P5H9R
Xu_mac16_top_u_inB_data_out_reg_14_ u_mac16_top_inB_par__14_ VDD VSS u_mac16_top_u_inB_net803 copt_net_90 HFSNET_10 DFFRPQX0P5H9R
Xu_mac16_top_u_inB_shift_reg_reg_14_ u_mac16_top_u_inB_shift_reg__14_ VDD VSS clk u_mac16_top_u_inB_N47 HFSNET_13 DFFRPQX0P5H9R
Xu_mac16_top_u_inB_data_out_reg_15_ u_mac16_top_inB_par__15_ VDD VSS u_mac16_top_u_inB_net803 copt_net_70 HFSNET_25 DFFRPQX0P5H9R
Xu_mac16_top_u_inA_in_done_reg u_mac16_top_inA_done VDD VSS clk u_mac16_top_u_inA_N48 HFSNET_25 DFFRPQX0P5H9R
Xu_mac16_top_op_fifo_count_reg_2_ u_mac16_top_op_fifo_count__2_ VDD VSS u_mac16_top_net617 n2348 HFSNET_10 DFFRPQX0P5H9R
Xu_mac16_top_schedule_active_reg u_mac16_top_schedule_active VDD VSS u_mac16_top_net575 n733 HFSNET_25 DFFRPQX0P5H9R
Xu_mac16_top_sched_cnt_reg_0_ u_mac16_top_sched_cnt__0_ VDD VSS u_mac16_top_net575 u_mac16_top_N202 HFSNET_25 DFFRPQX0P5H9R
Xu_mac16_top_sched_cnt_reg_1_ u_mac16_top_sched_cnt__1_ VDD VSS u_mac16_top_net575 u_mac16_top_N203 HFSNET_25 DFFRPQX0P5H9R
Xu_mac16_top_sched_cnt_reg_2_ u_mac16_top_sched_cnt__2_ VDD VSS u_mac16_top_net575 u_mac16_top_N204 HFSNET_25 DFFRPQX0P5H9R
Xu_mac16_top_calc_start_reg u_mac16_top_calc_start VDD VSS clk u_mac16_top_N206 HFSNET_25 DFFRPQX0P5H9R
Xu_mac16_top_op_fifo_rd_ptr_reg_0_ u_mac16_top_op_fifo_rd_ptr__0_ VDD VSS u_mac16_top_net570 n806 HFSNET_8 DFFRPQX0P5H9R
Xu_mac16_top_op_fifo_rd_ptr_reg_1_ u_mac16_top_op_fifo_rd_ptr__1_ VDD VSS u_mac16_top_net564 u_mac16_top_N178 HFSNET_7 DFFRPQX0P5H9R
Xu_mac16_top_opB_fifo_reg_3__15_ u_mac16_top_opB_fifo_3__15_ VDD VSS u_mac16_top_net642 u_mac16_top_inB_par__15_ HFSNET_9 DFFRPQX0P5H9R
Xu_mac16_top_opB_fifo_reg_3__14_ u_mac16_top_opB_fifo_3__14_ VDD VSS u_mac16_top_net642 u_mac16_top_inB_par__14_ HFSNET_11 DFFRPQX0P5H9R
Xu_mac16_top_opB_fifo_reg_3__13_ u_mac16_top_opB_fifo_3__13_ VDD VSS u_mac16_top_net642 u_mac16_top_inB_par__13_ HFSNET_9 DFFRPQX0P5H9R
Xu_mac16_top_opB_fifo_reg_3__12_ u_mac16_top_opB_fifo_3__12_ VDD VSS u_mac16_top_net642 u_mac16_top_inB_par__12_ HFSNET_9 DFFRPQX0P5H9R
Xu_mac16_top_opB_fifo_reg_3__11_ u_mac16_top_opB_fifo_3__11_ VDD VSS u_mac16_top_net642 u_mac16_top_inB_par__11_ HFSNET_11 DFFRPQX0P5H9R
Xu_mac16_top_opB_fifo_reg_3__10_ u_mac16_top_opB_fifo_3__10_ VDD VSS u_mac16_top_net642 u_mac16_top_inB_par__10_ HFSNET_11 DFFRPQX0P5H9R
Xu_mac16_top_opB_fifo_reg_3__9_ u_mac16_top_opB_fifo_3__9_ VDD VSS u_mac16_top_net642 u_mac16_top_inB_par__9_ HFSNET_10 DFFRPQX0P5H9R
Xu_mac16_top_opB_fifo_reg_3__8_ u_mac16_top_opB_fifo_3__8_ VDD VSS u_mac16_top_net642 u_mac16_top_inB_par__8_ HFSNET_9 DFFRPQX0P5H9R
Xu_mac16_top_opB_fifo_reg_3__7_ u_mac16_top_opB_fifo_3__7_ VDD VSS u_mac16_top_net642 u_mac16_top_inB_par__7_ HFSNET_9 DFFRPQX0P5H9R
Xu_mac16_top_opB_fifo_reg_3__6_ u_mac16_top_opB_fifo_3__6_ VDD VSS u_mac16_top_net642 u_mac16_top_inB_par__6_ HFSNET_11 DFFRPQX0P5H9R
Xu_mac16_top_opB_fifo_reg_3__5_ u_mac16_top_opB_fifo_3__5_ VDD VSS u_mac16_top_net642 u_mac16_top_inB_par__5_ HFSNET_9 DFFRPQX0P5H9R
Xu_mac16_top_opB_fifo_reg_3__4_ u_mac16_top_opB_fifo_3__4_ VDD VSS u_mac16_top_net642 u_mac16_top_inB_par__4_ HFSNET_9 DFFRPQX0P5H9R
Xu_mac16_top_opB_fifo_reg_3__3_ u_mac16_top_opB_fifo_3__3_ VDD VSS u_mac16_top_net642 u_mac16_top_inB_par__3_ HFSNET_10 DFFRPQX0P5H9R
Xu_mac16_top_opB_fifo_reg_3__2_ u_mac16_top_opB_fifo_3__2_ VDD VSS u_mac16_top_net642 u_mac16_top_inB_par__2_ HFSNET_10 DFFRPQX0P5H9R
Xu_mac16_top_opB_fifo_reg_3__1_ u_mac16_top_opB_fifo_3__1_ VDD VSS u_mac16_top_net642 u_mac16_top_inB_par__1_ HFSNET_10 DFFRPQX0P5H9R
Xu_mac16_top_opB_fifo_reg_3__0_ u_mac16_top_opB_fifo_3__0_ VDD VSS u_mac16_top_net642 u_mac16_top_inB_par__0_ HFSNET_10 DFFRPQX0P5H9R
Xu_mac16_top_opB_fifo_reg_2__15_ u_mac16_top_opB_fifo_2__15_ VDD VSS u_mac16_top_net637 u_mac16_top_inB_par__15_ HFSNET_10 DFFRPQX0P5H9R
Xu_mac16_top_opB_fifo_reg_2__14_ u_mac16_top_opB_fifo_2__14_ VDD VSS u_mac16_top_net637 u_mac16_top_inB_par__14_ HFSNET_9 DFFRPQX0P5H9R
Xu_mac16_top_opB_fifo_reg_2__13_ u_mac16_top_opB_fifo_2__13_ VDD VSS u_mac16_top_net637 u_mac16_top_inB_par__13_ HFSNET_10 DFFRPQX0P5H9R
Xu_mac16_top_opB_fifo_reg_2__12_ u_mac16_top_opB_fifo_2__12_ VDD VSS u_mac16_top_net637 u_mac16_top_inB_par__12_ HFSNET_10 DFFRPQX0P5H9R
Xu_mac16_top_opB_fifo_reg_2__11_ u_mac16_top_opB_fifo_2__11_ VDD VSS u_mac16_top_net637 u_mac16_top_inB_par__11_ HFSNET_9 DFFRPQX0P5H9R
Xu_mac16_top_opB_fifo_reg_2__10_ u_mac16_top_opB_fifo_2__10_ VDD VSS u_mac16_top_net637 u_mac16_top_inB_par__10_ HFSNET_10 DFFRPQX0P5H9R
Xu_mac16_top_opB_fifo_reg_2__9_ u_mac16_top_opB_fifo_2__9_ VDD VSS u_mac16_top_net637 u_mac16_top_inB_par__9_ HFSNET_10 DFFRPQX0P5H9R
Xu_mac16_top_opB_fifo_reg_2__8_ u_mac16_top_opB_fifo_2__8_ VDD VSS u_mac16_top_net637 u_mac16_top_inB_par__8_ HFSNET_9 DFFRPQX0P5H9R
Xu_mac16_top_opB_fifo_reg_2__7_ u_mac16_top_opB_fifo_2__7_ VDD VSS u_mac16_top_net637 u_mac16_top_inB_par__7_ HFSNET_9 DFFRPQX0P5H9R
Xu_mac16_top_opB_fifo_reg_2__6_ u_mac16_top_opB_fifo_2__6_ VDD VSS u_mac16_top_net637 u_mac16_top_inB_par__6_ HFSNET_9 DFFRPQX0P5H9R
Xu_mac16_top_opB_fifo_reg_2__5_ u_mac16_top_opB_fifo_2__5_ VDD VSS u_mac16_top_net637 u_mac16_top_inB_par__5_ HFSNET_9 DFFRPQX0P5H9R
Xu_mac16_top_opB_fifo_reg_2__4_ u_mac16_top_opB_fifo_2__4_ VDD VSS u_mac16_top_net637 u_mac16_top_inB_par__4_ HFSNET_9 DFFRPQX0P5H9R
Xu_mac16_top_opB_fifo_reg_2__3_ u_mac16_top_opB_fifo_2__3_ VDD VSS u_mac16_top_net637 u_mac16_top_inB_par__3_ HFSNET_10 DFFRPQX0P5H9R
Xu_mac16_top_opB_fifo_reg_2__2_ u_mac16_top_opB_fifo_2__2_ VDD VSS u_mac16_top_net637 u_mac16_top_inB_par__2_ HFSNET_13 DFFRPQX0P5H9R
Xu_mac16_top_opB_fifo_reg_2__1_ u_mac16_top_opB_fifo_2__1_ VDD VSS u_mac16_top_net637 u_mac16_top_inB_par__1_ HFSNET_10 DFFRPQX0P5H9R
Xu_mac16_top_opB_fifo_reg_2__0_ u_mac16_top_opB_fifo_2__0_ VDD VSS u_mac16_top_net637 u_mac16_top_inB_par__0_ HFSNET_13 DFFRPQX0P5H9R
Xu_mac16_top_opB_fifo_reg_1__15_ u_mac16_top_opB_fifo_1__15_ VDD VSS u_mac16_top_net632 u_mac16_top_inB_par__15_ HFSNET_9 DFFRPQX0P5H9R
Xu_mac16_top_opB_fifo_reg_1__14_ u_mac16_top_opB_fifo_1__14_ VDD VSS u_mac16_top_net632 u_mac16_top_inB_par__14_ HFSNET_9 DFFRPQX0P5H9R
Xu_mac16_top_opB_fifo_reg_1__13_ u_mac16_top_opB_fifo_1__13_ VDD VSS u_mac16_top_net632 u_mac16_top_inB_par__13_ HFSNET_10 DFFRPQX0P5H9R
Xu_mac16_top_opB_fifo_reg_1__12_ u_mac16_top_opB_fifo_1__12_ VDD VSS u_mac16_top_net632 u_mac16_top_inB_par__12_ HFSNET_9 DFFRPQX0P5H9R
Xu_mac16_top_opB_fifo_reg_1__11_ u_mac16_top_opB_fifo_1__11_ VDD VSS u_mac16_top_net632 u_mac16_top_inB_par__11_ HFSNET_9 DFFRPQX0P5H9R
Xu_mac16_top_opB_fifo_reg_1__10_ u_mac16_top_opB_fifo_1__10_ VDD VSS u_mac16_top_net632 u_mac16_top_inB_par__10_ HFSNET_10 DFFRPQX0P5H9R
Xu_mac16_top_opB_fifo_reg_1__9_ u_mac16_top_opB_fifo_1__9_ VDD VSS u_mac16_top_net632 u_mac16_top_inB_par__9_ HFSNET_10 DFFRPQX0P5H9R
Xu_mac16_top_opB_fifo_reg_1__8_ u_mac16_top_opB_fifo_1__8_ VDD VSS u_mac16_top_net632 u_mac16_top_inB_par__8_ HFSNET_9 DFFRPQX0P5H9R
Xu_mac16_top_opB_fifo_reg_1__7_ u_mac16_top_opB_fifo_1__7_ VDD VSS u_mac16_top_net632 u_mac16_top_inB_par__7_ HFSNET_9 DFFRPQX0P5H9R
Xu_mac16_top_opB_fifo_reg_1__6_ u_mac16_top_opB_fifo_1__6_ VDD VSS u_mac16_top_net632 u_mac16_top_inB_par__6_ HFSNET_9 DFFRPQX0P5H9R
Xu_mac16_top_opB_fifo_reg_1__5_ u_mac16_top_opB_fifo_1__5_ VDD VSS u_mac16_top_net632 u_mac16_top_inB_par__5_ HFSNET_9 DFFRPQX0P5H9R
Xu_mac16_top_opB_fifo_reg_1__4_ u_mac16_top_opB_fifo_1__4_ VDD VSS u_mac16_top_net632 u_mac16_top_inB_par__4_ HFSNET_9 DFFRPQX0P5H9R
Xu_mac16_top_opB_fifo_reg_1__3_ u_mac16_top_opB_fifo_1__3_ VDD VSS u_mac16_top_net632 u_mac16_top_inB_par__3_ HFSNET_9 DFFRPQX0P5H9R
Xu_mac16_top_opB_fifo_reg_1__2_ u_mac16_top_opB_fifo_1__2_ VDD VSS u_mac16_top_net632 u_mac16_top_inB_par__2_ HFSNET_13 DFFRPQX0P5H9R
Xu_mac16_top_opB_fifo_reg_1__1_ u_mac16_top_opB_fifo_1__1_ VDD VSS u_mac16_top_net632 u_mac16_top_inB_par__1_ HFSNET_11 DFFRPQX0P5H9R
Xu_mac16_top_opB_fifo_reg_1__0_ u_mac16_top_opB_fifo_1__0_ VDD VSS u_mac16_top_net632 u_mac16_top_inB_par__0_ HFSNET_12 DFFRPQX0P5H9R
Xu_mac16_top_opB_fifo_reg_0__15_ u_mac16_top_opB_fifo_0__15_ VDD VSS u_mac16_top_net627 u_mac16_top_inB_par__15_ HFSNET_11 DFFRPQX0P5H9R
Xu_mac16_top_opB_fifo_reg_0__14_ u_mac16_top_opB_fifo_0__14_ VDD VSS u_mac16_top_net627 u_mac16_top_inB_par__14_ HFSNET_11 DFFRPQX0P5H9R
Xu_mac16_top_opB_reg_reg_14_ u_mac16_top_opB_reg__14_ VDD VSS u_mac16_top_net564 n787 HFSNET_14 DFFRPQX0P5H9R
Xu_mac16_top_opB_fifo_reg_0__13_ u_mac16_top_opB_fifo_0__13_ VDD VSS u_mac16_top_net627 u_mac16_top_inB_par__13_ HFSNET_11 DFFRPQX0P5H9R
Xu_mac16_top_opB_fifo_reg_0__12_ u_mac16_top_opB_fifo_0__12_ VDD VSS u_mac16_top_net627 u_mac16_top_inB_par__12_ HFSNET_11 DFFRPQX0P5H9R
Xu_mac16_top_opB_fifo_reg_0__11_ u_mac16_top_opB_fifo_0__11_ VDD VSS u_mac16_top_net627 u_mac16_top_inB_par__11_ HFSNET_11 DFFRPQX0P5H9R
Xu_mac16_top_opB_fifo_reg_0__10_ u_mac16_top_opB_fifo_0__10_ VDD VSS u_mac16_top_net627 u_mac16_top_inB_par__10_ HFSNET_11 DFFRPQX0P5H9R
Xu_mac16_top_opB_fifo_reg_0__9_ u_mac16_top_opB_fifo_0__9_ VDD VSS u_mac16_top_net627 u_mac16_top_inB_par__9_ HFSNET_13 DFFRPQX0P5H9R
Xu_mac16_top_opB_fifo_reg_0__8_ u_mac16_top_opB_fifo_0__8_ VDD VSS u_mac16_top_net627 u_mac16_top_inB_par__8_ HFSNET_11 DFFRPQX0P5H9R
Xu_mac16_top_opB_fifo_reg_0__7_ u_mac16_top_opB_fifo_0__7_ VDD VSS u_mac16_top_net627 u_mac16_top_inB_par__7_ HFSNET_11 DFFRPQX0P5H9R
Xu_mac16_top_opB_fifo_reg_0__6_ u_mac16_top_opB_fifo_0__6_ VDD VSS u_mac16_top_net627 u_mac16_top_inB_par__6_ HFSNET_11 DFFRPQX0P5H9R
Xu_mac16_top_opB_fifo_reg_0__5_ u_mac16_top_opB_fifo_0__5_ VDD VSS u_mac16_top_net627 u_mac16_top_inB_par__5_ HFSNET_12 DFFRPQX0P5H9R
Xu_mac16_top_opB_fifo_reg_0__4_ u_mac16_top_opB_fifo_0__4_ VDD VSS u_mac16_top_net627 u_mac16_top_inB_par__4_ HFSNET_12 DFFRPQX0P5H9R
Xu_mac16_top_opB_fifo_reg_0__3_ u_mac16_top_opB_fifo_0__3_ VDD VSS u_mac16_top_net627 u_mac16_top_inB_par__3_ HFSNET_13 DFFRPQX0P5H9R
Xu_mac16_top_opB_fifo_reg_0__2_ u_mac16_top_opB_fifo_0__2_ VDD VSS u_mac16_top_net627 u_mac16_top_inB_par__2_ HFSNET_13 DFFRPQX0P5H9R
Xu_mac16_top_opB_fifo_reg_0__1_ u_mac16_top_opB_fifo_0__1_ VDD VSS u_mac16_top_net627 u_mac16_top_inB_par__1_ HFSNET_13 DFFRPQX0P5H9R
Xu_mac16_top_opB_fifo_reg_0__0_ u_mac16_top_opB_fifo_0__0_ VDD VSS u_mac16_top_net627 u_mac16_top_inB_par__0_ HFSNET_13 DFFRPQX0P5H9R
Xu_mac16_top_u_inA_data_out_reg_0_ u_mac16_top_inA_par__0_ VDD VSS u_mac16_top_u_inA_net803 inA HFSNET_13 DFFRPQX0P5H9R
Xu_mac16_top_opA_fifo_reg_0__0_ u_mac16_top_opA_fifo_0__0_ VDD VSS u_mac16_top_net627 u_mac16_top_inA_par__0_ HFSNET_13 DFFRPQX0P5H9R
Xu_mac16_top_opA_fifo_reg_1__0_ u_mac16_top_opA_fifo_1__0_ VDD VSS u_mac16_top_net632 u_mac16_top_inA_par__0_ HFSNET_13 DFFRPQX0P5H9R
Xu_mac16_top_opA_fifo_reg_2__0_ u_mac16_top_opA_fifo_2__0_ VDD VSS u_mac16_top_net637 u_mac16_top_inA_par__0_ HFSNET_13 DFFRPQX0P5H9R
Xu_mac16_top_opA_fifo_reg_3__0_ u_mac16_top_opA_fifo_3__0_ VDD VSS u_mac16_top_net642 u_mac16_top_inA_par__0_ HFSNET_13 DFFRPQX0P5H9R
Xu_mac16_top_u_inA_cnt_reg_0_ u_mac16_top_u_inA_cnt__0_ VDD VSS clk u_mac16_top_u_inA_N49 HFSNET_32 DFFRPQX0P5H9R
Xu_mac16_top_u_inA_cnt_reg_1_ u_mac16_top_u_inA_cnt__1_ VDD VSS clk u_mac16_top_u_inA_N50 HFSNET_16 DFFRPQX0P5H9R
Xu_mac16_top_u_inA_cnt_reg_2_ u_mac16_top_u_inA_cnt__2_ VDD VSS clk u_mac16_top_u_inA_N51 HFSNET_32 DFFRPQX0P5H9R
Xu_mac16_top_u_inA_cnt_reg_3_ u_mac16_top_u_inA_cnt__3_ VDD VSS clk u_mac16_top_u_inA_N52 HFSNET_16 DFFRPQX0P5H9R
Xu_mac16_top_u_inA_shift_reg_reg_0_ u_mac16_top_u_inA_shift_reg__0_ VDD VSS clk u_mac16_top_u_inA_N33 HFSNET_27 DFFRPQX0P5H9R
Xu_mac16_top_u_inA_data_out_reg_1_ u_mac16_top_inA_par__1_ VDD VSS u_mac16_top_u_inA_net803 copt_net_74 HFSNET_27 DFFRPQX0P5H9R
Xu_mac16_top_opA_fifo_reg_0__1_ u_mac16_top_opA_fifo_0__1_ VDD VSS u_mac16_top_net627 u_mac16_top_inA_par__1_ HFSNET_13 DFFRPQX0P5H9R
Xu_mac16_top_opA_fifo_reg_1__1_ u_mac16_top_opA_fifo_1__1_ VDD VSS u_mac16_top_net632 u_mac16_top_inA_par__1_ HFSNET_13 DFFRPQX0P5H9R
Xu_mac16_top_opA_fifo_reg_2__1_ u_mac16_top_opA_fifo_2__1_ VDD VSS u_mac16_top_net637 u_mac16_top_inA_par__1_ HFSNET_13 DFFRPQX0P5H9R
Xu_mac16_top_opA_fifo_reg_3__1_ u_mac16_top_opA_fifo_3__1_ VDD VSS u_mac16_top_net642 u_mac16_top_inA_par__1_ HFSNET_12 DFFRPQX0P5H9R
Xu_mac16_top_u_inA_shift_reg_reg_1_ u_mac16_top_u_inA_shift_reg__1_ VDD VSS clk u_mac16_top_u_inA_N34 HFSNET_27 DFFRPQX0P5H9R
Xu_mac16_top_u_inA_data_out_reg_2_ u_mac16_top_inA_par__2_ VDD VSS u_mac16_top_u_inA_net803 copt_net_85 HFSNET_27 DFFRPQX0P5H9R
Xu_mac16_top_opA_fifo_reg_0__2_ u_mac16_top_opA_fifo_0__2_ VDD VSS u_mac16_top_net627 u_mac16_top_inA_par__2_ HFSNET_12 DFFRPQX0P5H9R
Xu_mac16_top_opA_fifo_reg_1__2_ u_mac16_top_opA_fifo_1__2_ VDD VSS u_mac16_top_net632 u_mac16_top_inA_par__2_ HFSNET_12 DFFRPQX0P5H9R
Xu_mac16_top_opA_fifo_reg_2__2_ u_mac16_top_opA_fifo_2__2_ VDD VSS u_mac16_top_net637 u_mac16_top_inA_par__2_ HFSNET_12 DFFRPQX0P5H9R
Xu_mac16_top_opA_fifo_reg_3__2_ u_mac16_top_opA_fifo_3__2_ VDD VSS u_mac16_top_net642 u_mac16_top_inA_par__2_ HFSNET_12 DFFRPQX0P5H9R
Xu_mac16_top_u_inA_shift_reg_reg_2_ u_mac16_top_u_inA_shift_reg__2_ VDD VSS clk u_mac16_top_u_inA_N35 HFSNET_27 DFFRPQX0P5H9R
Xu_mac16_top_u_inA_data_out_reg_3_ u_mac16_top_inA_par__3_ VDD VSS u_mac16_top_u_inA_net803 copt_net_72 HFSNET_27 DFFRPQX0P5H9R
Xu_mac16_top_opA_fifo_reg_0__3_ u_mac16_top_opA_fifo_0__3_ VDD VSS u_mac16_top_net627 u_mac16_top_inA_par__3_ HFSNET_12 DFFRPQX0P5H9R
Xu_mac16_top_opA_fifo_reg_1__3_ u_mac16_top_opA_fifo_1__3_ VDD VSS u_mac16_top_net632 u_mac16_top_inA_par__3_ HFSNET_12 DFFRPQX0P5H9R
Xu_mac16_top_opA_fifo_reg_2__3_ u_mac16_top_opA_fifo_2__3_ VDD VSS u_mac16_top_net637 u_mac16_top_inA_par__3_ HFSNET_12 DFFRPQX0P5H9R
Xu_mac16_top_opA_fifo_reg_3__3_ u_mac16_top_opA_fifo_3__3_ VDD VSS u_mac16_top_net642 u_mac16_top_inA_par__3_ HFSNET_12 DFFRPQX0P5H9R
Xu_mac16_top_u_inA_shift_reg_reg_3_ u_mac16_top_u_inA_shift_reg__3_ VDD VSS clk u_mac16_top_u_inA_N36 HFSNET_13 DFFRPQX0P5H9R
Xu_mac16_top_u_inA_data_out_reg_4_ u_mac16_top_inA_par__4_ VDD VSS u_mac16_top_u_inA_net803 copt_net_87 HFSNET_7 DFFRPQX0P5H9R
Xu_mac16_top_opA_fifo_reg_0__4_ u_mac16_top_opA_fifo_0__4_ VDD VSS u_mac16_top_net627 u_mac16_top_inA_par__4_ HFSNET_12 DFFRPQX0P5H9R
Xu_mac16_top_opA_fifo_reg_1__4_ u_mac16_top_opA_fifo_1__4_ VDD VSS u_mac16_top_net632 u_mac16_top_inA_par__4_ HFSNET_7 DFFRPQX0P5H9R
Xu_mac16_top_opA_fifo_reg_2__4_ u_mac16_top_opA_fifo_2__4_ VDD VSS u_mac16_top_net637 u_mac16_top_inA_par__4_ HFSNET_12 DFFRPQX0P5H9R
Xu_mac16_top_opA_fifo_reg_3__4_ u_mac16_top_opA_fifo_3__4_ VDD VSS u_mac16_top_net642 u_mac16_top_inA_par__4_ HFSNET_12 DFFRPQX0P5H9R
Xu_mac16_top_u_inA_shift_reg_reg_4_ u_mac16_top_u_inA_shift_reg__4_ VDD VSS clk u_mac16_top_u_inA_N37 HFSNET_27 DFFRPQX0P5H9R
Xu_mac16_top_u_inA_data_out_reg_5_ u_mac16_top_inA_par__5_ VDD VSS u_mac16_top_u_inA_net803 copt_net_71 HFSNET_27 DFFRPQX0P5H9R
Xu_mac16_top_opA_fifo_reg_0__5_ u_mac16_top_opA_fifo_0__5_ VDD VSS u_mac16_top_net627 u_mac16_top_inA_par__5_ HFSNET_12 DFFRPQX0P5H9R
Xu_mac16_top_opA_fifo_reg_1__5_ u_mac16_top_opA_fifo_1__5_ VDD VSS u_mac16_top_net632 u_mac16_top_inA_par__5_ HFSNET_12 DFFRPQX0P5H9R
Xu_mac16_top_opA_fifo_reg_2__5_ u_mac16_top_opA_fifo_2__5_ VDD VSS u_mac16_top_net637 u_mac16_top_inA_par__5_ HFSNET_14 DFFRPQX0P5H9R
Xu_mac16_top_opA_fifo_reg_3__5_ u_mac16_top_opA_fifo_3__5_ VDD VSS u_mac16_top_net642 u_mac16_top_inA_par__5_ HFSNET_11 DFFRPQX0P5H9R
Xu_mac16_top_u_inA_shift_reg_reg_5_ u_mac16_top_u_inA_shift_reg__5_ VDD VSS clk u_mac16_top_u_inA_N38 HFSNET_27 DFFRPQX0P5H9R
Xu_mac16_top_u_inA_data_out_reg_6_ u_mac16_top_inA_par__6_ VDD VSS u_mac16_top_u_inA_net803 copt_net_83 HFSNET_27 DFFRPQX0P5H9R
Xu_mac16_top_opA_fifo_reg_0__6_ u_mac16_top_opA_fifo_0__6_ VDD VSS u_mac16_top_net627 u_mac16_top_inA_par__6_ HFSNET_12 DFFRPQX0P5H9R
Xu_mac16_top_opA_fifo_reg_1__6_ u_mac16_top_opA_fifo_1__6_ VDD VSS u_mac16_top_net632 u_mac16_top_inA_par__6_ HFSNET_12 DFFRPQX0P5H9R
Xu_mac16_top_opA_fifo_reg_2__6_ u_mac16_top_opA_fifo_2__6_ VDD VSS u_mac16_top_net637 u_mac16_top_inA_par__6_ HFSNET_12 DFFRPQX0P5H9R
Xu_mac16_top_opA_fifo_reg_3__6_ u_mac16_top_opA_fifo_3__6_ VDD VSS u_mac16_top_net642 u_mac16_top_inA_par__6_ HFSNET_12 DFFRPQX0P5H9R
Xu_mac16_top_u_inA_shift_reg_reg_6_ u_mac16_top_u_inA_shift_reg__6_ VDD VSS clk u_mac16_top_u_inA_N39 HFSNET_27 DFFRPQX0P5H9R
Xu_mac16_top_u_inA_data_out_reg_7_ u_mac16_top_inA_par__7_ VDD VSS u_mac16_top_u_inA_net803 copt_net_92 HFSNET_7 DFFRPQX0P5H9R
Xu_mac16_top_opA_fifo_reg_0__7_ u_mac16_top_opA_fifo_0__7_ VDD VSS u_mac16_top_net627 u_mac16_top_inA_par__7_ HFSNET_7 DFFRPQX0P5H9R
Xu_mac16_top_opA_fifo_reg_1__7_ u_mac16_top_opA_fifo_1__7_ VDD VSS u_mac16_top_net632 u_mac16_top_inA_par__7_ HFSNET_7 DFFRPQX0P5H9R
Xu_mac16_top_opA_fifo_reg_2__7_ u_mac16_top_opA_fifo_2__7_ VDD VSS u_mac16_top_net637 u_mac16_top_inA_par__7_ HFSNET_12 DFFRPQX0P5H9R
Xu_mac16_top_opA_fifo_reg_3__7_ u_mac16_top_opA_fifo_3__7_ VDD VSS u_mac16_top_net642 u_mac16_top_inA_par__7_ HFSNET_7 DFFRPQX0P5H9R
Xu_mac16_top_u_inA_shift_reg_reg_7_ u_mac16_top_u_inA_shift_reg__7_ VDD VSS clk u_mac16_top_u_inA_N40 HFSNET_27 DFFRPQX0P5H9R
Xu_mac16_top_u_inA_data_out_reg_8_ u_mac16_top_inA_par__8_ VDD VSS u_mac16_top_u_inA_net803 copt_net_91 HFSNET_27 DFFRPQX0P5H9R
Xu_mac16_top_opA_fifo_reg_0__8_ u_mac16_top_opA_fifo_0__8_ VDD VSS u_mac16_top_net627 u_mac16_top_inA_par__8_ HFSNET_7 DFFRPQX0P5H9R
Xu_mac16_top_opA_fifo_reg_1__8_ u_mac16_top_opA_fifo_1__8_ VDD VSS u_mac16_top_net632 u_mac16_top_inA_par__8_ HFSNET_7 DFFRPQX0P5H9R
Xu_mac16_top_opA_fifo_reg_2__8_ u_mac16_top_opA_fifo_2__8_ VDD VSS u_mac16_top_net637 u_mac16_top_inA_par__8_ HFSNET_7 DFFRPQX0P5H9R
Xu_mac16_top_opA_fifo_reg_3__8_ u_mac16_top_opA_fifo_3__8_ VDD VSS u_mac16_top_net642 u_mac16_top_inA_par__8_ HFSNET_7 DFFRPQX0P5H9R
Xu_mac16_top_u_inA_shift_reg_reg_8_ u_mac16_top_u_inA_shift_reg__8_ VDD VSS clk u_mac16_top_u_inA_N41 HFSNET_1 DFFRPQX0P5H9R
Xu_mac16_top_u_inA_data_out_reg_9_ u_mac16_top_inA_par__9_ VDD VSS u_mac16_top_u_inA_net803 copt_net_77 HFSNET_27 DFFRPQX0P5H9R
Xu_mac16_top_opA_fifo_reg_0__9_ u_mac16_top_opA_fifo_0__9_ VDD VSS u_mac16_top_net627 u_mac16_top_inA_par__9_ HFSNET_7 DFFRPQX0P5H9R
Xu_mac16_top_opA_fifo_reg_1__9_ u_mac16_top_opA_fifo_1__9_ VDD VSS u_mac16_top_net632 u_mac16_top_inA_par__9_ HFSNET_14 DFFRPQX0P5H9R
Xu_mac16_top_opA_fifo_reg_2__9_ u_mac16_top_opA_fifo_2__9_ VDD VSS u_mac16_top_net637 u_mac16_top_inA_par__9_ HFSNET_14 DFFRPQX0P5H9R
Xu_mac16_top_opA_fifo_reg_3__9_ u_mac16_top_opA_fifo_3__9_ VDD VSS u_mac16_top_net642 u_mac16_top_inA_par__9_ HFSNET_7 DFFRPQX0P5H9R
Xu_mac16_top_u_inA_shift_reg_reg_9_ u_mac16_top_u_inA_shift_reg__9_ VDD VSS clk u_mac16_top_u_inA_N42 HFSNET_1 DFFRPQX0P5H9R
Xu_mac16_top_u_inA_data_out_reg_10_ u_mac16_top_inA_par__10_ VDD VSS u_mac16_top_u_inA_net803 copt_net_84 HFSNET_7 DFFRPQX0P5H9R
Xu_mac16_top_opA_fifo_reg_0__10_ u_mac16_top_opA_fifo_0__10_ VDD VSS u_mac16_top_net627 u_mac16_top_inA_par__10_ HFSNET_12 DFFRPQX0P5H9R
Xu_mac16_top_opA_fifo_reg_1__10_ u_mac16_top_opA_fifo_1__10_ VDD VSS u_mac16_top_net632 u_mac16_top_inA_par__10_ HFSNET_12 DFFRPQX0P5H9R
Xu_mac16_top_opA_fifo_reg_2__10_ u_mac16_top_opA_fifo_2__10_ VDD VSS u_mac16_top_net637 u_mac16_top_inA_par__10_ HFSNET_7 DFFRPQX0P5H9R
Xu_mac16_top_opA_fifo_reg_3__10_ u_mac16_top_opA_fifo_3__10_ VDD VSS u_mac16_top_net642 u_mac16_top_inA_par__10_ HFSNET_8 DFFRPQX0P5H9R
Xu_mac16_top_u_inA_shift_reg_reg_10_ u_mac16_top_u_inA_shift_reg__10_ VDD VSS clk u_mac16_top_u_inA_N43 HFSNET_1 DFFRPQX0P5H9R
Xu_mac16_top_u_inA_data_out_reg_11_ u_mac16_top_inA_par__11_ VDD VSS u_mac16_top_u_inA_net803 copt_net_80 HFSNET_1 DFFRPQX0P5H9R
Xu_mac16_top_opA_fifo_reg_0__11_ u_mac16_top_opA_fifo_0__11_ VDD VSS u_mac16_top_net627 u_mac16_top_inA_par__11_ HFSNET_12 DFFRPQX0P5H9R
Xu_mac16_top_opA_fifo_reg_1__11_ u_mac16_top_opA_fifo_1__11_ VDD VSS u_mac16_top_net632 u_mac16_top_inA_par__11_ HFSNET_7 DFFRPQX0P5H9R
Xu_mac16_top_opA_fifo_reg_2__11_ u_mac16_top_opA_fifo_2__11_ VDD VSS u_mac16_top_net637 u_mac16_top_inA_par__11_ HFSNET_7 DFFRPQX0P5H9R
Xu_mac16_top_opA_fifo_reg_3__11_ u_mac16_top_opA_fifo_3__11_ VDD VSS u_mac16_top_net642 u_mac16_top_inA_par__11_ HFSNET_8 DFFRPQX0P5H9R
Xu_mac16_top_u_inA_shift_reg_reg_11_ u_mac16_top_u_inA_shift_reg__11_ VDD VSS clk u_mac16_top_u_inA_N44 HFSNET_27 DFFRPQX0P5H9R
Xu_mac16_top_u_inA_data_out_reg_12_ u_mac16_top_inA_par__12_ VDD VSS u_mac16_top_u_inA_net803 copt_net_79 HFSNET_27 DFFRPQX0P5H9R
Xu_mac16_top_opA_fifo_reg_0__12_ u_mac16_top_opA_fifo_0__12_ VDD VSS u_mac16_top_net627 u_mac16_top_inA_par__12_ HFSNET_14 DFFRPQX0P5H9R
Xu_mac16_top_opA_fifo_reg_1__12_ u_mac16_top_opA_fifo_1__12_ VDD VSS u_mac16_top_net632 u_mac16_top_inA_par__12_ HFSNET_14 DFFRPQX0P5H9R
Xu_mac16_top_opA_fifo_reg_2__12_ u_mac16_top_opA_fifo_2__12_ VDD VSS u_mac16_top_net637 u_mac16_top_inA_par__12_ HFSNET_14 DFFRPQX0P5H9R
Xu_mac16_top_opA_fifo_reg_3__12_ u_mac16_top_opA_fifo_3__12_ VDD VSS u_mac16_top_net642 u_mac16_top_inA_par__12_ HFSNET_14 DFFRPQX0P5H9R
Xu_mac16_top_u_inA_shift_reg_reg_12_ u_mac16_top_u_inA_shift_reg__12_ VDD VSS clk u_mac16_top_u_inA_N45 HFSNET_27 DFFRPQX0P5H9R
Xu_mac16_top_u_inA_data_out_reg_13_ u_mac16_top_inA_par__13_ VDD VSS u_mac16_top_u_inA_net803 copt_net_88 HFSNET_7 DFFRPQX0P5H9R
Xu_mac16_top_opA_fifo_reg_0__13_ u_mac16_top_opA_fifo_0__13_ VDD VSS u_mac16_top_net627 u_mac16_top_inA_par__13_ HFSNET_14 DFFRPQX0P5H9R
Xu_mac16_top_opA_fifo_reg_1__13_ u_mac16_top_opA_fifo_1__13_ VDD VSS u_mac16_top_net632 u_mac16_top_inA_par__13_ HFSNET_14 DFFRPQX0P5H9R
Xu_mac16_top_opA_fifo_reg_2__13_ u_mac16_top_opA_fifo_2__13_ VDD VSS u_mac16_top_net637 u_mac16_top_inA_par__13_ HFSNET_14 DFFRPQX0P5H9R
Xu_mac16_top_opA_fifo_reg_3__13_ u_mac16_top_opA_fifo_3__13_ VDD VSS u_mac16_top_net642 u_mac16_top_inA_par__13_ HFSNET_14 DFFRPQX0P5H9R
Xu_mac16_top_u_inA_shift_reg_reg_13_ u_mac16_top_u_inA_shift_reg__13_ VDD VSS clk u_mac16_top_u_inA_N46 HFSNET_1 DFFRPQX0P5H9R
Xu_mac16_top_u_inA_data_out_reg_14_ u_mac16_top_inA_par__14_ VDD VSS u_mac16_top_u_inA_net803 copt_net_75 HFSNET_7 DFFRPQX0P5H9R
Xu_mac16_top_opA_fifo_reg_0__14_ u_mac16_top_opA_fifo_0__14_ VDD VSS u_mac16_top_net627 u_mac16_top_inA_par__14_ HFSNET_14 DFFRPQX0P5H9R
Xu_mac16_top_opA_fifo_reg_1__14_ u_mac16_top_opA_fifo_1__14_ VDD VSS u_mac16_top_net632 u_mac16_top_inA_par__14_ HFSNET_14 DFFRPQX0P5H9R
Xu_mac16_top_opA_fifo_reg_2__14_ u_mac16_top_opA_fifo_2__14_ VDD VSS u_mac16_top_net637 u_mac16_top_inA_par__14_ HFSNET_14 DFFRPQX0P5H9R
Xu_mac16_top_opA_fifo_reg_3__14_ u_mac16_top_opA_fifo_3__14_ VDD VSS u_mac16_top_net642 u_mac16_top_inA_par__14_ HFSNET_14 DFFRPQX0P5H9R
Xu_mac16_top_u_inA_shift_reg_reg_14_ u_mac16_top_u_inA_shift_reg__14_ VDD VSS clk u_mac16_top_u_inA_N47 HFSNET_1 DFFRPQX0P5H9R
Xu_mac16_top_u_inA_data_out_reg_15_ u_mac16_top_inA_par__15_ VDD VSS u_mac16_top_u_inA_net803 copt_net_69 HFSNET_7 DFFRPQX0P5H9R
Xu_mac16_top_opA_fifo_reg_0__15_ u_mac16_top_opA_fifo_0__15_ VDD VSS u_mac16_top_net627 u_mac16_top_inA_par__15_ HFSNET_7 DFFRPQX0P5H9R
Xu_mac16_top_opA_fifo_reg_1__15_ u_mac16_top_opA_fifo_1__15_ VDD VSS u_mac16_top_net632 u_mac16_top_inA_par__15_ HFSNET_7 DFFRPQX0P5H9R
Xu_mac16_top_opA_fifo_reg_2__15_ u_mac16_top_opA_fifo_2__15_ VDD VSS u_mac16_top_net637 u_mac16_top_inA_par__15_ HFSNET_7 DFFRPQX0P5H9R
Xu_mac16_top_opA_fifo_reg_3__15_ u_mac16_top_opA_fifo_3__15_ VDD VSS u_mac16_top_net642 u_mac16_top_inA_par__15_ HFSNET_7 DFFRPQX0P5H9R
Xu_mac16_top_u_mac_u_mul_r_c22_reg_12_ u_mac16_top_u_mac_u_mul_r_c22__12_ VDD VSS u_mac16_top_u_mac_u_mul_net731 u_mac16_top_u_mac_u_mul_st2_2_gen_csa_fa_11__u_fa_N1 HFSNET_5 DFFRPQX0P5H9R
Xu_mac16_top_u_mac_u_mul_r_c22_reg_13_ u_mac16_top_u_mac_u_mul_r_c22__13_ VDD VSS u_mac16_top_u_mac_u_mul_net731 u_mac16_top_u_mac_u_mul_c22__13_ HFSNET_5 DFFRPQX0P5H9R
Xu_mac16_top_u_mac_u_mul_r_c22_reg_14_ u_mac16_top_u_mac_u_mul_r_c22__14_ VDD VSS u_mac16_top_u_mac_u_mul_net731 u_mac16_top_u_mac_u_mul_c22__14_ HFSNET_5 DFFRPQX0P5H9R
Xu_mac16_top_u_mac_u_mul_r_c22_reg_15_ u_mac16_top_u_mac_u_mul_r_c22__15_ VDD VSS u_mac16_top_u_mac_u_mul_net731 u_mac16_top_u_mac_u_mul_c22__15_ HFSNET_5 DFFRPQX0P5H9R
Xu_mac16_top_u_mac_u_mul_r_c22_reg_16_ u_mac16_top_u_mac_u_mul_r_c22__16_ VDD VSS u_mac16_top_u_mac_u_mul_net731 u_mac16_top_u_mac_u_mul_c22__16_ HFSNET_2 DFFRPQX0P5H9R
Xu_mac16_top_u_mac_u_mul_r_c22_reg_17_ u_mac16_top_u_mac_u_mul_r_c22__17_ VDD VSS u_mac16_top_u_mac_u_mul_net736 u_mac16_top_u_mac_u_mul_c22__17_ HFSNET_2 DFFRPQX0P5H9R
Xu_mac16_top_u_mac_u_mul_r_c22_reg_18_ u_mac16_top_u_mac_u_mul_r_c22__18_ VDD VSS u_mac16_top_u_mac_u_mul_net731 u_mac16_top_u_mac_u_mul_c22__18_ HFSNET_5 DFFRPQX0P5H9R
Xu_mac16_top_u_mac_u_mul_r_c22_reg_19_ u_mac16_top_u_mac_u_mul_r_c22__19_ VDD VSS u_mac16_top_u_mac_u_mul_net731 u_mac16_top_u_mac_u_mul_c22__19_ HFSNET_2 DFFRPQX0P5H9R
Xu_mac16_top_u_mac_u_mul_r_c22_reg_20_ u_mac16_top_u_mac_u_mul_r_c22__20_ VDD VSS u_mac16_top_u_mac_u_mul_net731 u_mac16_top_u_mac_u_mul_c22__20_ HFSNET_2 DFFRPQX0P5H9R
Xu_mac16_top_u_mac_u_mul_r_c22_reg_21_ u_mac16_top_u_mac_u_mul_r_c22__21_ VDD VSS u_mac16_top_u_mac_u_mul_net731 u_mac16_top_u_mac_u_mul_c22__21_ HFSNET_5 DFFRPQX0P5H9R
Xu_mac16_top_u_mac_u_mul_r_c22_reg_22_ u_mac16_top_u_mac_u_mul_r_c22__22_ VDD VSS u_mac16_top_u_mac_u_mul_net731 u_mac16_top_u_mac_u_mul_c22__22_ HFSNET_5 DFFRPQX0P5H9R
Xu_mac16_top_u_mac_u_mul_r_c22_reg_23_ u_mac16_top_u_mac_u_mul_r_c22__23_ VDD VSS u_mac16_top_u_mac_u_mul_net731 u_mac16_top_u_mac_u_mul_c22__23_ HFSNET_5 DFFRPQX0P5H9R
Xu_mac16_top_u_mac_u_mul_r_s22_reg_9_ u_mac16_top_u_mac_u_mul_r_s22__9_ VDD VSS u_mac16_top_u_mac_u_mul_net741 u_mac16_top_u_mac_u_mul_pp_9__9_ HFSNET_5 DFFRPQX0P5H9R
Xu_mac16_top_u_mac_u_mul_r_s22_reg_10_ u_mac16_top_u_mac_u_mul_r_s22__10_ VDD VSS u_mac16_top_u_mac_u_mul_net741 u_mac16_top_u_mac_u_mul_st1_3_gen_csa_fa_10__u_fa_N0 HFSNET_5 DFFRPQX0P5H9R
Xu_mac16_top_u_mac_u_mul_r_s22_reg_11_ u_mac16_top_u_mac_u_mul_r_s22__11_ VDD VSS u_mac16_top_u_mac_u_mul_net741 n772 HFSNET_5 DFFRPQX0P5H9R
Xu_mac16_top_u_mac_u_mul_r_s22_reg_12_ u_mac16_top_u_mac_u_mul_r_s22__12_ VDD VSS u_mac16_top_u_mac_u_mul_net741 n771 HFSNET_5 DFFRPQX0P5H9R
Xu_mac16_top_u_mac_u_mul_r_c21_reg_7_ u_mac16_top_u_mac_u_mul_r_c21__7_ VDD VSS u_mac16_top_u_mac_u_mul_net736 u_mac16_top_u_mac_u_mul_st2_1_gen_csa_fa_6__u_fa_N1 HFSNET_3 DFFRPQX0P5H9R
Xu_mac16_top_u_mac_u_mul_r_c21_reg_8_ u_mac16_top_u_mac_u_mul_r_c21__8_ VDD VSS u_mac16_top_u_mac_u_mul_net736 u_mac16_top_u_mac_u_mul_st2_1_gen_csa_fa_7__u_fa_N1 HFSNET_2 DFFRPQX0P5H9R
Xu_mac16_top_u_mac_u_mul_r_c21_reg_9_ u_mac16_top_u_mac_u_mul_r_c21__9_ VDD VSS u_mac16_top_u_mac_u_mul_net736 u_mac16_top_u_mac_u_mul_c21__9_ HFSNET_1 DFFRPQX0P5H9R
Xu_mac16_top_u_mac_u_mul_r_c21_reg_10_ u_mac16_top_u_mac_u_mul_r_c21__10_ VDD VSS u_mac16_top_u_mac_u_mul_net736 u_mac16_top_u_mac_u_mul_c21__10_ HFSNET_2 DFFRPQX0P5H9R
Xu_mac16_top_u_mac_u_mul_r_c21_reg_11_ u_mac16_top_u_mac_u_mul_r_c21__11_ VDD VSS u_mac16_top_u_mac_u_mul_net736 u_mac16_top_u_mac_u_mul_c21__11_ HFSNET_2 DFFRPQX0P5H9R
Xu_mac16_top_u_mac_u_mul_r_c21_reg_12_ u_mac16_top_u_mac_u_mul_r_c21__12_ VDD VSS u_mac16_top_u_mac_u_mul_net736 u_mac16_top_u_mac_u_mul_c21__12_ HFSNET_2 DFFRPQX0P5H9R
Xu_mac16_top_u_mac_u_mul_r_c21_reg_13_ u_mac16_top_u_mac_u_mul_r_c21__13_ VDD VSS u_mac16_top_u_mac_u_mul_net736 u_mac16_top_u_mac_u_mul_c21__13_ HFSNET_2 DFFRPQX0P5H9R
Xu_mac16_top_u_mac_u_mul_r_c21_reg_14_ u_mac16_top_u_mac_u_mul_r_c21__14_ VDD VSS u_mac16_top_u_mac_u_mul_net736 u_mac16_top_u_mac_u_mul_c21__14_ HFSNET_2 DFFRPQX0P5H9R
Xu_mac16_top_u_mac_u_mul_r_c21_reg_15_ u_mac16_top_u_mac_u_mul_r_c21__15_ VDD VSS u_mac16_top_u_mac_u_mul_net736 u_mac16_top_u_mac_u_mul_c21__15_ HFSNET_2 DFFRPQX0P5H9R
Xu_mac16_top_u_mac_u_mul_r_c21_reg_16_ u_mac16_top_u_mac_u_mul_r_c21__16_ VDD VSS u_mac16_top_u_mac_u_mul_net736 u_mac16_top_u_mac_u_mul_c21__16_ HFSNET_6 DFFRPQX0P5H9R
Xu_mac16_top_u_mac_u_mul_r_c21_reg_17_ u_mac16_top_u_mac_u_mul_r_c21__17_ VDD VSS u_mac16_top_u_mac_u_mul_net736 u_mac16_top_u_mac_u_mul_c21__17_ HFSNET_6 DFFRPQX0P5H9R
Xu_mac16_top_u_mac_u_mul_r_c21_reg_18_ u_mac16_top_u_mac_u_mul_r_c21__18_ VDD VSS u_mac16_top_u_mac_u_mul_net736 u_mac16_top_u_mac_u_mul_c21__18_ HFSNET_6 DFFRPQX0P5H9R
Xu_mac16_top_u_mac_u_mul_r_c21_reg_19_ u_mac16_top_u_mac_u_mul_r_c21__19_ VDD VSS u_mac16_top_u_mac_u_mul_net736 u_mac16_top_u_mac_u_mul_c21__19_ HFSNET_6 DFFRPQX0P5H9R
Xu_mac16_top_u_mac_u_mul_r_c21_reg_20_ u_mac16_top_u_mac_u_mul_r_c21__20_ VDD VSS u_mac16_top_u_mac_u_mul_net736 u_mac16_top_u_mac_u_mul_c21__20_ HFSNET_6 DFFRPQX0P5H9R
Xu_mac16_top_u_mac_u_mul_r_c21_reg_21_ u_mac16_top_u_mac_u_mul_r_c21__21_ VDD VSS u_mac16_top_u_mac_u_mul_net736 u_mac16_top_u_mac_u_mul_c21__21_ HFSNET_6 DFFRPQX0P5H9R
Xu_mac16_top_u_mac_u_mul_r_c21_reg_22_ u_mac16_top_u_mac_u_mul_r_c21__22_ VDD VSS u_mac16_top_u_mac_u_mul_net736 u_mac16_top_u_mac_u_mul_st2_1_gen_csa_fa_21__u_fa_N4 HFSNET_6 DFFRPQX0P5H9R
Xu_mac16_top_u_mac_u_mul_r_c21_reg_23_ u_mac16_top_u_mac_u_mul_r_c21__23_ VDD VSS u_mac16_top_u_mac_u_mul_net736 u_mac16_top_u_mac_u_mul_st2_1_gen_csa_fa_22__u_fa_N4 HFSNET_6 DFFRPQX0P5H9R
Xu_mac16_top_u_mac_u_mul_r_s21_reg_5_ u_mac16_top_u_mac_u_mul_r_s21__5_ VDD VSS u_mac16_top_u_mac_u_mul_net731 u_mac16_top_u_mac_u_mul_st1_1_gen_csa_fa_4__u_fa_N1 HFSNET_2 DFFRPQX0P5H9R
Xu_mac16_top_u_mac_u_mul_r_s21_reg_6_ u_mac16_top_u_mac_u_mul_r_s21__6_ VDD VSS u_mac16_top_u_mac_u_mul_net731 u_mac16_top_u_mac_u_mul_st2_1_gen_csa_fa_6__u_fa_N0 HFSNET_2 DFFRPQX0P5H9R
Xu_mac16_top_u_mac_u_mul_r_s21_reg_7_ u_mac16_top_u_mac_u_mul_r_s21__7_ VDD VSS u_mac16_top_u_mac_u_mul_net731 n758 HFSNET_6 DFFRPQX0P5H9R
Xu_mac16_top_u_mac_u_mul_r_s21_reg_8_ u_mac16_top_u_mac_u_mul_r_s21__8_ VDD VSS u_mac16_top_u_mac_u_mul_net731 u_mac16_top_u_mac_u_mul_s21__8_ HFSNET_6 DFFRPQX0P5H9R
Xu_mac16_top_u_mac_u_mul_r_s21_reg_14_ u_mac16_top_u_mac_u_mul_r_s21__14_ VDD VSS u_mac16_top_u_mac_u_mul_net731 n752 HFSNET_18 DFFRPQX0P5H9R
Xu_mac16_top_u_mac_u_mul_r_s21_reg_15_ u_mac16_top_u_mac_u_mul_r_s21__15_ VDD VSS u_mac16_top_u_mac_u_mul_net731 n751 HFSNET_20 DFFRPQX0P5H9R
Xu_mac16_top_u_mac_u_mul_r_s21_reg_16_ u_mac16_top_u_mac_u_mul_r_s21__16_ VDD VSS u_mac16_top_u_mac_u_mul_net731 n750 HFSNET_1 DFFRPQX0P5H9R
Xu_mac16_top_u_mac_u_mul_r_s21_reg_17_ u_mac16_top_u_mac_u_mul_r_s21__17_ VDD VSS u_mac16_top_u_mac_u_mul_net731 n749 HFSNET_1 DFFRPQX0P5H9R
Xu_mac16_top_u_mac_u_mul_r_s21_reg_18_ u_mac16_top_u_mac_u_mul_r_s21__18_ VDD VSS u_mac16_top_u_mac_u_mul_net731 n748 HFSNET_1 DFFRPQX0P5H9R
Xu_mac16_top_u_mac_u_mul_r_s21_reg_20_ u_mac16_top_u_mac_u_mul_r_s21__20_ VDD VSS u_mac16_top_u_mac_u_mul_net731 u_mac16_top_u_mac_u_mul_s21__20_ HFSNET_6 DFFRPQX0P5H9R
Xu_mac16_top_u_mac_u_mul_r_s21_reg_21_ u_mac16_top_u_mac_u_mul_r_s21__21_ VDD VSS u_mac16_top_u_mac_u_mul_net731 u_mac16_top_u_mac_u_mul_s21__21_ HFSNET_2 DFFRPQX0P5H9R
Xu_mac16_top_u_mac_u_mul_r_s21_reg_22_ u_mac16_top_u_mac_u_mul_r_s21__22_ VDD VSS u_mac16_top_u_mac_u_mul_net731 n759 HFSNET_2 DFFRPQX0P5H9R
Xu_mac16_top_u_mac_u_mul_r_s21_reg_23_ u_mac16_top_u_mac_u_mul_r_s21__23_ VDD VSS u_mac16_top_u_mac_u_mul_net731 u_mac16_top_u_mac_u_mul_s21__23_ HFSNET_1 DFFRPQX0P5H9R
Xu_mac16_top_u_mac_u_mul_r_c20_reg_3_ u_mac16_top_u_mac_u_mul_r_c20__3_ VDD VSS u_mac16_top_u_mac_u_mul_net741 u_mac16_top_u_mac_u_mul_st2_0_gen_csa_fa_2__u_fa_N1 HFSNET_6 DFFRPQX0P5H9R
Xu_mac16_top_u_mac_u_mul_r_c20_reg_4_ u_mac16_top_u_mac_u_mul_r_c20__4_ VDD VSS u_mac16_top_u_mac_u_mul_net741 u_mac16_top_u_mac_u_mul_c20__4_ HFSNET_6 DFFRPQX0P5H9R
Xu_mac16_top_u_mac_u_mul_r_c20_reg_5_ u_mac16_top_u_mac_u_mul_r_c20__5_ VDD VSS u_mac16_top_u_mac_u_mul_net741 u_mac16_top_u_mac_u_mul_c20__5_ HFSNET_2 DFFRPQX0P5H9R
Xu_mac16_top_u_mac_u_mul_r_c20_reg_6_ u_mac16_top_u_mac_u_mul_r_c20__6_ VDD VSS u_mac16_top_u_mac_u_mul_net741 u_mac16_top_u_mac_u_mul_c20__6_ HFSNET_2 DFFRPQX0P5H9R
Xu_mac16_top_u_mac_u_mul_r_c20_reg_7_ u_mac16_top_u_mac_u_mul_r_c20__7_ VDD VSS u_mac16_top_u_mac_u_mul_net741 u_mac16_top_u_mac_u_mul_c20__7_ HFSNET_1 DFFRPQX0P5H9R
Xu_mac16_top_u_mac_u_mul_r_c20_reg_8_ u_mac16_top_u_mac_u_mul_r_c20__8_ VDD VSS u_mac16_top_u_mac_u_mul_net741 u_mac16_top_u_mac_u_mul_c20__8_ HFSNET_2 DFFRPQX0P5H9R
Xu_mac16_top_u_mac_u_mul_r_c20_reg_9_ u_mac16_top_u_mac_u_mul_r_c20__9_ VDD VSS u_mac16_top_u_mac_u_mul_net741 u_mac16_top_u_mac_u_mul_c20__9_ HFSNET_2 DFFRPQX0P5H9R
Xu_mac16_top_u_mac_u_mul_r_c20_reg_10_ u_mac16_top_u_mac_u_mul_r_c20__10_ VDD VSS u_mac16_top_u_mac_u_mul_net741 u_mac16_top_u_mac_u_mul_c20__10_ HFSNET_2 DFFRPQX0P5H9R
Xu_mac16_top_u_mac_u_mul_r_c20_reg_11_ u_mac16_top_u_mac_u_mul_r_c20__11_ VDD VSS u_mac16_top_u_mac_u_mul_net721 u_mac16_top_u_mac_u_mul_c20__11_ HFSNET_6 DFFRPQX0P5H9R
Xu_mac16_top_u_mac_u_mul_r_c20_reg_12_ u_mac16_top_u_mac_u_mul_r_c20__12_ VDD VSS u_mac16_top_u_mac_u_mul_net721 u_mac16_top_u_mac_u_mul_c20__12_ HFSNET_6 DFFRPQX0P5H9R
Xu_mac16_top_u_mac_u_mul_r_c20_reg_13_ u_mac16_top_u_mac_u_mul_r_c20__13_ VDD VSS u_mac16_top_u_mac_u_mul_net721 u_mac16_top_u_mac_u_mul_c20__13_ HFSNET_6 DFFRPQX0P5H9R
Xu_mac16_top_u_mac_u_mul_r_c20_reg_14_ u_mac16_top_u_mac_u_mul_r_c20__14_ VDD VSS u_mac16_top_u_mac_u_mul_net721 u_mac16_top_u_mac_u_mul_c20__14_ HFSNET_6 DFFRPQX0P5H9R
Xu_mac16_top_u_mac_u_mul_r_c20_reg_15_ u_mac16_top_u_mac_u_mul_r_c20__15_ VDD VSS u_mac16_top_u_mac_u_mul_net721 u_mac16_top_u_mac_u_mul_c20__15_ HFSNET_6 DFFRPQX0P5H9R
Xu_mac16_top_u_mac_u_mul_r_c20_reg_17_ u_mac16_top_u_mac_u_mul_r_c20__17_ VDD VSS u_mac16_top_u_mac_u_mul_net721 u_mac16_top_u_mac_u_mul_c20__17_ HFSNET_6 DFFRPQX0P5H9R
Xu_mac16_top_u_mac_u_mul_r_c20_reg_18_ u_mac16_top_u_mac_u_mul_r_c20__18_ VDD VSS u_mac16_top_u_mac_u_mul_net721 u_mac16_top_u_mac_u_mul_c20__18_ HFSNET_8 DFFRPQX0P5H9R
Xu_mac16_top_u_mac_u_mul_r_s20_reg_0_ u_mac16_top_u_mac_u_mul_r_s20__0_ VDD VSS u_mac16_top_u_mac_u_mul_net721 u_mac16_top_u_mac_u_mul_pp_0__0_ HFSNET_6 DFFRPQX0P5H9R
Xu_mac16_top_u_mac_u_mul_r_s20_reg_1_ u_mac16_top_u_mac_u_mul_r_s20__1_ VDD VSS u_mac16_top_u_mac_u_mul_net721 u_mac16_top_u_mac_u_mul_st1_0_gen_csa_fa_1__u_fa_N0 HFSNET_6 DFFRPQX0P5H9R
Xu_mac16_top_u_mac_u_mul_r_s20_reg_2_ u_mac16_top_u_mac_u_mul_r_s20__2_ VDD VSS u_mac16_top_u_mac_u_mul_net721 n746 HFSNET_6 DFFRPQX0P5H9R
Xu_mac16_top_u_mac_u_mul_r_s20_reg_3_ u_mac16_top_u_mac_u_mul_r_s20__3_ VDD VSS u_mac16_top_u_mac_u_mul_net721 n745 HFSNET_6 DFFRPQX0P5H9R
Xu_mac16_top_u_mac_u_mul_r_s20_reg_6_ u_mac16_top_u_mac_u_mul_r_s20__6_ VDD VSS u_mac16_top_u_mac_u_mul_net721 n743 HFSNET_6 DFFRPQX0P5H9R
Xu_mac16_top_u_mac_u_mul_r_s20_reg_11_ u_mac16_top_u_mac_u_mul_r_s20__11_ VDD VSS u_mac16_top_u_mac_u_mul_net721 n738 HFSNET_3 DFFRPQX0P5H9R
Xu_mac16_top_u_mac_u_mul_r_s20_reg_13_ u_mac16_top_u_mac_u_mul_r_s20__13_ VDD VSS u_mac16_top_u_mac_u_mul_net721 n736 HFSNET_6 DFFRPQX0P5H9R
Xu_mac16_top_u_mac_u_mul_r_s20_reg_17_ u_mac16_top_u_mac_u_mul_r_s20__17_ VDD VSS u_mac16_top_u_mac_u_mul_net721 u_mac16_top_u_mac_u_mul_s20__17_ HFSNET_6 DFFRPQX0P5H9R
Xu_mac16_top_u_mac_u_mul_r_s20_reg_18_ u_mac16_top_u_mac_u_mul_r_s20__18_ VDD VSS u_mac16_top_u_mac_u_mul_net721 u_mac16_top_u_mac_u_mul_s11__18_ HFSNET_6 DFFRPQX0P5H9R
Xu_mac16_top_u_mac_u_mul_r_s20_reg_19_ u_mac16_top_u_mac_u_mul_r_s20__19_ VDD VSS u_mac16_top_u_mac_u_mul_net721 u_mac16_top_u_mac_u_mul_s11__19_ HFSNET_6 DFFRPQX0P5H9R
Xu_mac16_top_u_mac_u_mul_r_s20_reg_20_ u_mac16_top_u_mac_u_mul_r_s20__20_ VDD VSS u_mac16_top_u_mac_u_mul_net721 u_mac16_top_u_mac_u_mul_pp_5__20_ HFSNET_1 DFFRPQX0P5H9R
Xu_mac16_top_u_mac_u_mul_en_d1_reg u_mac16_top_u_mac_u_mul_en_d1 VDD VSS clk u_mac16_top_calc_start HFSNET_1 DFFRPQX0P5H9R
Xu_mac16_top_u_mac_u_mul_en_d2_reg u_mac16_top_u_mac_u_mul_en_d2 VDD VSS clk u_mac16_top_u_mac_u_mul_en_d1 HFSNET_1 DFFRPQX0P5H9R
Xu_mac16_top_u_mac_u_mul_en_d3_reg u_mac16_top_u_mac_u_mul_en_d3 VDD VSS clk u_mac16_top_u_mac_u_mul_en_d2 HFSNET_17 DFFRPQX0P5H9R
Xu_mac16_top_u_mac_u_mul_valid_reg_reg u_mac16_top_u_mac_mult_valid VDD VSS clk u_mac16_top_u_mac_u_mul_en_d3 HFSNET_17 DFFRPQX0P5H9R
Xu_mac16_top_u_mac_cal_done_reg u_mac16_top_cal_done VDD VSS clk u_mac16_top_u_mac_mult_valid HFSNET_16 DFFRPQX0P5H9R
Xu_mac16_top_p2s_load_reg u_mac16_top_p2s_load VDD VSS clk u_mac16_top_N91 HFSNET_16 DFFRPQX0P5H9R
Xu_mac16_top_u_out_bits_left_reg_2_ u_mac16_top_u_out_bits_left__2_ VDD VSS u_mac16_top_u_out_net664 n2352 HFSNET_25 DFFRPQX0P5H9R
Xu_mac16_top_u_out_bits_left_reg_3_ u_mac16_top_u_out_bits_left__3_ VDD VSS u_mac16_top_u_out_net664 n2351 HFSNET_25 DFFRPQX0P5H9R
Xu_mac16_top_u_out_bits_left_reg_4_ u_mac16_top_u_out_bits_left__4_ VDD VSS u_mac16_top_u_out_net664 n2350 HFSNET_25 DFFRPQX0P5H9R
Xu_mac16_top_u_out_bits_left_reg_5_ u_mac16_top_u_out_bits_left__5_ VDD VSS u_mac16_top_u_out_net664 n2349 HFSNET_25 DFFRPQX0P5H9R
Xu_mac16_top_p2s_issue_hold_reg u_mac16_top_p2s_issue_hold VDD VSS clk u_mac16_top_N91 HFSNET_16 DFFRPQX0P5H9R
Xu_mac16_top_fifo_count_reg_2_ u_mac16_top_fifo_count__2_ VDD VSS u_mac16_top_net647 n2345 HFSNET_25 DFFRPQX0P5H9R
Xu_mac16_top_u_mac_sum_out_reg_23_ u_mac16_top_mac_result__23_ VDD VSS u_mac16_top_u_mac_net688 u_mac16_top_u_mac_add_tmp_comb__23_ HFSNET_16 DFFRPQX0P5H9R
Xu_mac16_top_result_fifo_reg_3__23_ u_mac16_top_result_fifo_3__23_ VDD VSS u_mac16_top_net595 u_mac16_top_mac_result__23_ HFSNET_23 DFFRPQX0P5H9R
Xu_mac16_top_result_fifo_reg_2__23_ u_mac16_top_result_fifo_2__23_ VDD VSS u_mac16_top_net590 u_mac16_top_mac_result__23_ HFSNET_23 DFFRPQX0P5H9R
Xu_mac16_top_result_fifo_reg_1__23_ u_mac16_top_result_fifo_1__23_ VDD VSS u_mac16_top_net585 u_mac16_top_mac_result__23_ HFSNET_23 DFFRPQX0P5H9R
Xu_mac16_top_result_fifo_reg_0__23_ u_mac16_top_result_fifo_0__23_ VDD VSS u_mac16_top_net580 u_mac16_top_mac_result__23_ HFSNET_24 DFFRPQX0P5H9R
Xu_mac16_top_u_mac_sum_out_reg_22_ u_mac16_top_mac_result__22_ VDD VSS u_mac16_top_u_mac_net688 u_mac16_top_u_mac_add_tmp_comb__22_ HFSNET_16 DFFRPQX0P5H9R
Xu_mac16_top_result_fifo_reg_3__22_ u_mac16_top_result_fifo_3__22_ VDD VSS u_mac16_top_net595 u_mac16_top_mac_result__22_ HFSNET_23 DFFRPQX0P5H9R
Xu_mac16_top_result_fifo_reg_2__22_ u_mac16_top_result_fifo_2__22_ VDD VSS u_mac16_top_net590 u_mac16_top_mac_result__22_ HFSNET_23 DFFRPQX0P5H9R
Xu_mac16_top_result_fifo_reg_1__22_ u_mac16_top_result_fifo_1__22_ VDD VSS u_mac16_top_net585 u_mac16_top_mac_result__22_ HFSNET_23 DFFRPQX0P5H9R
Xu_mac16_top_result_fifo_reg_0__22_ u_mac16_top_result_fifo_0__22_ VDD VSS u_mac16_top_net580 u_mac16_top_mac_result__22_ HFSNET_24 DFFRPQX0P5H9R
Xu_mac16_top_u_mac_sum_out_reg_21_ u_mac16_top_mac_result__21_ VDD VSS u_mac16_top_u_mac_net688 u_mac16_top_u_mac_add_tmp_comb__21_ HFSNET_16 DFFRPQX0P5H9R
Xu_mac16_top_result_fifo_reg_3__21_ u_mac16_top_result_fifo_3__21_ VDD VSS u_mac16_top_net595 u_mac16_top_mac_result__21_ HFSNET_23 DFFRPQX0P5H9R
Xu_mac16_top_result_fifo_reg_2__21_ u_mac16_top_result_fifo_2__21_ VDD VSS u_mac16_top_net590 u_mac16_top_mac_result__21_ HFSNET_23 DFFRPQX0P5H9R
Xu_mac16_top_result_fifo_reg_1__21_ u_mac16_top_result_fifo_1__21_ VDD VSS u_mac16_top_net585 u_mac16_top_mac_result__21_ HFSNET_23 DFFRPQX0P5H9R
Xu_mac16_top_result_fifo_reg_0__21_ u_mac16_top_result_fifo_0__21_ VDD VSS u_mac16_top_net580 u_mac16_top_mac_result__21_ HFSNET_24 DFFRPQX0P5H9R
Xu_mac16_top_u_mac_sum_out_reg_20_ u_mac16_top_mac_result__20_ VDD VSS u_mac16_top_u_mac_net688 u_mac16_top_u_mac_add_tmp_comb__20_ HFSNET_19 DFFRPQX0P5H9R
Xu_mac16_top_result_fifo_reg_3__20_ u_mac16_top_result_fifo_3__20_ VDD VSS u_mac16_top_net595 u_mac16_top_mac_result__20_ HFSNET_23 DFFRPQX0P5H9R
Xu_mac16_top_result_fifo_reg_2__20_ u_mac16_top_result_fifo_2__20_ VDD VSS u_mac16_top_net590 u_mac16_top_mac_result__20_ HFSNET_23 DFFRPQX0P5H9R
Xu_mac16_top_result_fifo_reg_1__20_ u_mac16_top_result_fifo_1__20_ VDD VSS u_mac16_top_net585 u_mac16_top_mac_result__20_ HFSNET_23 DFFRPQX0P5H9R
Xu_mac16_top_result_fifo_reg_0__20_ u_mac16_top_result_fifo_0__20_ VDD VSS u_mac16_top_net580 u_mac16_top_mac_result__20_ HFSNET_24 DFFRPQX0P5H9R
Xu_mac16_top_u_mac_sum_out_reg_19_ u_mac16_top_mac_result__19_ VDD VSS u_mac16_top_u_mac_net688 u_mac16_top_u_mac_add_tmp_comb__19_ HFSNET_18 DFFRPQX0P5H9R
Xu_mac16_top_result_fifo_reg_3__19_ u_mac16_top_result_fifo_3__19_ VDD VSS u_mac16_top_net595 u_mac16_top_mac_result__19_ HFSNET_18 DFFRPQX0P5H9R
Xu_mac16_top_result_fifo_reg_2__19_ u_mac16_top_result_fifo_2__19_ VDD VSS u_mac16_top_net590 u_mac16_top_mac_result__19_ HFSNET_18 DFFRPQX0P5H9R
Xu_mac16_top_result_fifo_reg_1__19_ u_mac16_top_result_fifo_1__19_ VDD VSS u_mac16_top_net585 u_mac16_top_mac_result__19_ HFSNET_18 DFFRPQX0P5H9R
Xu_mac16_top_result_fifo_reg_0__19_ u_mac16_top_result_fifo_0__19_ VDD VSS u_mac16_top_net580 u_mac16_top_mac_result__19_ HFSNET_24 DFFRPQX0P5H9R
Xu_mac16_top_u_mac_sum_out_reg_18_ u_mac16_top_mac_result__18_ VDD VSS u_mac16_top_u_mac_net688 u_mac16_top_u_mac_add_tmp_comb__18_ HFSNET_18 DFFRPQX0P5H9R
Xu_mac16_top_result_fifo_reg_3__18_ u_mac16_top_result_fifo_3__18_ VDD VSS u_mac16_top_net595 u_mac16_top_mac_result__18_ HFSNET_18 DFFRPQX0P5H9R
Xu_mac16_top_result_fifo_reg_2__18_ u_mac16_top_result_fifo_2__18_ VDD VSS u_mac16_top_net590 u_mac16_top_mac_result__18_ HFSNET_18 DFFRPQX0P5H9R
Xu_mac16_top_result_fifo_reg_1__18_ u_mac16_top_result_fifo_1__18_ VDD VSS u_mac16_top_net585 u_mac16_top_mac_result__18_ HFSNET_18 DFFRPQX0P5H9R
Xu_mac16_top_result_fifo_reg_0__18_ u_mac16_top_result_fifo_0__18_ VDD VSS u_mac16_top_net580 u_mac16_top_mac_result__18_ HFSNET_18 DFFRPQX0P5H9R
Xu_mac16_top_result_fifo_reg_3__17_ u_mac16_top_result_fifo_3__17_ VDD VSS u_mac16_top_net595 u_mac16_top_mac_result__17_ HFSNET_24 DFFRPQX0P5H9R
Xu_mac16_top_result_fifo_reg_2__17_ u_mac16_top_result_fifo_2__17_ VDD VSS u_mac16_top_net590 u_mac16_top_mac_result__17_ HFSNET_24 DFFRPQX0P5H9R
Xu_mac16_top_result_fifo_reg_1__17_ u_mac16_top_result_fifo_1__17_ VDD VSS u_mac16_top_net585 u_mac16_top_mac_result__17_ HFSNET_24 DFFRPQX0P5H9R
Xu_mac16_top_result_fifo_reg_0__17_ u_mac16_top_result_fifo_0__17_ VDD VSS u_mac16_top_net580 u_mac16_top_mac_result__17_ HFSNET_24 DFFRPQX0P5H9R
Xu_mac16_top_u_mac_sum_out_reg_16_ u_mac16_top_mac_result__16_ VDD VSS u_mac16_top_u_mac_net688 u_mac16_top_u_mac_add_tmp_comb__16_ HFSNET_16 DFFRPQX0P5H9R
Xu_mac16_top_result_fifo_reg_3__16_ u_mac16_top_result_fifo_3__16_ VDD VSS u_mac16_top_net595 u_mac16_top_mac_result__16_ HFSNET_24 DFFRPQX0P5H9R
Xu_mac16_top_result_fifo_reg_2__16_ u_mac16_top_result_fifo_2__16_ VDD VSS u_mac16_top_net590 u_mac16_top_mac_result__16_ HFSNET_24 DFFRPQX0P5H9R
Xu_mac16_top_result_fifo_reg_1__16_ u_mac16_top_result_fifo_1__16_ VDD VSS u_mac16_top_net585 u_mac16_top_mac_result__16_ HFSNET_24 DFFRPQX0P5H9R
Xu_mac16_top_result_fifo_reg_0__16_ u_mac16_top_result_fifo_0__16_ VDD VSS u_mac16_top_net580 u_mac16_top_mac_result__16_ HFSNET_24 DFFRPQX0P5H9R
Xu_mac16_top_result_fifo_reg_3__15_ u_mac16_top_result_fifo_3__15_ VDD VSS u_mac16_top_net595 u_mac16_top_mac_result__15_ HFSNET_24 DFFRPQX0P5H9R
Xu_mac16_top_result_fifo_reg_2__15_ u_mac16_top_result_fifo_2__15_ VDD VSS u_mac16_top_net590 u_mac16_top_mac_result__15_ HFSNET_16 DFFRPQX0P5H9R
Xu_mac16_top_result_fifo_reg_1__15_ u_mac16_top_result_fifo_1__15_ VDD VSS u_mac16_top_net585 u_mac16_top_mac_result__15_ HFSNET_16 DFFRPQX0P5H9R
Xu_mac16_top_result_fifo_reg_0__15_ u_mac16_top_result_fifo_0__15_ VDD VSS u_mac16_top_net580 u_mac16_top_mac_result__15_ HFSNET_24 DFFRPQX0P5H9R
Xu_mac16_top_u_mac_sum_out_reg_14_ u_mac16_top_mac_result__14_ VDD VSS u_mac16_top_u_mac_net688 u_mac16_top_u_mac_add_tmp_comb__14_ HFSNET_19 DFFRPQX0P5H9R
Xu_mac16_top_result_fifo_reg_3__14_ u_mac16_top_result_fifo_3__14_ VDD VSS u_mac16_top_net595 u_mac16_top_mac_result__14_ HFSNET_16 DFFRPQX0P5H9R
Xu_mac16_top_result_fifo_reg_2__14_ u_mac16_top_result_fifo_2__14_ VDD VSS u_mac16_top_net590 u_mac16_top_mac_result__14_ HFSNET_24 DFFRPQX0P5H9R
Xu_mac16_top_result_fifo_reg_1__14_ u_mac16_top_result_fifo_1__14_ VDD VSS u_mac16_top_net585 u_mac16_top_mac_result__14_ HFSNET_24 DFFRPQX0P5H9R
Xu_mac16_top_result_fifo_reg_0__14_ u_mac16_top_result_fifo_0__14_ VDD VSS u_mac16_top_net580 u_mac16_top_mac_result__14_ HFSNET_24 DFFRPQX0P5H9R
Xu_mac16_top_result_fifo_reg_2__13_ u_mac16_top_result_fifo_2__13_ VDD VSS u_mac16_top_net590 u_mac16_top_mac_result__13_ HFSNET_18 DFFRPQX0P5H9R
Xu_mac16_top_result_fifo_reg_1__13_ u_mac16_top_result_fifo_1__13_ VDD VSS u_mac16_top_net585 u_mac16_top_mac_result__13_ HFSNET_18 DFFRPQX0P5H9R
Xu_mac16_top_result_fifo_reg_0__13_ u_mac16_top_result_fifo_0__13_ VDD VSS u_mac16_top_net580 u_mac16_top_mac_result__13_ HFSNET_18 DFFRPQX0P5H9R
Xu_mac16_top_result_fifo_reg_3__12_ u_mac16_top_result_fifo_3__12_ VDD VSS u_mac16_top_net595 u_mac16_top_mac_result__12_ HFSNET_18 DFFRPQX0P5H9R
Xu_mac16_top_result_fifo_reg_2__12_ u_mac16_top_result_fifo_2__12_ VDD VSS u_mac16_top_net590 u_mac16_top_mac_result__12_ HFSNET_18 DFFRPQX0P5H9R
Xu_mac16_top_result_fifo_reg_1__12_ u_mac16_top_result_fifo_1__12_ VDD VSS u_mac16_top_net585 u_mac16_top_mac_result__12_ HFSNET_22 DFFRPQX0P5H9R
Xu_mac16_top_result_fifo_reg_0__12_ u_mac16_top_result_fifo_0__12_ VDD VSS u_mac16_top_net580 u_mac16_top_mac_result__12_ HFSNET_22 DFFRPQX0P5H9R
Xu_mac16_top_result_fifo_reg_3__11_ u_mac16_top_result_fifo_3__11_ VDD VSS u_mac16_top_net595 u_mac16_top_mac_result__11_ HFSNET_22 DFFRPQX0P5H9R
Xu_mac16_top_result_fifo_reg_2__11_ u_mac16_top_result_fifo_2__11_ VDD VSS u_mac16_top_net590 u_mac16_top_mac_result__11_ HFSNET_22 DFFRPQX0P5H9R
Xu_mac16_top_result_fifo_reg_1__11_ u_mac16_top_result_fifo_1__11_ VDD VSS u_mac16_top_net585 u_mac16_top_mac_result__11_ HFSNET_22 DFFRPQX0P5H9R
Xu_mac16_top_result_fifo_reg_0__11_ u_mac16_top_result_fifo_0__11_ VDD VSS u_mac16_top_net580 u_mac16_top_mac_result__11_ HFSNET_22 DFFRPQX0P5H9R
Xu_mac16_top_result_fifo_reg_3__10_ u_mac16_top_result_fifo_3__10_ VDD VSS u_mac16_top_net595 u_mac16_top_mac_result__10_ HFSNET_22 DFFRPQX0P5H9R
Xu_mac16_top_result_fifo_reg_2__10_ u_mac16_top_result_fifo_2__10_ VDD VSS u_mac16_top_net590 u_mac16_top_mac_result__10_ HFSNET_22 DFFRPQX0P5H9R
Xu_mac16_top_result_fifo_reg_1__10_ u_mac16_top_result_fifo_1__10_ VDD VSS u_mac16_top_net585 u_mac16_top_mac_result__10_ HFSNET_22 DFFRPQX0P5H9R
Xu_mac16_top_result_fifo_reg_0__10_ u_mac16_top_result_fifo_0__10_ VDD VSS u_mac16_top_net580 u_mac16_top_mac_result__10_ HFSNET_22 DFFRPQX0P5H9R
Xu_mac16_top_result_fifo_reg_3__9_ u_mac16_top_result_fifo_3__9_ VDD VSS u_mac16_top_net595 u_mac16_top_mac_result__9_ HFSNET_23 DFFRPQX0P5H9R
Xu_mac16_top_result_fifo_reg_2__9_ u_mac16_top_result_fifo_2__9_ VDD VSS u_mac16_top_net590 u_mac16_top_mac_result__9_ HFSNET_21 DFFRPQX0P5H9R
Xu_mac16_top_result_fifo_reg_1__9_ u_mac16_top_result_fifo_1__9_ VDD VSS u_mac16_top_net585 u_mac16_top_mac_result__9_ HFSNET_21 DFFRPQX0P5H9R
Xu_mac16_top_result_fifo_reg_0__9_ u_mac16_top_result_fifo_0__9_ VDD VSS u_mac16_top_net580 u_mac16_top_mac_result__9_ HFSNET_22 DFFRPQX0P5H9R
Xu_mac16_top_u_mac_sum_out_reg_8_ u_mac16_top_mac_result__8_ VDD VSS u_mac16_top_u_mac_net688 u_mac16_top_u_mac_add_tmp_comb__8_ HFSNET_20 DFFRPQX0P5H9R
Xu_mac16_top_result_fifo_reg_3__8_ u_mac16_top_result_fifo_3__8_ VDD VSS u_mac16_top_net595 u_mac16_top_mac_result__8_ HFSNET_23 DFFRPQX0P5H9R
Xu_mac16_top_result_fifo_reg_2__8_ u_mac16_top_result_fifo_2__8_ VDD VSS u_mac16_top_net590 u_mac16_top_mac_result__8_ HFSNET_21 DFFRPQX0P5H9R
Xu_mac16_top_result_fifo_reg_1__8_ u_mac16_top_result_fifo_1__8_ VDD VSS u_mac16_top_net585 u_mac16_top_mac_result__8_ HFSNET_21 DFFRPQX0P5H9R
Xu_mac16_top_result_fifo_reg_0__8_ u_mac16_top_result_fifo_0__8_ VDD VSS u_mac16_top_net580 u_mac16_top_mac_result__8_ HFSNET_21 DFFRPQX0P5H9R
Xu_mac16_top_u_mac_sum_out_reg_7_ u_mac16_top_mac_result__7_ VDD VSS u_mac16_top_u_mac_net688 u_mac16_top_u_mac_add_tmp_comb__7_ HFSNET_20 DFFRPQX0P5H9R
Xu_mac16_top_result_fifo_reg_3__7_ u_mac16_top_result_fifo_3__7_ VDD VSS u_mac16_top_net595 u_mac16_top_mac_result__7_ HFSNET_18 DFFRPQX0P5H9R
Xu_mac16_top_result_fifo_reg_2__7_ u_mac16_top_result_fifo_2__7_ VDD VSS u_mac16_top_net590 u_mac16_top_mac_result__7_ HFSNET_18 DFFRPQX0P5H9R
Xu_mac16_top_result_fifo_reg_1__7_ u_mac16_top_result_fifo_1__7_ VDD VSS u_mac16_top_net585 u_mac16_top_mac_result__7_ HFSNET_18 DFFRPQX0P5H9R
Xu_mac16_top_result_fifo_reg_0__7_ u_mac16_top_result_fifo_0__7_ VDD VSS u_mac16_top_net580 u_mac16_top_mac_result__7_ HFSNET_22 DFFRPQX0P5H9R
Xu_mac16_top_u_mac_sum_out_reg_6_ u_mac16_top_mac_result__6_ VDD VSS u_mac16_top_u_mac_net688 u_mac16_top_u_mac_add_tmp_comb__6_ HFSNET_20 DFFRPQX0P5H9R
Xu_mac16_top_result_fifo_reg_3__6_ u_mac16_top_result_fifo_3__6_ VDD VSS u_mac16_top_net595 u_mac16_top_mac_result__6_ HFSNET_20 DFFRPQX0P5H9R
Xu_mac16_top_result_fifo_reg_2__6_ u_mac16_top_result_fifo_2__6_ VDD VSS u_mac16_top_net590 u_mac16_top_mac_result__6_ HFSNET_22 DFFRPQX0P5H9R
Xu_mac16_top_result_fifo_reg_1__6_ u_mac16_top_result_fifo_1__6_ VDD VSS u_mac16_top_net585 u_mac16_top_mac_result__6_ HFSNET_20 DFFRPQX0P5H9R
Xu_mac16_top_result_fifo_reg_0__6_ u_mac16_top_result_fifo_0__6_ VDD VSS u_mac16_top_net580 u_mac16_top_mac_result__6_ HFSNET_22 DFFRPQX0P5H9R
Xu_mac16_top_u_mac_sum_out_reg_5_ u_mac16_top_mac_result__5_ VDD VSS u_mac16_top_u_mac_net688 u_mac16_top_u_mac_add_tmp_comb__5_ HFSNET_20 DFFRPQX0P5H9R
Xu_mac16_top_result_fifo_reg_3__5_ u_mac16_top_result_fifo_3__5_ VDD VSS u_mac16_top_net595 u_mac16_top_mac_result__5_ HFSNET_21 DFFRPQX0P5H9R
Xu_mac16_top_result_fifo_reg_2__5_ u_mac16_top_result_fifo_2__5_ VDD VSS u_mac16_top_net590 u_mac16_top_mac_result__5_ HFSNET_21 DFFRPQX0P5H9R
Xu_mac16_top_result_fifo_reg_1__5_ u_mac16_top_result_fifo_1__5_ VDD VSS u_mac16_top_net585 u_mac16_top_mac_result__5_ HFSNET_21 DFFRPQX0P5H9R
Xu_mac16_top_result_fifo_reg_0__5_ u_mac16_top_result_fifo_0__5_ VDD VSS u_mac16_top_net580 u_mac16_top_mac_result__5_ HFSNET_21 DFFRPQX0P5H9R
Xu_mac16_top_u_mac_sum_out_reg_4_ u_mac16_top_mac_result__4_ VDD VSS u_mac16_top_u_mac_net688 u_mac16_top_u_mac_add_tmp_comb__4_ HFSNET_20 DFFRPQX0P5H9R
Xu_mac16_top_result_fifo_reg_3__4_ u_mac16_top_result_fifo_3__4_ VDD VSS u_mac16_top_net595 u_mac16_top_mac_result__4_ HFSNET_21 DFFRPQX0P5H9R
Xu_mac16_top_result_fifo_reg_2__4_ u_mac16_top_result_fifo_2__4_ VDD VSS u_mac16_top_net590 u_mac16_top_mac_result__4_ HFSNET_21 DFFRPQX0P5H9R
Xu_mac16_top_result_fifo_reg_1__4_ u_mac16_top_result_fifo_1__4_ VDD VSS u_mac16_top_net585 u_mac16_top_mac_result__4_ HFSNET_21 DFFRPQX0P5H9R
Xu_mac16_top_result_fifo_reg_0__4_ u_mac16_top_result_fifo_0__4_ VDD VSS u_mac16_top_net580 u_mac16_top_mac_result__4_ HFSNET_21 DFFRPQX0P5H9R
Xu_mac16_top_u_mac_sum_out_reg_3_ u_mac16_top_mac_result__3_ VDD VSS u_mac16_top_u_mac_net688 u_mac16_top_u_mac_add_tmp_comb__3_ HFSNET_18 DFFRPQX0P5H9R
Xu_mac16_top_result_fifo_reg_3__3_ u_mac16_top_result_fifo_3__3_ VDD VSS u_mac16_top_net595 u_mac16_top_mac_result__3_ HFSNET_21 DFFRPQX0P5H9R
Xu_mac16_top_result_fifo_reg_2__3_ u_mac16_top_result_fifo_2__3_ VDD VSS u_mac16_top_net590 u_mac16_top_mac_result__3_ HFSNET_21 DFFRPQX0P5H9R
Xu_mac16_top_result_fifo_reg_1__3_ u_mac16_top_result_fifo_1__3_ VDD VSS u_mac16_top_net585 u_mac16_top_mac_result__3_ HFSNET_21 DFFRPQX0P5H9R
Xu_mac16_top_result_fifo_reg_0__3_ u_mac16_top_result_fifo_0__3_ VDD VSS u_mac16_top_net580 u_mac16_top_mac_result__3_ HFSNET_24 DFFRPQX0P5H9R
Xu_mac16_top_u_mac_sum_out_reg_2_ u_mac16_top_mac_result__2_ VDD VSS u_mac16_top_u_mac_net688 u_mac16_top_u_mac_add_tmp_comb__2_ HFSNET_18 DFFRPQX0P5H9R
Xu_mac16_top_result_fifo_reg_3__2_ u_mac16_top_result_fifo_3__2_ VDD VSS u_mac16_top_net595 u_mac16_top_mac_result__2_ HFSNET_23 DFFRPQX0P5H9R
Xu_mac16_top_result_fifo_reg_2__2_ u_mac16_top_result_fifo_2__2_ VDD VSS u_mac16_top_net590 u_mac16_top_mac_result__2_ HFSNET_21 DFFRPQX0P5H9R
Xu_mac16_top_result_fifo_reg_1__2_ u_mac16_top_result_fifo_1__2_ VDD VSS u_mac16_top_net585 u_mac16_top_mac_result__2_ HFSNET_23 DFFRPQX0P5H9R
Xu_mac16_top_result_fifo_reg_0__2_ u_mac16_top_result_fifo_0__2_ VDD VSS u_mac16_top_net580 u_mac16_top_mac_result__2_ HFSNET_24 DFFRPQX0P5H9R
Xu_mac16_top_u_mac_sum_out_reg_1_ u_mac16_top_mac_result__1_ VDD VSS u_mac16_top_u_mac_net688 u_mac16_top_u_mac_add_tmp_comb__1_ HFSNET_18 DFFRPQX0P5H9R
Xu_mac16_top_result_fifo_reg_3__1_ u_mac16_top_result_fifo_3__1_ VDD VSS u_mac16_top_net595 u_mac16_top_mac_result__1_ HFSNET_22 DFFRPQX0P5H9R
Xu_mac16_top_result_fifo_reg_2__1_ u_mac16_top_result_fifo_2__1_ VDD VSS u_mac16_top_net590 u_mac16_top_mac_result__1_ HFSNET_22 DFFRPQX0P5H9R
Xu_mac16_top_result_fifo_reg_1__1_ u_mac16_top_result_fifo_1__1_ VDD VSS u_mac16_top_net585 u_mac16_top_mac_result__1_ HFSNET_22 DFFRPQX0P5H9R
Xu_mac16_top_result_fifo_reg_0__1_ u_mac16_top_result_fifo_0__1_ VDD VSS u_mac16_top_net580 u_mac16_top_mac_result__1_ HFSNET_22 DFFRPQX0P5H9R
Xu_mac16_top_u_mac_sum_out_reg_0_ u_mac16_top_mac_result__0_ VDD VSS u_mac16_top_u_mac_net688 u_mac16_top_u_mac_add_tmp_comb__0_ HFSNET_20 DFFRPQX0P5H9R
Xu_mac16_top_result_fifo_reg_3__0_ u_mac16_top_result_fifo_3__0_ VDD VSS u_mac16_top_net595 u_mac16_top_mac_result__0_ HFSNET_20 DFFRPQX0P5H9R
Xu_mac16_top_result_fifo_reg_2__0_ u_mac16_top_result_fifo_2__0_ VDD VSS u_mac16_top_net590 u_mac16_top_mac_result__0_ HFSNET_22 DFFRPQX0P5H9R
Xu_mac16_top_result_fifo_reg_1__0_ u_mac16_top_result_fifo_1__0_ VDD VSS u_mac16_top_net585 u_mac16_top_mac_result__0_ HFSNET_22 DFFRPQX0P5H9R
Xu_mac16_top_result_fifo_reg_0__0_ u_mac16_top_result_fifo_0__0_ VDD VSS u_mac16_top_net580 u_mac16_top_mac_result__0_ HFSNET_22 DFFRPQX0P5H9R
Xu_mac16_top_u_out_shift_reg_reg_1_ u_mac16_top_u_out_shift_reg__1_ VDD VSS u_mac16_top_u_out_net664 u_mac16_top_u_out_N21 HFSNET_21 DFFRPQX0P5H9R
Xu_mac16_top_u_out_shift_reg_reg_2_ u_mac16_top_u_out_shift_reg__2_ VDD VSS u_mac16_top_u_out_net664 n2255 HFSNET_21 DFFRPQX0P5H9R
Xu_mac16_top_u_out_shift_reg_reg_3_ u_mac16_top_u_out_shift_reg__3_ VDD VSS u_mac16_top_u_out_net664 n2254 HFSNET_22 DFFRPQX0P5H9R
Xu_mac16_top_u_out_shift_reg_reg_4_ u_mac16_top_u_out_shift_reg__4_ VDD VSS u_mac16_top_u_out_net664 n2253 HFSNET_21 DFFRPQX0P5H9R
Xu_mac16_top_u_out_shift_reg_reg_5_ u_mac16_top_u_out_shift_reg__5_ VDD VSS u_mac16_top_u_out_net664 n2252 HFSNET_21 DFFRPQX0P5H9R
Xu_mac16_top_u_out_shift_reg_reg_6_ u_mac16_top_u_out_shift_reg__6_ VDD VSS u_mac16_top_u_out_net664 n2251 HFSNET_21 DFFRPQX0P5H9R
Xu_mac16_top_u_out_shift_reg_reg_7_ u_mac16_top_u_out_shift_reg__7_ VDD VSS u_mac16_top_u_out_net664 n2250 HFSNET_22 DFFRPQX0P5H9R
Xu_mac16_top_u_out_shift_reg_reg_8_ u_mac16_top_u_out_shift_reg__8_ VDD VSS u_mac16_top_u_out_net664 n2249 HFSNET_22 DFFRPQX0P5H9R
Xu_mac16_top_u_out_shift_reg_reg_9_ u_mac16_top_u_out_shift_reg__9_ VDD VSS u_mac16_top_u_out_net664 n2248 HFSNET_21 DFFRPQX0P5H9R
Xu_mac16_top_u_out_shift_reg_reg_10_ u_mac16_top_u_out_shift_reg__10_ VDD VSS u_mac16_top_u_out_net664 n2247 HFSNET_21 DFFRPQX0P5H9R
Xu_mac16_top_u_out_shift_reg_reg_11_ u_mac16_top_u_out_shift_reg__11_ VDD VSS u_mac16_top_u_out_net664 n2246 HFSNET_21 DFFRPQX0P5H9R
Xu_mac16_top_u_out_shift_reg_reg_12_ u_mac16_top_u_out_shift_reg__12_ VDD VSS u_mac16_top_u_out_net664 n2245 HFSNET_22 DFFRPQX0P5H9R
Xu_mac16_top_u_out_shift_reg_reg_13_ u_mac16_top_u_out_shift_reg__13_ VDD VSS u_mac16_top_u_out_net664 n2265 HFSNET_21 DFFRPQX0P5H9R
Xu_mac16_top_u_out_shift_reg_reg_14_ u_mac16_top_u_out_shift_reg__14_ VDD VSS u_mac16_top_u_out_net664 n2264 HFSNET_24 DFFRPQX0P5H9R
Xu_mac16_top_u_out_shift_reg_reg_15_ u_mac16_top_u_out_shift_reg__15_ VDD VSS u_mac16_top_u_out_net664 n2263 HFSNET_24 DFFRPQX0P5H9R
Xu_mac16_top_u_out_shift_reg_reg_16_ u_mac16_top_u_out_shift_reg__16_ VDD VSS u_mac16_top_u_out_net664 n2262 HFSNET_23 DFFRPQX0P5H9R
Xu_mac16_top_u_out_shift_reg_reg_17_ u_mac16_top_u_out_shift_reg__17_ VDD VSS u_mac16_top_u_out_net664 n2261 HFSNET_23 DFFRPQX0P5H9R
Xu_mac16_top_u_out_shift_reg_reg_18_ u_mac16_top_u_out_shift_reg__18_ VDD VSS u_mac16_top_u_out_net664 n2260 HFSNET_25 DFFRPQX0P5H9R
Xu_mac16_top_u_out_shift_reg_reg_19_ u_mac16_top_u_out_shift_reg__19_ VDD VSS u_mac16_top_u_out_net664 n2259 HFSNET_25 DFFRPQX0P5H9R
Xu_mac16_top_u_out_shift_reg_reg_20_ u_mac16_top_u_out_shift_reg__20_ VDD VSS u_mac16_top_u_out_net664 n2258 HFSNET_23 DFFRPQX0P5H9R
Xu_mac16_top_u_out_shift_reg_reg_21_ u_mac16_top_u_out_shift_reg__21_ VDD VSS u_mac16_top_u_out_net664 n2257 HFSNET_23 DFFRPQX0P5H9R
Xu_mac16_top_u_out_shift_reg_reg_22_ u_mac16_top_u_out_shift_reg__22_ VDD VSS u_mac16_top_u_out_net664 n2256 HFSNET_23 DFFRPQX0P5H9R
Xu_mac16_top_u_out_shift_reg_reg_23_ u_mac16_top_u_out_shift_reg__23_ VDD VSS u_mac16_top_u_out_net664 n2244 HFSNET_25 DFFRPQX0P5H9R
Xu_mac16_top_u_mac_last_prod_reg_22_ u_mac16_top_u_mac_last_prod__22_ VDD VSS u_mac16_top_u_mac_net693 u_mac16_top_u_mac_mult_result__22_ HFSNET_1 DFFRPQX0P5H9R
Xu_mac16_top_u_mac_last_prod_reg_21_ u_mac16_top_u_mac_last_prod__21_ VDD VSS u_mac16_top_u_mac_net693 u_mac16_top_u_mac_mult_result__21_ HFSNET_32 DFFRPQX0P5H9R
Xu_mac16_top_u_mac_last_prod_reg_0_ u_mac16_top_u_mac_last_prod__0_ VDD VSS u_mac16_top_u_mac_net693 u_mac16_top_u_mac_mult_result__0_ HFSNET_29 DFFRPQX0P5H9R
Xu_mac16_top_u_mac_accum_reg_reg_23_ u_mac16_top_u_mac_accum_reg__23_ VDD VSS u_mac16_top_u_mac_net682 u_mac16_top_u_mac_add_tmp_comb__23_ HFSNET_16 DFFRPQX0P5H9R
Xu_mac16_top_u_mac_accum_reg_reg_22_ u_mac16_top_u_mac_accum_reg__22_ VDD VSS u_mac16_top_u_mac_net682 u_mac16_top_u_mac_add_tmp_comb__22_ HFSNET_17 DFFRPQX0P5H9R
Xu_mac16_top_u_mac_accum_reg_reg_21_ u_mac16_top_u_mac_accum_reg__21_ VDD VSS u_mac16_top_u_mac_net682 u_mac16_top_u_mac_add_tmp_comb__21_ HFSNET_16 DFFRPQX0P5H9R
Xu_mac16_top_u_mac_accum_reg_reg_20_ u_mac16_top_u_mac_accum_reg__20_ VDD VSS u_mac16_top_u_mac_net682 u_mac16_top_u_mac_add_tmp_comb__20_ HFSNET_20 DFFRPQX0P5H9R
Xu_mac16_top_u_mac_accum_reg_reg_19_ u_mac16_top_u_mac_accum_reg__19_ VDD VSS u_mac16_top_u_mac_net682 u_mac16_top_u_mac_add_tmp_comb__19_ HFSNET_18 DFFRPQX0P5H9R
Xu_mac16_top_u_mac_accum_reg_reg_18_ u_mac16_top_u_mac_accum_reg__18_ VDD VSS u_mac16_top_u_mac_net682 u_mac16_top_u_mac_add_tmp_comb__18_ HFSNET_18 DFFRPQX0P5H9R
Xu_mac16_top_u_mac_u_mul_r_s31_reg_23_ u_mac16_top_u_mac_u_mul_r_s31__23_ VDD VSS u_mac16_top_u_mac_u_mul_net751 u_mac16_top_u_mac_u_mul_s31__23_ HFSNET_4 DFFRPQX0P5H9R
Xu_mac16_top_u_mac_u_mul_r_s31_reg_22_ u_mac16_top_u_mac_u_mul_r_s31__22_ VDD VSS u_mac16_top_u_mac_u_mul_net751 u_mac16_top_u_mac_u_mul_s31__22_ HFSNET_4 DFFRPQX0P5H9R
Xu_mac16_top_u_mac_u_mul_r_s31_reg_21_ u_mac16_top_u_mac_u_mul_r_s31__21_ VDD VSS u_mac16_top_u_mac_u_mul_net751 u_mac16_top_u_mac_u_mul_s31__21_ HFSNET_3 DFFRPQX0P5H9R
Xu_mac16_top_u_mac_u_mul_r_s31_reg_20_ u_mac16_top_u_mac_u_mul_r_s31__20_ VDD VSS u_mac16_top_u_mac_u_mul_net751 u_mac16_top_u_mac_u_mul_s31__20_ HFSNET_31 DFFRPQX0P5H9R
Xu_mac16_top_u_mac_u_mul_r_s31_reg_19_ u_mac16_top_u_mac_u_mul_r_s31__19_ VDD VSS u_mac16_top_u_mac_u_mul_net751 u_mac16_top_u_mac_u_mul_s31__19_ HFSNET_3 DFFRPQX0P5H9R
Xu_mac16_top_u_mac_u_mul_r_s31_reg_18_ u_mac16_top_u_mac_u_mul_r_s31__18_ VDD VSS u_mac16_top_u_mac_u_mul_net751 u_mac16_top_u_mac_u_mul_s31__18_ HFSNET_4 DFFRPQX0P5H9R
Xu_mac16_top_u_mac_u_mul_r_s31_reg_17_ u_mac16_top_u_mac_u_mul_r_s31__17_ VDD VSS u_mac16_top_u_mac_u_mul_net751 u_mac16_top_u_mac_u_mul_s31__17_ HFSNET_4 DFFRPQX0P5H9R
Xu_mac16_top_u_mac_u_mul_r_s31_reg_16_ u_mac16_top_u_mac_u_mul_r_s31__16_ VDD VSS u_mac16_top_u_mac_u_mul_net751 u_mac16_top_u_mac_u_mul_s31__16_ HFSNET_3 DFFRPQX0P5H9R
Xu_mac16_top_u_mac_u_mul_r_s31_reg_15_ u_mac16_top_u_mac_u_mul_r_s31__15_ VDD VSS u_mac16_top_u_mac_u_mul_net751 u_mac16_top_u_mac_u_mul_s31__15_ HFSNET_4 DFFRPQX0P5H9R
Xu_mac16_top_u_mac_u_mul_r_s31_reg_14_ u_mac16_top_u_mac_u_mul_r_s31__14_ VDD VSS u_mac16_top_u_mac_u_mul_net751 u_mac16_top_u_mac_u_mul_s31__14_ HFSNET_3 DFFRPQX0P5H9R
Xu_mac16_top_u_mac_u_mul_r_s31_reg_13_ u_mac16_top_u_mac_u_mul_r_s31__13_ VDD VSS u_mac16_top_u_mac_u_mul_net751 u_mac16_top_u_mac_u_mul_s31__13_ HFSNET_3 DFFRPQX0P5H9R
Xu_mac16_top_u_mac_u_mul_r_s31_reg_12_ u_mac16_top_u_mac_u_mul_r_s31__12_ VDD VSS u_mac16_top_u_mac_u_mul_net751 u_mac16_top_u_mac_u_mul_s31__12_ HFSNET_4 DFFRPQX0P5H9R
Xu_mac16_top_u_mac_u_mul_r_s31_reg_11_ u_mac16_top_u_mac_u_mul_r_s31__11_ VDD VSS u_mac16_top_u_mac_u_mul_net751 u_mac16_top_u_mac_u_mul_st3_1_gen_csa_fa_11__u_fa_N0 HFSNET_4 DFFRPQX0P5H9R
Xu_mac16_top_u_mac_u_mul_r_s31_reg_10_ u_mac16_top_u_mac_u_mul_r_s31__10_ VDD VSS u_mac16_top_u_mac_u_mul_net751 u_mac16_top_u_mac_u_mul_st3_1_gen_csa_fa_10__u_fa_N0 HFSNET_4 DFFRPQX0P5H9R
Xu_mac16_top_u_mac_u_mul_r_s31_reg_9_ u_mac16_top_u_mac_u_mul_r_s31__9_ VDD VSS u_mac16_top_u_mac_u_mul_net751 u_mac16_top_u_mac_u_mul_st3_1_gen_csa_fa_9__u_fa_N0 HFSNET_4 DFFRPQX0P5H9R
Xu_mac16_top_u_mac_u_mul_r_s31_reg_8_ u_mac16_top_u_mac_u_mul_r_s31__8_ VDD VSS u_mac16_top_u_mac_u_mul_net751 u_mac16_top_u_mac_u_mul_r_c21__8_ HFSNET_4 DFFRPQX0P5H9R
Xu_mac16_top_u_mac_u_mul_r_s31_reg_7_ u_mac16_top_u_mac_u_mul_r_s31__7_ VDD VSS u_mac16_top_u_mac_u_mul_net751 u_mac16_top_u_mac_u_mul_r_c21__7_ HFSNET_4 DFFRPQX0P5H9R
Xu_mac16_top_u_mac_u_mul_r_c31_reg_23_ u_mac16_top_u_mac_u_mul_r_c31__23_ VDD VSS u_mac16_top_u_mac_u_mul_net756 u_mac16_top_u_mac_u_mul_c31__23_ HFSNET_4 DFFRPQX0P5H9R
Xu_mac16_top_u_mac_u_mul_r_c31_reg_22_ u_mac16_top_u_mac_u_mul_r_c31__22_ VDD VSS u_mac16_top_u_mac_u_mul_net756 u_mac16_top_u_mac_u_mul_c31__22_ HFSNET_4 DFFRPQX0P5H9R
Xu_mac16_top_u_mac_u_mul_r_c31_reg_21_ u_mac16_top_u_mac_u_mul_r_c31__21_ VDD VSS u_mac16_top_u_mac_u_mul_net756 u_mac16_top_u_mac_u_mul_c31__21_ HFSNET_3 DFFRPQX0P5H9R
Xu_mac16_top_u_mac_u_mul_r_c31_reg_20_ u_mac16_top_u_mac_u_mul_r_c31__20_ VDD VSS u_mac16_top_u_mac_u_mul_net756 u_mac16_top_u_mac_u_mul_c31__20_ HFSNET_3 DFFRPQX0P5H9R
Xu_mac16_top_u_mac_u_mul_r_c31_reg_19_ u_mac16_top_u_mac_u_mul_r_c31__19_ VDD VSS u_mac16_top_u_mac_u_mul_net756 u_mac16_top_u_mac_u_mul_c31__19_ HFSNET_4 DFFRPQX0P5H9R
Xu_mac16_top_u_mac_u_mul_r_c31_reg_18_ u_mac16_top_u_mac_u_mul_r_c31__18_ VDD VSS u_mac16_top_u_mac_u_mul_net756 u_mac16_top_u_mac_u_mul_c31__18_ HFSNET_4 DFFRPQX0P5H9R
Xu_mac16_top_u_mac_u_mul_r_c31_reg_17_ u_mac16_top_u_mac_u_mul_r_c31__17_ VDD VSS u_mac16_top_u_mac_u_mul_net756 u_mac16_top_u_mac_u_mul_c31__17_ HFSNET_3 DFFRPQX0P5H9R
Xu_mac16_top_u_mac_u_mul_r_c31_reg_16_ u_mac16_top_u_mac_u_mul_r_c31__16_ VDD VSS u_mac16_top_u_mac_u_mul_net756 u_mac16_top_u_mac_u_mul_c31__16_ HFSNET_3 DFFRPQX0P5H9R
Xu_mac16_top_u_mac_u_mul_r_c31_reg_15_ u_mac16_top_u_mac_u_mul_r_c31__15_ VDD VSS u_mac16_top_u_mac_u_mul_net756 u_mac16_top_u_mac_u_mul_c31__15_ HFSNET_3 DFFRPQX0P5H9R
Xu_mac16_top_u_mac_u_mul_r_c31_reg_14_ u_mac16_top_u_mac_u_mul_r_c31__14_ VDD VSS u_mac16_top_u_mac_u_mul_net756 u_mac16_top_u_mac_u_mul_c31__14_ HFSNET_4 DFFRPQX0P5H9R
Xu_mac16_top_u_mac_u_mul_r_c31_reg_13_ u_mac16_top_u_mac_u_mul_r_c31__13_ VDD VSS u_mac16_top_u_mac_u_mul_net756 n2288 HFSNET_4 DFFRPQX0P5H9R
Xu_mac16_top_u_mac_u_mul_r_c31_reg_12_ u_mac16_top_u_mac_u_mul_r_c31__12_ VDD VSS u_mac16_top_u_mac_u_mul_net756 u_mac16_top_u_mac_u_mul_st3_1_gen_csa_fa_11__u_fa_N1 HFSNET_4 DFFRPQX0P5H9R
Xu_mac16_top_u_mac_u_mul_r_c31_reg_11_ u_mac16_top_u_mac_u_mul_r_c31__11_ VDD VSS u_mac16_top_u_mac_u_mul_net756 u_mac16_top_u_mac_u_mul_st3_1_gen_csa_fa_10__u_fa_N1 HFSNET_4 DFFRPQX0P5H9R
Xu_mac16_top_u_mac_u_mul_r_c31_reg_10_ u_mac16_top_u_mac_u_mul_r_c31__10_ VDD VSS u_mac16_top_u_mac_u_mul_net756 u_mac16_top_u_mac_u_mul_st3_1_gen_csa_fa_9__u_fa_N1 HFSNET_4 DFFRPQX0P5H9R
Xu_mac16_top_u_mac_u_mul_r_s30_reg_23_ u_mac16_top_u_mac_u_mul_r_s30__23_ VDD VSS u_mac16_top_u_mac_u_mul_net761 u_mac16_top_u_mac_u_mul_r_s21__23_ HFSNET_30 DFFRPQX0P5H9R
Xu_mac16_top_u_mac_u_mul_r_s40_reg_23_ u_mac16_top_u_mac_u_mul_r_s40__23_ VDD VSS u_mac16_top_u_mac_u_mul_net781 u_mac16_top_u_mac_u_mul_s40__23_ HFSNET_30 DFFRPQX0P5H9R
Xu_mac16_top_u_mac_u_mul_r_s30_reg_22_ u_mac16_top_u_mac_u_mul_r_s30__22_ VDD VSS u_mac16_top_u_mac_u_mul_net761 u_mac16_top_u_mac_u_mul_r_s21__22_ HFSNET_30 DFFRPQX0P5H9R
Xu_mac16_top_u_mac_u_mul_r_c40_reg_23_ u_mac16_top_u_mac_u_mul_r_c40__23_ VDD VSS u_mac16_top_u_mac_u_mul_net786 u_mac16_top_u_mac_u_mul_st4_0_gen_csa_fa_22__u_fa_N2 HFSNET_30 DFFRPQX0P5H9R
Xu_mac16_top_u_mac_u_mul_r_s40_reg_22_ u_mac16_top_u_mac_u_mul_r_s40__22_ VDD VSS u_mac16_top_u_mac_u_mul_net781 u_mac16_top_u_mac_u_mul_s40__22_ HFSNET_30 DFFRPQX0P5H9R
Xu_mac16_top_u_mac_u_mul_r_s30_reg_21_ u_mac16_top_u_mac_u_mul_r_s30__21_ VDD VSS u_mac16_top_u_mac_u_mul_net761 u_mac16_top_u_mac_u_mul_r_s21__21_ HFSNET_30 DFFRPQX0P5H9R
Xu_mac16_top_u_mac_u_mul_r_s30_reg_20_ u_mac16_top_u_mac_u_mul_r_s30__20_ VDD VSS u_mac16_top_u_mac_u_mul_net761 u_mac16_top_u_mac_u_mul_s30__20_ HFSNET_30 DFFRPQX0P5H9R
Xu_mac16_top_u_mac_u_mul_r_s30_reg_19_ u_mac16_top_u_mac_u_mul_r_s30__19_ VDD VSS u_mac16_top_u_mac_u_mul_net761 u_mac16_top_u_mac_u_mul_s30__19_ HFSNET_30 DFFRPQX0P5H9R
Xu_mac16_top_u_mac_u_mul_r_s30_reg_18_ u_mac16_top_u_mac_u_mul_r_s30__18_ VDD VSS u_mac16_top_u_mac_u_mul_net761 u_mac16_top_u_mac_u_mul_s30__18_ HFSNET_31 DFFRPQX0P5H9R
Xu_mac16_top_u_mac_u_mul_r_s30_reg_17_ u_mac16_top_u_mac_u_mul_r_s30__17_ VDD VSS u_mac16_top_u_mac_u_mul_net761 u_mac16_top_u_mac_u_mul_s30__17_ HFSNET_28 DFFRPQX0P5H9R
Xu_mac16_top_u_mac_u_mul_r_s30_reg_16_ u_mac16_top_u_mac_u_mul_r_s30__16_ VDD VSS u_mac16_top_u_mac_u_mul_net761 u_mac16_top_u_mac_u_mul_s30__16_ HFSNET_31 DFFRPQX0P5H9R
Xu_mac16_top_u_mac_u_mul_r_s30_reg_15_ u_mac16_top_u_mac_u_mul_r_s30__15_ VDD VSS u_mac16_top_u_mac_u_mul_net761 u_mac16_top_u_mac_u_mul_s30__15_ HFSNET_31 DFFRPQX0P5H9R
Xu_mac16_top_u_mac_u_mul_r_s30_reg_14_ u_mac16_top_u_mac_u_mul_r_s30__14_ VDD VSS u_mac16_top_u_mac_u_mul_net761 u_mac16_top_u_mac_u_mul_s30__14_ HFSNET_31 DFFRPQX0P5H9R
Xu_mac16_top_u_mac_u_mul_r_s30_reg_13_ u_mac16_top_u_mac_u_mul_r_s30__13_ VDD VSS u_mac16_top_u_mac_u_mul_net761 u_mac16_top_u_mac_u_mul_s30__13_ HFSNET_28 DFFRPQX0P5H9R
Xu_mac16_top_u_mac_u_mul_r_s30_reg_12_ u_mac16_top_u_mac_u_mul_r_s30__12_ VDD VSS u_mac16_top_u_mac_u_mul_net761 u_mac16_top_u_mac_u_mul_s30__12_ HFSNET_31 DFFRPQX0P5H9R
Xu_mac16_top_u_mac_u_mul_r_s30_reg_11_ u_mac16_top_u_mac_u_mul_r_s30__11_ VDD VSS u_mac16_top_u_mac_u_mul_net761 u_mac16_top_u_mac_u_mul_s30__11_ HFSNET_28 DFFRPQX0P5H9R
Xu_mac16_top_u_mac_u_mul_r_s30_reg_10_ u_mac16_top_u_mac_u_mul_r_s30__10_ VDD VSS u_mac16_top_u_mac_u_mul_net761 u_mac16_top_u_mac_u_mul_s30__10_ HFSNET_31 DFFRPQX0P5H9R
Xu_mac16_top_u_mac_u_mul_r_s30_reg_9_ u_mac16_top_u_mac_u_mul_r_s30__9_ VDD VSS u_mac16_top_u_mac_u_mul_net761 u_mac16_top_u_mac_u_mul_s30__9_ HFSNET_3 DFFRPQX0P5H9R
Xu_mac16_top_u_mac_u_mul_r_s30_reg_8_ u_mac16_top_u_mac_u_mul_r_s30__8_ VDD VSS u_mac16_top_u_mac_u_mul_net761 u_mac16_top_u_mac_u_mul_s30__8_ HFSNET_31 DFFRPQX0P5H9R
Xu_mac16_top_u_mac_u_mul_r_s30_reg_7_ u_mac16_top_u_mac_u_mul_r_s30__7_ VDD VSS u_mac16_top_u_mac_u_mul_net761 u_mac16_top_u_mac_u_mul_s30__7_ HFSNET_31 DFFRPQX0P5H9R
Xu_mac16_top_u_mac_u_mul_r_s30_reg_6_ u_mac16_top_u_mac_u_mul_r_s30__6_ VDD VSS u_mac16_top_u_mac_u_mul_net761 u_mac16_top_u_mac_u_mul_s30__6_ HFSNET_31 DFFRPQX0P5H9R
Xu_mac16_top_u_mac_u_mul_r_s30_reg_5_ u_mac16_top_u_mac_u_mul_r_s30__5_ VDD VSS u_mac16_top_u_mac_u_mul_net761 u_mac16_top_u_mac_u_mul_s30__5_ HFSNET_31 DFFRPQX0P5H9R
Xu_mac16_top_u_mac_u_mul_r_s30_reg_4_ u_mac16_top_u_mac_u_mul_r_s30__4_ VDD VSS u_mac16_top_u_mac_u_mul_net761 u_mac16_top_u_mac_u_mul_st3_0_gen_csa_fa_4__u_fa_N0 HFSNET_31 DFFRPQX0P5H9R
Xu_mac16_top_u_mac_u_mul_r_s30_reg_3_ u_mac16_top_u_mac_u_mul_r_s30__3_ VDD VSS u_mac16_top_u_mac_u_mul_net761 u_mac16_top_u_mac_u_mul_st3_0_gen_csa_fa_3__u_fa_N0 HFSNET_31 DFFRPQX0P5H9R
Xu_mac16_top_u_mac_u_mul_r_s40_reg_3_ u_mac16_top_u_mac_u_mul_N36 VDD VSS u_mac16_top_u_mac_u_mul_net781 u_mac16_top_u_mac_u_mul_r_s30__3_ HFSNET_32 DFFRPQX0P5H9R
Xu_mac16_top_u_mac_u_mul_r_s30_reg_2_ u_mac16_top_u_mac_u_mul_r_s30__2_ VDD VSS u_mac16_top_u_mac_u_mul_net761 u_mac16_top_u_mac_u_mul_r_s20__2_ HFSNET_32 DFFRPQX0P5H9R
Xu_mac16_top_u_mac_u_mul_r_s40_reg_2_ u_mac16_top_u_mac_u_mul_N35 VDD VSS u_mac16_top_u_mac_u_mul_net781 u_mac16_top_u_mac_u_mul_r_s30__2_ HFSNET_32 DFFRPQX0P5H9R
Xu_mac16_top_u_mac_u_mul_r_s30_reg_1_ u_mac16_top_u_mac_u_mul_r_s30__1_ VDD VSS u_mac16_top_u_mac_u_mul_net761 u_mac16_top_u_mac_u_mul_r_s20__1_ HFSNET_32 DFFRPQX0P5H9R
Xu_mac16_top_u_mac_u_mul_r_s40_reg_1_ u_mac16_top_u_mac_u_mul_N34 VDD VSS u_mac16_top_u_mac_u_mul_net781 u_mac16_top_u_mac_u_mul_r_s30__1_ HFSNET_31 DFFRPQX0P5H9R
Xu_mac16_top_u_mac_u_mul_r_s30_reg_0_ u_mac16_top_u_mac_u_mul_r_s30__0_ VDD VSS u_mac16_top_u_mac_u_mul_net761 u_mac16_top_u_mac_u_mul_r_s20__0_ HFSNET_31 DFFRPQX0P5H9R
Xu_mac16_top_u_mac_u_mul_r_s40_reg_0_ u_mac16_top_u_mac_u_mul_N33 VDD VSS u_mac16_top_u_mac_u_mul_net781 u_mac16_top_u_mac_u_mul_r_s30__0_ HFSNET_31 DFFRPQX0P5H9R
Xu_mac16_top_u_mac_u_mul_r_c30_reg_21_ u_mac16_top_u_mac_u_mul_r_c30__21_ VDD VSS u_mac16_top_u_mac_u_mul_net756 u_mac16_top_u_mac_u_mul_st3_0_gen_csa_fa_20__u_fa_N2 HFSNET_31 DFFRPQX0P5H9R
Xu_mac16_top_u_mac_u_mul_r_c30_reg_20_ u_mac16_top_u_mac_u_mul_r_c30__20_ VDD VSS u_mac16_top_u_mac_u_mul_net756 u_mac16_top_u_mac_u_mul_st3_0_gen_csa_fa_19__u_fa_N2 HFSNET_4 DFFRPQX0P5H9R
Xu_mac16_top_u_mac_u_mul_r_c30_reg_19_ u_mac16_top_u_mac_u_mul_r_c30__19_ VDD VSS u_mac16_top_u_mac_u_mul_net756 u_mac16_top_u_mac_u_mul_c30__19_ HFSNET_3 DFFRPQX0P5H9R
Xu_mac16_top_u_mac_u_mul_r_c30_reg_18_ u_mac16_top_u_mac_u_mul_r_c30__18_ VDD VSS u_mac16_top_u_mac_u_mul_net756 u_mac16_top_u_mac_u_mul_c30__18_ HFSNET_30 DFFRPQX0P5H9R
Xu_mac16_top_u_mac_u_mul_r_c30_reg_17_ u_mac16_top_u_mac_u_mul_r_c30__17_ VDD VSS u_mac16_top_u_mac_u_mul_net756 u_mac16_top_u_mac_u_mul_c30__17_ HFSNET_30 DFFRPQX0P5H9R
Xu_mac16_top_u_mac_u_mul_r_c30_reg_16_ u_mac16_top_u_mac_u_mul_r_c30__16_ VDD VSS u_mac16_top_u_mac_u_mul_net756 u_mac16_top_u_mac_u_mul_c30__16_ HFSNET_28 DFFRPQX0P5H9R
Xu_mac16_top_u_mac_u_mul_r_c30_reg_15_ u_mac16_top_u_mac_u_mul_r_c30__15_ VDD VSS u_mac16_top_u_mac_u_mul_net756 u_mac16_top_u_mac_u_mul_c30__15_ HFSNET_28 DFFRPQX0P5H9R
Xu_mac16_top_u_mac_u_mul_r_c30_reg_14_ u_mac16_top_u_mac_u_mul_r_c30__14_ VDD VSS u_mac16_top_u_mac_u_mul_net756 u_mac16_top_u_mac_u_mul_c30__14_ HFSNET_28 DFFRPQX0P5H9R
Xu_mac16_top_u_mac_u_mul_r_c30_reg_13_ u_mac16_top_u_mac_u_mul_r_c30__13_ VDD VSS u_mac16_top_u_mac_u_mul_net756 u_mac16_top_u_mac_u_mul_c30__13_ HFSNET_30 DFFRPQX0P5H9R
Xu_mac16_top_u_mac_u_mul_r_c30_reg_12_ u_mac16_top_u_mac_u_mul_r_c30__12_ VDD VSS u_mac16_top_u_mac_u_mul_net751 u_mac16_top_u_mac_u_mul_c30__12_ HFSNET_31 DFFRPQX0P5H9R
Xu_mac16_top_u_mac_u_mul_r_c30_reg_11_ u_mac16_top_u_mac_u_mul_r_c30__11_ VDD VSS u_mac16_top_u_mac_u_mul_net751 u_mac16_top_u_mac_u_mul_c30__11_ HFSNET_3 DFFRPQX0P5H9R
Xu_mac16_top_u_mac_u_mul_r_c40_reg_12_ u_mac16_top_u_mac_u_mul_r_c40__12_ VDD VSS u_mac16_top_u_mac_u_mul_net771 n2278 HFSNET_28 DFFRPQX0P5H9R
Xu_mac16_top_u_mac_u_mul_r_c30_reg_10_ u_mac16_top_u_mac_u_mul_r_c30__10_ VDD VSS u_mac16_top_u_mac_u_mul_net751 u_mac16_top_u_mac_u_mul_c30__10_ HFSNET_3 DFFRPQX0P5H9R
Xu_mac16_top_u_mac_u_mul_r_c30_reg_9_ u_mac16_top_u_mac_u_mul_r_c30__9_ VDD VSS u_mac16_top_u_mac_u_mul_net751 u_mac16_top_u_mac_u_mul_c30__9_ HFSNET_32 DFFRPQX0P5H9R
Xu_mac16_top_u_mac_u_mul_r_c30_reg_8_ u_mac16_top_u_mac_u_mul_r_c30__8_ VDD VSS u_mac16_top_u_mac_u_mul_net751 u_mac16_top_u_mac_u_mul_c30__8_ HFSNET_3 DFFRPQX0P5H9R
Xu_mac16_top_u_mac_u_mul_r_c30_reg_7_ u_mac16_top_u_mac_u_mul_r_c30__7_ VDD VSS u_mac16_top_u_mac_u_mul_net756 u_mac16_top_u_mac_u_mul_c30__7_ HFSNET_31 DFFRPQX0P5H9R
Xu_mac16_top_u_mac_u_mul_r_c30_reg_6_ u_mac16_top_u_mac_u_mul_r_c30__6_ VDD VSS u_mac16_top_u_mac_u_mul_net751 u_mac16_top_u_mac_u_mul_c30__6_ HFSNET_3 DFFRPQX0P5H9R
Xu_mac16_top_u_mac_u_mul_r_c30_reg_5_ u_mac16_top_u_mac_u_mul_r_c30__5_ VDD VSS u_mac16_top_u_mac_u_mul_net751 u_mac16_top_u_mac_u_mul_st3_0_gen_csa_fa_4__u_fa_N1 HFSNET_3 DFFRPQX0P5H9R
Xu_mac16_top_u_mac_u_mul_r_s40_reg_5_ u_mac16_top_u_mac_u_mul_r_s40__5_ VDD VSS u_mac16_top_u_mac_u_mul_net781 u_mac16_top_u_mac_u_mul_st4_0_gen_csa_fa_5__u_fa_N0 HFSNET_31 DFFRPQX0P5H9R
Xu_mac16_top_u_mac_u_mul_r_c30_reg_4_ u_mac16_top_u_mac_u_mul_r_c30__4_ VDD VSS u_mac16_top_u_mac_u_mul_net761 u_mac16_top_u_mac_u_mul_st3_0_gen_csa_fa_3__u_fa_N1 HFSNET_29 DFFRPQX0P5H9R
Xu_mac16_top_u_mac_u_mul_r_s40_reg_4_ u_mac16_top_u_mac_u_mul_N37 VDD VSS u_mac16_top_u_mac_u_mul_net781 u_mac16_top_u_mac_u_mul_st4_0_gen_csa_fa_4__u_fa_N0 HFSNET_28 DFFRPQX0P5H9R
Xu_mac16_top_u_mac_u_mul_r_c23_reg_16_ u_mac16_top_u_mac_u_mul_r_c23__16_ VDD VSS u_mac16_top_u_mac_u_mul_net736 u_mac16_top_u_mac_u_mul_st2_3_gen_csa_fa_15__u_fa_N1 HFSNET_3 DFFRPQX0P5H9R
Xu_mac16_top_u_mac_u_mul_r_c23_reg_17_ u_mac16_top_u_mac_u_mul_r_c23__17_ VDD VSS u_mac16_top_u_mac_u_mul_net736 u_mac16_top_u_mac_u_mul_st2_3_gen_csa_fa_16__u_fa_N1 HFSNET_3 DFFRPQX0P5H9R
Xu_mac16_top_u_mac_u_mul_r_c23_reg_18_ u_mac16_top_u_mac_u_mul_r_c23__18_ VDD VSS u_mac16_top_u_mac_u_mul_net736 u_mac16_top_u_mac_u_mul_st2_3_gen_csa_fa_17__u_fa_N1 HFSNET_3 DFFRPQX0P5H9R
Xu_mac16_top_u_mac_u_mul_r_c23_reg_19_ u_mac16_top_u_mac_u_mul_r_c23__19_ VDD VSS u_mac16_top_u_mac_u_mul_net736 u_mac16_top_u_mac_u_mul_st2_3_gen_csa_fa_18__u_fa_N1 HFSNET_3 DFFRPQX0P5H9R
Xu_mac16_top_u_mac_u_mul_r_c23_reg_20_ u_mac16_top_u_mac_u_mul_r_c23__20_ VDD VSS u_mac16_top_u_mac_u_mul_net736 u_mac16_top_u_mac_u_mul_st2_3_gen_csa_fa_19__u_fa_N1 HFSNET_31 DFFRPQX0P5H9R
Xu_mac16_top_u_mac_u_mul_r_c23_reg_21_ u_mac16_top_u_mac_u_mul_r_c23__21_ VDD VSS u_mac16_top_u_mac_u_mul_net736 u_mac16_top_u_mac_u_mul_st2_3_gen_csa_fa_20__u_fa_N1 HFSNET_3 DFFRPQX0P5H9R
Xu_mac16_top_u_mac_u_mul_r_c23_reg_22_ u_mac16_top_u_mac_u_mul_r_c23__22_ VDD VSS u_mac16_top_u_mac_u_mul_net736 u_mac16_top_u_mac_u_mul_st2_3_gen_csa_fa_21__u_fa_N1 HFSNET_3 DFFRPQX0P5H9R
Xu_mac16_top_u_mac_u_mul_r_c23_reg_23_ u_mac16_top_u_mac_u_mul_r_c23__23_ VDD VSS u_mac16_top_u_mac_u_mul_net736 u_mac16_top_u_mac_u_mul_st2_3_gen_csa_fa_22__u_fa_N1 HFSNET_1 DFFRPQX0P5H9R
Xu_mac16_top_u_mac_u_mul_r_s23_reg_14_ u_mac16_top_u_mac_u_mul_r_s23__14_ VDD VSS u_mac16_top_u_mac_u_mul_net741 u_mac16_top_u_mac_u_mul_st1_4_gen_csa_fa_13__u_fa_N1 HFSNET_6 DFFRPQX0P5H9R
Xu_mac16_top_u_mac_u_mul_r_s23_reg_15_ u_mac16_top_u_mac_u_mul_r_s23__15_ VDD VSS u_mac16_top_u_mac_u_mul_net741 u_mac16_top_u_mac_u_mul_st2_3_gen_csa_fa_15__u_fa_N0 HFSNET_1 DFFRPQX0P5H9R
Xu_mac16_top_u_mac_u_mul_r_s23_reg_16_ u_mac16_top_u_mac_u_mul_r_s23__16_ VDD VSS u_mac16_top_u_mac_u_mul_net741 u_mac16_top_u_mac_u_mul_st2_3_gen_csa_fa_16__u_fa_N0 HFSNET_5 DFFRPQX0P5H9R
Xu_mac16_top_u_mac_u_mul_r_s23_reg_17_ u_mac16_top_u_mac_u_mul_r_s23__17_ VDD VSS u_mac16_top_u_mac_u_mul_net741 u_mac16_top_u_mac_u_mul_st2_3_gen_csa_fa_17__u_fa_N0 HFSNET_5 DFFRPQX0P5H9R
Xu_mac16_top_u_mac_u_mul_r_s23_reg_18_ u_mac16_top_u_mac_u_mul_r_s23__18_ VDD VSS u_mac16_top_u_mac_u_mul_net741 u_mac16_top_u_mac_u_mul_st2_3_gen_csa_fa_18__u_fa_N0 HFSNET_5 DFFRPQX0P5H9R
Xu_mac16_top_u_mac_u_mul_r_s23_reg_19_ u_mac16_top_u_mac_u_mul_r_s23__19_ VDD VSS u_mac16_top_u_mac_u_mul_net741 u_mac16_top_u_mac_u_mul_st2_3_gen_csa_fa_19__u_fa_N0 HFSNET_5 DFFRPQX0P5H9R
Xu_mac16_top_u_mac_u_mul_r_s23_reg_20_ u_mac16_top_u_mac_u_mul_r_s23__20_ VDD VSS u_mac16_top_u_mac_u_mul_net736 u_mac16_top_u_mac_u_mul_st2_3_gen_csa_fa_20__u_fa_N0 HFSNET_6 DFFRPQX0P5H9R
Xu_mac16_top_u_mac_u_mul_r_s23_reg_21_ u_mac16_top_u_mac_u_mul_r_s23__21_ VDD VSS u_mac16_top_u_mac_u_mul_net736 u_mac16_top_u_mac_u_mul_st2_3_gen_csa_fa_21__u_fa_N0 HFSNET_3 DFFRPQX0P5H9R
Xu_mac16_top_u_mac_u_mul_r_c41_reg_22_ u_mac16_top_u_mac_u_mul_r_c41__22_ VDD VSS u_mac16_top_u_mac_u_mul_net786 n2284 HFSNET_32 DFFRPQX0P5H9R
Xu_mac16_top_u_mac_u_mul_r_s23_reg_22_ u_mac16_top_u_mac_u_mul_r_s23__22_ VDD VSS u_mac16_top_u_mac_u_mul_net736 u_mac16_top_u_mac_u_mul_st2_3_gen_csa_fa_22__u_fa_N0 HFSNET_2 DFFRPQX0P5H9R
Xu_mac16_top_u_mac_u_mul_r_c41_reg_23_ u_mac16_top_u_mac_u_mul_r_c41__23_ VDD VSS u_mac16_top_u_mac_u_mul_net786 n2283 HFSNET_31 DFFRPQX0P5H9R
Xu_mac16_top_u_mac_u_mul_r_s23_reg_23_ u_mac16_top_u_mac_u_mul_r_s23__23_ VDD VSS u_mac16_top_u_mac_u_mul_net736 u_mac16_top_u_mac_u_mul_st2_3_gen_csa_fa_23__u_fa_N0 HFSNET_2 DFFRPQX0P5H9R
Xu_mac16_top_u_mac_u_mul_r_s41_reg_23_ u_mac16_top_u_mac_u_mul_r_s41__23_ VDD VSS u_mac16_top_u_mac_u_mul_net771 u_mac16_top_u_mac_u_mul_s41__23_ HFSNET_4 DFFRPQX0P5H9R
Xu_mac16_top_opB_reg_reg_15_ u_mac16_top_opB_reg__15_ VDD VSS u_mac16_top_net564 n788 HFSNET_14 DFFRPQX0P5H9R
Xu_mac16_top_u_mac_last_prod_reg_5_ u_mac16_top_u_mac_last_prod__5_ VDD VSS u_mac16_top_u_mac_net693 u_mac16_top_u_mac_mult_result__5_ HFSNET_29 DFFRPQX0P5H9R
Xu_mac16_top_u_mac_last_prod_reg_23_ u_mac16_top_u_mac_last_prod__23_ VDD VSS u_mac16_top_u_mac_net693 u_mac16_top_u_mac_mult_result__23_ HFSNET_29 DFFRPQX0P5H9R
Xu_mac16_top_u_mac_u_mul_product_reg_reg_15_ u_mac16_top_u_mac_mult_result__15_ VDD VSS clk ZBUF_2_6 HFSNET_32 DFFRPQX0P5H9R
Xu_mac16_top_u_out_busy_reg u_mac16_top_u_out_busy VDD VSS clk n732 HFSNET_16 DFFRPQX0P5H9R
Xu_mac16_top_u_out_bits_left_reg_1_ u_mac16_top_u_out_bits_left__1_ VDD VSS u_mac16_top_u_out_net664 n936 HFSNET_25 DFFRPQX0P5H9R
Xu_mac16_top_u_out_bits_left_reg_0_ u_mac16_top_u_out_bits_left__0_ VDD VSS u_mac16_top_u_out_net664 n2353 HFSNET_25 DFFRPQX0P5H9R
Xu_mac16_top_op_fifo_count_reg_0_ u_mac16_top_op_fifo_count__0_ VDD VSS u_mac16_top_net617 n2340 HFSNET_10 DFFRPQX0P5H9R
Xu_mac16_top_op_fifo_count_reg_1_ u_mac16_top_op_fifo_count__1_ VDD VSS u_mac16_top_net617 n2347 HFSNET_10 DFFRPQX0P5H9R
Xu_mac16_top_u_out_serial_out_reg sum_out VDD VSS clk u_mac16_top_u_out_N16 HFSNET_32 DFFRPQX0P5H9R
Xu_mac16_top_u_out_out_ready_reg out_ready VDD VSS clk n730 HFSNET_16 DFFRPQX0P5H9R
Xu_mac16_top_u_mac_carry_reg carry VDD VSS u_mac16_top_u_mac_net688 n729 HFSNET_16 DFFRPQX0P5H9R
Xu_mac16_top_u_mac_u_mul_r_s40_reg_15_ u_mac16_top_u_mac_u_mul_r_s40__15_ VDD VSS u_mac16_top_u_mac_u_mul_net781 u_mac16_top_u_mac_u_mul_s40__15_ HFSNET_28 DFFRPQX0P5H9R
Xu_mac16_top_u_mac_u_mul_r_s40_reg_10_ u_mac16_top_u_mac_u_mul_r_s40__10_ VDD VSS u_mac16_top_u_mac_u_mul_net781 u_mac16_top_u_mac_u_mul_s40__10_ HFSNET_28 DFFRPQX0P5H9R
Xu_mac16_top_u_mac_u_mul_r_s40_reg_9_ u_mac16_top_u_mac_u_mul_r_s40__9_ VDD VSS u_mac16_top_u_mac_u_mul_net771 u_mac16_top_u_mac_u_mul_s40__9_ HFSNET_31 DFFRPQX1H9R
Xu_mac16_top_u_mac_u_mul_r_c41_reg_15_ u_mac16_top_u_mac_u_mul_r_c41__15_ VDD VSS u_mac16_top_u_mac_u_mul_net771 u_mac16_top_u_mac_u_mul_st4_1_gen_csa_fa_14__u_fa_N1 HFSNET_3 DFFRPQX0P5H9R
Xu_mac16_top_u_mac_accum_reg_reg_0_ u_mac16_top_u_mac_accum_reg__0_ VDD VSS u_mac16_top_u_mac_net682 u_mac16_top_u_mac_add_tmp_comb__0_ HFSNET_20 DFFRPQX0P5H9R
Xu_mac16_top_u_mac_accum_reg_reg_4_ u_mac16_top_u_mac_accum_reg__4_ VDD VSS u_mac16_top_u_mac_net682 u_mac16_top_u_mac_add_tmp_comb__4_ HFSNET_20 DFFRPQX0P5H9R
Xu_mac16_top_fifo_count_reg_0_ u_mac16_top_fifo_count__0_ VDD VSS u_mac16_top_net647 u_mac16_top_N118 HFSNET_25 DFFRPQX0P5H9R
Xu_mac16_top_mac_result_shadow_reg_23_ u_mac16_top_mac_result_shadow__23_ VDD VSS u_mac16_top_net622 u_mac16_top_N115 HFSNET_24 DFFRPQX0P5H9R
Xu_mac16_top_mac_result_shadow_reg_22_ u_mac16_top_mac_result_shadow__22_ VDD VSS u_mac16_top_net622 u_mac16_top_N114 HFSNET_23 DFFRPQX0P5H9R
Xu_mac16_top_mac_result_shadow_reg_21_ u_mac16_top_mac_result_shadow__21_ VDD VSS u_mac16_top_net622 u_mac16_top_N113 HFSNET_23 DFFRPQX0P5H9R
Xu_mac16_top_mac_result_shadow_reg_20_ u_mac16_top_mac_result_shadow__20_ VDD VSS u_mac16_top_net622 u_mac16_top_N112 HFSNET_23 DFFRPQX0P5H9R
Xu_mac16_top_mac_result_shadow_reg_18_ u_mac16_top_mac_result_shadow__18_ VDD VSS u_mac16_top_net622 u_mac16_top_N110 HFSNET_18 DFFRPQX0P5H9R
Xu_mac16_top_mac_result_shadow_reg_17_ u_mac16_top_mac_result_shadow__17_ VDD VSS u_mac16_top_net622 u_mac16_top_N109 HFSNET_24 DFFRPQX0P5H9R
Xu_mac16_top_mac_result_shadow_reg_16_ u_mac16_top_mac_result_shadow__16_ VDD VSS u_mac16_top_net622 u_mac16_top_N108 HFSNET_23 DFFRPQX0P5H9R
Xu_mac16_top_mac_result_shadow_reg_15_ u_mac16_top_mac_result_shadow__15_ VDD VSS u_mac16_top_net622 u_mac16_top_N107 HFSNET_24 DFFRPQX0P5H9R
Xu_mac16_top_mac_result_shadow_reg_14_ u_mac16_top_mac_result_shadow__14_ VDD VSS u_mac16_top_net622 u_mac16_top_N106 HFSNET_24 DFFRPQX0P5H9R
Xu_mac16_top_mac_result_shadow_reg_13_ u_mac16_top_mac_result_shadow__13_ VDD VSS u_mac16_top_net622 u_mac16_top_N105 HFSNET_22 DFFRPQX0P5H9R
Xu_mac16_top_mac_result_shadow_reg_12_ u_mac16_top_mac_result_shadow__12_ VDD VSS u_mac16_top_net622 u_mac16_top_N104 HFSNET_22 DFFRPQX0P5H9R
Xu_mac16_top_mac_result_shadow_reg_11_ u_mac16_top_mac_result_shadow__11_ VDD VSS u_mac16_top_net622 u_mac16_top_N103 HFSNET_22 DFFRPQX0P5H9R
Xu_mac16_top_mac_result_shadow_reg_10_ u_mac16_top_mac_result_shadow__10_ VDD VSS u_mac16_top_net622 u_mac16_top_N102 HFSNET_22 DFFRPQX0P5H9R
Xu_mac16_top_mac_result_shadow_reg_9_ u_mac16_top_mac_result_shadow__9_ VDD VSS u_mac16_top_net622 u_mac16_top_N101 HFSNET_21 DFFRPQX0P5H9R
Xu_mac16_top_mac_result_shadow_reg_8_ u_mac16_top_mac_result_shadow__8_ VDD VSS u_mac16_top_net622 u_mac16_top_N100 HFSNET_21 DFFRPQX0P5H9R
Xu_mac16_top_mac_result_shadow_reg_7_ u_mac16_top_mac_result_shadow__7_ VDD VSS u_mac16_top_net622 u_mac16_top_N99 HFSNET_22 DFFRPQX0P5H9R
Xu_mac16_top_mac_result_shadow_reg_6_ u_mac16_top_mac_result_shadow__6_ VDD VSS u_mac16_top_net622 u_mac16_top_N98 HFSNET_22 DFFRPQX0P5H9R
Xu_mac16_top_mac_result_shadow_reg_5_ u_mac16_top_mac_result_shadow__5_ VDD VSS u_mac16_top_net622 u_mac16_top_N97 HFSNET_21 DFFRPQX0P5H9R
Xu_mac16_top_mac_result_shadow_reg_4_ u_mac16_top_mac_result_shadow__4_ VDD VSS u_mac16_top_net622 u_mac16_top_N96 HFSNET_21 DFFRPQX0P5H9R
Xu_mac16_top_mac_result_shadow_reg_3_ u_mac16_top_mac_result_shadow__3_ VDD VSS u_mac16_top_net622 u_mac16_top_N95 HFSNET_21 DFFRPQX0P5H9R
Xu_mac16_top_mac_result_shadow_reg_1_ u_mac16_top_mac_result_shadow__1_ VDD VSS u_mac16_top_net622 u_mac16_top_N93 HFSNET_21 DFFRPQX0P5H9R
Xu_mac16_top_u_mac_last_prod_reg_13_ u_mac16_top_u_mac_last_prod__13_ VDD VSS u_mac16_top_u_mac_net693 u_mac16_top_u_mac_mult_result__13_ HFSNET_29 DFFRPQX0P5H9R
Xu_mac16_top_u_mac_accum_reg_reg_12_ u_mac16_top_u_mac_accum_reg__12_ VDD VSS u_mac16_top_u_mac_net682 u_mac16_top_u_mac_add_tmp_comb__12_ HFSNET_29 DFFRPQX0P5H9R
Xu_mac16_top_u_mac_u_mul_r_c20_reg_16_ u_mac16_top_u_mac_u_mul_r_c20__16_ VDD VSS u_mac16_top_u_mac_u_mul_net721 u_mac16_top_u_mac_u_mul_c20__16_ HFSNET_6 DFFRPQX0P5H9R
Xu_mac16_top_u_mac_last_prod_reg_2_ u_mac16_top_u_mac_last_prod__2_ VDD VSS u_mac16_top_u_mac_net693 u_mac16_top_u_mac_mult_result__2_ HFSNET_29 DFFRPQX0P5H9R
Xu_mac16_top_u_mac_accum_reg_reg_13_ u_mac16_top_u_mac_accum_reg__13_ VDD VSS u_mac16_top_u_mac_net682 u_mac16_top_u_mac_add_tmp_comb__13_ HFSNET_29 DFFRPQX0P5H9R
Xu_mac16_top_u_mac_u_mul_r_c41_reg_16_ u_mac16_top_u_mac_u_mul_r_c41__16_ VDD VSS u_mac16_top_u_mac_u_mul_net771 u_mac16_top_u_mac_u_mul_st4_1_gen_csa_fa_15__u_fa_N1 HFSNET_28 DFFRPQX0P5H9R
Xu_mac16_top_u_mac_u_mul_r_s40_reg_16_ u_mac16_top_u_mac_u_mul_r_s40__16_ VDD VSS u_mac16_top_u_mac_u_mul_net781 u_mac16_top_u_mac_u_mul_s40__16_ HFSNET_28 DFFRPQX0P5H9R
Xu_mac16_top_u_mac_u_mul_r_c40_reg_14_ u_mac16_top_u_mac_u_mul_r_c40__14_ VDD VSS u_mac16_top_u_mac_u_mul_net771 n2267 HFSNET_28 DFFRPQX0P5H9R
Xu_mac16_top_u_mac_accum_reg_reg_1_ u_mac16_top_u_mac_accum_reg__1_ VDD VSS u_mac16_top_u_mac_net682 u_mac16_top_u_mac_add_tmp_comb__1_ HFSNET_20 DFFRPQX0P5H9R
Xu_mac16_top_u_mac_u_mul_r_c40_reg_9_ u_mac16_top_u_mac_u_mul_r_c40__9_ VDD VSS u_mac16_top_u_mac_u_mul_net771 n2266 HFSNET_31 DFFRPQX0P5H9R
Xu_mac16_top_mac_result_shadow_reg_0_ u_mac16_top_mac_result_shadow__0_ VDD VSS u_mac16_top_net622 u_mac16_top_N92 HFSNET_21 DFFRPQX0P5H9R
Xu_mac16_top_u_mac_u_mul_r_s40_reg_6_ u_mac16_top_u_mac_u_mul_r_s40__6_ VDD VSS u_mac16_top_u_mac_u_mul_net781 u_mac16_top_u_mac_u_mul_st4_0_gen_csa_fa_6__u_fa_N0 HFSNET_30 DFFRPQX0P5H9R
Xu_mac16_top_u_mac_last_prod_reg_14_ u_mac16_top_u_mac_last_prod__14_ VDD VSS u_mac16_top_u_mac_net693 u_mac16_top_u_mac_mult_result__14_ HFSNET_29 DFFRPQX0P5H9R
Xu_mac16_top_u_mac_accum_reg_reg_2_ u_mac16_top_u_mac_accum_reg__2_ VDD VSS u_mac16_top_u_mac_net682 u_mac16_top_u_mac_add_tmp_comb__2_ HFSNET_20 DFFRPQX0P5H9R
Xu_mac16_top_u_mac_u_mul_r_s40_reg_17_ u_mac16_top_u_mac_u_mul_r_s40__17_ VDD VSS u_mac16_top_u_mac_u_mul_net781 u_mac16_top_u_mac_u_mul_s40__17_ HFSNET_28 DFFRPQX0P5H9R
Xu_mac16_top_u_mac_last_prod_reg_11_ u_mac16_top_u_mac_last_prod__11_ VDD VSS u_mac16_top_u_mac_net693 u_mac16_top_u_mac_mult_result__11_ HFSNET_29 DFFRPQX0P5H9R
Xu_mac16_top_u_mac_last_prod_reg_16_ u_mac16_top_u_mac_last_prod__16_ VDD VSS u_mac16_top_u_mac_net693 u_mac16_top_u_mac_mult_result__16_ HFSNET_29 DFFRPQX0P5H9R
Xu_mac16_top_u_mac_u_mul_r_c41_reg_21_ u_mac16_top_u_mac_u_mul_r_c41__21_ VDD VSS u_mac16_top_u_mac_u_mul_net786 n2285 HFSNET_30 DFFRPQX0P5H9R
Xu_mac16_top_u_mac_accum_reg_reg_7_ u_mac16_top_u_mac_accum_reg__7_ VDD VSS u_mac16_top_u_mac_net682 u_mac16_top_u_mac_add_tmp_comb__7_ HFSNET_20 DFFRPQX0P5H9R
Xu_mac16_top_fifo_rd_ptr_reg_0_ u_mac16_top_fifo_rd_ptr__0_ VDD VSS u_mac16_top_net622 n942 HFSNET_26 DFFSQNX0P5H9R
Xu_mac16_top_fifo_rd_ptr_reg_1_ u_mac16_top_fifo_rd_ptr__1_ VDD VSS u_mac16_top_net622 n944 n2368 DFFSQNX0P5H9R
Xu_mac16_top_fifo_wr_ptr_reg_1_ u_mac16_top_fifo_wr_ptr__1_ VDD VSS u_mac16_top_net647 n945 n2368 DFFSQNX0P5H9R
Xu_mac16_top_fifo_wr_ptr_reg_0_ u_mac16_top_fifo_wr_ptr__0_ VDD VSS u_mac16_top_net647 n939 HFSNET_26 DFFSQNX0P5H9R
Xu_mac16_top_op_fifo_wr_ptr_reg_1_ u_mac16_top_op_fifo_wr_ptr__1_ VDD VSS clk n946 n2368 DFFSQNX0P5H9R
Xu_mac16_top_op_fifo_wr_ptr_reg_0_ u_mac16_top_op_fifo_wr_ptr__0_ VDD VSS clk n940 HFSNET_26 DFFSQNX0P5H9R
Xu_mac16_top_result_fifo_reg_3__13_ n2343 VDD VSS u_mac16_top_net595 u_mac16_top_mac_result__13_ HFSNET_18 DFFRPQNX0P5H9R
Xu_mac16_top_u_mac_u_mul_r_s40_reg_12_ u_mac16_top_u_mac_u_mul_r_s40__12_ VDD VSS u_mac16_top_u_mac_u_mul_net781 n938 n2368 DFFSQNX1H9R
Xu_mac16_top_opA_reg_reg_15_ u_mac16_top_opA_reg__15_ VDD VSS u_mac16_top_net570 n804 HFSNET_1 DFFRPQX0P5H9R
Xu_mac16_top_u_mac_u_mul_r_c40_reg_18_ u_mac16_top_u_mac_u_mul_r_c40__18_ VDD VSS u_mac16_top_u_mac_u_mul_net786 n2280 HFSNET_28 DFFRPQX0P5H9R
Xu_mac16_top_u_mac_u_mul_r_s40_reg_19_ u_mac16_top_u_mac_u_mul_r_s40__19_ VDD VSS u_mac16_top_u_mac_u_mul_net781 u_mac16_top_u_mac_u_mul_s40__19_ HFSNET_30 DFFRPQX0P5H9R
Xu_mac16_top_u_mac_u_mul_r_c40_reg_8_ u_mac16_top_u_mac_u_mul_r_c40__8_ VDD VSS u_mac16_top_u_mac_u_mul_net786 n2275 HFSNET_31 DFFRPQX0P5H9R
Xu_mac16_top_u_mac_u_mul_r_c40_reg_7_ u_mac16_top_u_mac_u_mul_r_c40__7_ VDD VSS u_mac16_top_u_mac_u_mul_net786 u_mac16_top_u_mac_u_mul_st4_0_gen_csa_fa_6__u_fa_N1 HFSNET_28 DFFRPQX0P5H9R
Xu_mac16_top_opA_reg_reg_14_ u_mac16_top_opA_reg__14_ VDD VSS u_mac16_top_net570 n803 HFSNET_8 DFFRPQX0P5H9R
Xu_mac16_top_u_mac_u_mul_r_s21_reg_10_ u_mac16_top_u_mac_u_mul_r_s21__10_ VDD VSS u_mac16_top_u_mac_u_mul_net731 n756 HFSNET_3 DFFRPQX0P5H9R
Xu_mac16_top_u_mac_sum_out_reg_9_ u_mac16_top_mac_result__9_ VDD VSS u_mac16_top_u_mac_net688 u_mac16_top_u_mac_add_tmp_comb__9_ HFSNET_20 DFFRPQX0P5H9R
Xu_mac16_top_opB_reg_reg_4_ u_mac16_top_opB_reg__4_ VDD VSS u_mac16_top_net564 n777 HFSNET_8 DFFRPQX0P5H9R
Xu_mac16_top_opB_reg_reg_7_ u_mac16_top_opB_reg__7_ VDD VSS u_mac16_top_net564 n780 HFSNET_8 DFFRPQX0P5H9R
Xu_mac16_top_u_mac_u_mul_r_s21_reg_19_ u_mac16_top_u_mac_u_mul_r_s21__19_ VDD VSS u_mac16_top_u_mac_u_mul_net731 n747 HFSNET_1 DFFRPQX0P5H9R
Xu_mac16_top_opB_reg_reg_0_ u_mac16_top_opB_reg__0_ VDD VSS u_mac16_top_net564 n773 HFSNET_8 DFFRPQX0P5H9R
Xu_mac16_top_opB_reg_reg_6_ u_mac16_top_opB_reg__6_ VDD VSS u_mac16_top_net564 n779 HFSNET_8 DFFRPQX0P5H9R
Xu_mac16_top_opA_reg_reg_2_ u_mac16_top_opA_reg__2_ VDD VSS u_mac16_top_net570 n791 HFSNET_8 DFFRPQX0P5H9R
Xu_mac16_top_opA_reg_reg_7_ u_mac16_top_opA_reg__7_ VDD VSS u_mac16_top_net570 n796 HFSNET_7 DFFRPQX0P5H9R
Xu_mac16_top_u_mac_u_mul_r_s20_reg_8_ u_mac16_top_u_mac_u_mul_r_s20__8_ VDD VSS u_mac16_top_u_mac_u_mul_net721 n741 HFSNET_6 DFFRPQX0P5H9R
Xu_mac16_top_opB_reg_reg_2_ u_mac16_top_opB_reg__2_ VDD VSS u_mac16_top_net564 n775 HFSNET_8 DFFRPQX0P5H9R
Xu_mac16_top_opA_reg_reg_4_ u_mac16_top_opA_reg__4_ VDD VSS u_mac16_top_net570 n793 HFSNET_8 DFFRPQX0P5H9R
Xu_mac16_top_u_mac_u_mul_r_s22_reg_14_ u_mac16_top_u_mac_u_mul_r_s22__14_ VDD VSS u_mac16_top_u_mac_u_mul_net741 n770 HFSNET_5 DFFRPQX0P5H9R
Xu_mac16_top_u_mac_u_mul_r_s22_reg_15_ u_mac16_top_u_mac_u_mul_r_s22__15_ VDD VSS u_mac16_top_u_mac_u_mul_net741 n769 HFSNET_5 DFFRPQX0P5H9R
Xu_mac16_top_u_mac_u_mul_r_s20_reg_7_ u_mac16_top_u_mac_u_mul_r_s20__7_ VDD VSS u_mac16_top_u_mac_u_mul_net721 n742 HFSNET_6 DFFRPQX0P5H9R
Xu_mac16_top_opB_reg_reg_10_ u_mac16_top_opB_reg__10_ VDD VSS u_mac16_top_net564 n783 HFSNET_8 DFFRPQX0P5H9R
Xu_mac16_top_u_mac_u_mul_r_s22_reg_20_ u_mac16_top_u_mac_u_mul_r_s22__20_ VDD VSS u_mac16_top_u_mac_u_mul_net741 n764 HFSNET_5 DFFRPQX0P5H9R
Xu_mac16_top_u_mac_u_mul_r_s22_reg_21_ u_mac16_top_u_mac_u_mul_r_s22__21_ VDD VSS u_mac16_top_u_mac_u_mul_net741 n763 HFSNET_5 DFFRPQX0P5H9R
Xu_mac16_top_u_mac_u_mul_r_s22_reg_22_ u_mac16_top_u_mac_u_mul_r_s22__22_ VDD VSS u_mac16_top_u_mac_u_mul_net741 n762 HFSNET_5 DFFRPQX0P5H9R
Xu_mac16_top_u_mac_u_mul_r_s22_reg_23_ u_mac16_top_u_mac_u_mul_r_s22__23_ VDD VSS u_mac16_top_u_mac_u_mul_net741 n761 HFSNET_2 DFFRPQX0P5H9R
Xu_mac16_top_u_mac_u_mul_r_s20_reg_16_ u_mac16_top_u_mac_u_mul_r_s20__16_ VDD VSS u_mac16_top_u_mac_u_mul_net721 u_mac16_top_u_mac_u_mul_s20__16_ HFSNET_1 DFFRPQX0P5H9R
Xu_mac16_top_opA_reg_reg_9_ u_mac16_top_opA_reg__9_ VDD VSS u_mac16_top_net570 n798 HFSNET_14 DFFRPQX0P5H9R
Xu_mac16_top_opB_reg_reg_11_ u_mac16_top_opB_reg__11_ VDD VSS u_mac16_top_net564 n784 HFSNET_14 DFFRPQX0P5H9R
Xu_mac16_top_opA_reg_reg_11_ u_mac16_top_opA_reg__11_ VDD VSS u_mac16_top_net570 n800 HFSNET_8 DFFRPQX0P5H9R
Xu_mac16_top_u_mac_u_mul_r_c40_reg_5_ u_mac16_top_u_mac_u_mul_r_c40__5_ VDD VSS u_mac16_top_u_mac_u_mul_net786 u_mac16_top_u_mac_u_mul_st4_0_gen_csa_fa_4__u_fa_N1 HFSNET_29 DFFRPQX0P5H9R
Xu_mac16_top_u_mac_sum_out_reg_13_ u_mac16_top_mac_result__13_ VDD VSS u_mac16_top_u_mac_net688 u_mac16_top_u_mac_add_tmp_comb__13_ HFSNET_16 DFFRPQX0P5H9R
Xu_mac16_top_u_mac_accum_reg_reg_8_ u_mac16_top_u_mac_accum_reg__8_ VDD VSS u_mac16_top_u_mac_net682 u_mac16_top_u_mac_add_tmp_comb__8_ HFSNET_20 DFFRPQX0P5H9R
Xu_mac16_top_opB_reg_reg_13_ u_mac16_top_opB_reg__13_ VDD VSS u_mac16_top_net564 n786 HFSNET_14 DFFRPQX0P5H9R
Xu_mac16_top_u_mac_accum_reg_reg_11_ u_mac16_top_u_mac_accum_reg__11_ VDD VSS u_mac16_top_u_mac_net682 u_mac16_top_u_mac_add_tmp_comb__11_ HFSNET_20 DFFRPQX0P5H9R
Xu_mac16_top_u_mac_u_mul_r_s22_reg_18_ u_mac16_top_u_mac_u_mul_r_s22__18_ VDD VSS u_mac16_top_u_mac_u_mul_net741 n766 HFSNET_2 DFFRPQX0P5H9R
Xu_mac16_top_u_mac_sum_out_reg_12_ u_mac16_top_mac_result__12_ VDD VSS u_mac16_top_u_mac_net688 u_mac16_top_u_mac_add_tmp_comb__12_ HFSNET_18 DFFRPQX0P5H9R
Xu_mac16_top_u_mac_accum_reg_reg_16_ u_mac16_top_u_mac_accum_reg__16_ VDD VSS u_mac16_top_u_mac_net682 u_mac16_top_u_mac_add_tmp_comb__16_ HFSNET_29 DFFRPQX0P5H9R
Xu_mac16_top_u_mac_accum_reg_reg_10_ u_mac16_top_u_mac_accum_reg__10_ VDD VSS u_mac16_top_u_mac_net682 u_mac16_top_u_mac_add_tmp_comb__10_ HFSNET_20 DFFRPQX0P5H9R
Xu_mac16_top_u_mac_sum_out_reg_10_ u_mac16_top_mac_result__10_ VDD VSS u_mac16_top_u_mac_net688 u_mac16_top_u_mac_add_tmp_comb__10_ HFSNET_20 DFFRPQX0P5H9R
Xu_mac16_top_u_mac_u_mul_r_s20_reg_10_ u_mac16_top_u_mac_u_mul_r_s20__10_ VDD VSS u_mac16_top_u_mac_u_mul_net721 n739 HFSNET_6 DFFRPQX0P5H9R
Xu_mac16_top_u_mac_last_prod_reg_10_ u_mac16_top_u_mac_last_prod__10_ VDD VSS u_mac16_top_u_mac_net693 u_mac16_top_u_mac_mult_result__10_ HFSNET_29 DFFRPQX0P5H9R
Xu_mac16_top_u_mac_u_mul_r_s22_reg_16_ u_mac16_top_u_mac_u_mul_r_s22__16_ VDD VSS u_mac16_top_u_mac_u_mul_net741 n768 HFSNET_2 DFFRPQX0P5H9R
Xu_mac16_top_u_mac_u_mul_r_s22_reg_17_ u_mac16_top_u_mac_u_mul_r_s22__17_ VDD VSS u_mac16_top_u_mac_u_mul_net741 n767 HFSNET_5 DFFRPQX0P5H9R
Xu_mac16_top_u_mac_u_mul_r_s20_reg_9_ u_mac16_top_u_mac_u_mul_r_s20__9_ VDD VSS u_mac16_top_u_mac_u_mul_net721 n740 HFSNET_6 DFFRPQX0P5H9R
Xu_mac16_top_u_mac_u_mul_product_reg_reg_17_ u_mac16_top_u_mac_mult_result__17_ VDD VSS clk ZBUF_2_9 HFSNET_17 DFFRPQX0P5H9R
Xu_mac16_top_u_mac_u_mul_r_s40_reg_13_ u_mac16_top_u_mac_u_mul_r_s40__13_ VDD VSS u_mac16_top_u_mac_u_mul_net771 u_mac16_top_u_mac_u_mul_s40__13_ HFSNET_28 DFFRPQX0P5H9R
Xu_mac16_top_u_mac_u_mul_r_s40_reg_18_ u_mac16_top_u_mac_u_mul_r_s40__18_ VDD VSS u_mac16_top_u_mac_u_mul_net781 u_mac16_top_u_mac_u_mul_s40__18_ HFSNET_30 DFFRPQX0P5H9R
Xu_mac16_top_u_mac_u_mul_product_reg_reg_0_ u_mac16_top_u_mac_mult_result__0_ VDD VSS clk u_mac16_top_u_mac_u_mul_N33 HFSNET_32 DFFRPQX0P5H9R
Xu_mac16_top_u_mac_last_prod_reg_15_ u_mac16_top_u_mac_last_prod__15_ VDD VSS u_mac16_top_u_mac_net693 u_mac16_top_u_mac_mult_result__15_ HFSNET_29 DFFRPQX0P5H9R
Xu_mac16_top_u_mac_u_mul_r_c41_reg_20_ u_mac16_top_u_mac_u_mul_r_c41__20_ VDD VSS u_mac16_top_u_mac_u_mul_net786 n2272 HFSNET_30 DFFRPQX0P5H9R
Xu_mac16_top_u_mac_accum_reg_reg_15_ u_mac16_top_u_mac_accum_reg__15_ VDD VSS u_mac16_top_u_mac_net682 u_mac16_top_u_mac_add_tmp_comb__15_ HFSNET_29 DFFRPQX0P5H9R
Xu_mac16_top_u_mac_u_mul_r_c40_reg_15_ u_mac16_top_u_mac_u_mul_r_c40__15_ VDD VSS u_mac16_top_u_mac_u_mul_net786 n2279 HFSNET_28 DFFRPQX0P5H9R
Xu_mac16_top_u_mac_u_mul_r_s41_reg_14_ u_mac16_top_u_mac_u_mul_r_s41__14_ VDD VSS u_mac16_top_u_mac_u_mul_net771 u_mac16_top_u_mac_u_mul_st4_1_gen_csa_fa_14__u_fa_N0 HFSNET_3 DFFRPQX0P5H9R
Xu_mac16_top_opA_reg_reg_13_ u_mac16_top_opA_reg__13_ VDD VSS u_mac16_top_net570 n802 HFSNET_14 DFFRPQX0P5H9R
Xu_mac16_top_u_mac_u_mul_r_c40_reg_20_ u_mac16_top_u_mac_u_mul_r_c40__20_ VDD VSS u_mac16_top_u_mac_u_mul_net786 n2282 HFSNET_28 DFFRPQX0P5H9R
Xu_mac16_top_u_mac_last_prod_reg_17_ u_mac16_top_u_mac_last_prod__17_ VDD VSS u_mac16_top_u_mac_net693 u_mac16_top_u_mac_mult_result__17_ HFSNET_32 DFFRPQX0P5H9R
Xu_mac16_top_u_mac_u_mul_r_c41_reg_18_ u_mac16_top_u_mac_u_mul_r_c41__18_ VDD VSS u_mac16_top_u_mac_u_mul_net786 n2273 HFSNET_30 DFFRPQX0P5H9R
Xu_mac16_top_u_mac_accum_reg_reg_17_ u_mac16_top_u_mac_accum_reg__17_ VDD VSS u_mac16_top_u_mac_net682 u_mac16_top_u_mac_add_tmp_comb__17_ HFSNET_16 DFFRPQX0P5H9R
Xu_mac16_top_opA_reg_reg_6_ u_mac16_top_opA_reg__6_ VDD VSS u_mac16_top_net570 n795 HFSNET_8 DFFRPQX0P5H9R
Xu_mac16_top_u_mac_u_mul_r_s40_reg_20_ u_mac16_top_u_mac_u_mul_r_s40__20_ VDD VSS u_mac16_top_u_mac_u_mul_net781 u_mac16_top_u_mac_u_mul_s40__20_ HFSNET_30 DFFRPQX0P5H9R
Xu_mac16_top_u_mac_u_mul_r_s41_reg_16_ u_mac16_top_u_mac_u_mul_r_s41__16_ VDD VSS u_mac16_top_u_mac_u_mul_net771 u_mac16_top_u_mac_u_mul_s41__16_ HFSNET_4 DFFRPQX0P5H9R
Xu_mac16_top_u_mac_u_mul_r_s41_reg_13_ u_mac16_top_u_mac_u_mul_r_s41__13_ VDD VSS u_mac16_top_u_mac_u_mul_net771 u_mac16_top_u_mac_u_mul_r_c31__13_ HFSNET_4 DFFRPQX0P5H9R
Xu_mac16_top_u_mac_sum_out_reg_17_ u_mac16_top_mac_result__17_ VDD VSS u_mac16_top_u_mac_net688 u_mac16_top_u_mac_add_tmp_comb__17_ HFSNET_18 DFFRPQX0P5H9R
Xu_mac16_top_u_mac_u_mul_r_c40_reg_6_ u_mac16_top_u_mac_u_mul_r_c40__6_ VDD VSS u_mac16_top_u_mac_u_mul_net786 u_mac16_top_u_mac_u_mul_st4_0_gen_csa_fa_5__u_fa_N1 HFSNET_28 DFFRPQX0P5H9R
Xu_mac16_top_u_mac_u_mul_r_s41_reg_11_ u_mac16_top_u_mac_u_mul_r_s41__11_ VDD VSS u_mac16_top_u_mac_u_mul_net771 u_mac16_top_u_mac_u_mul_r_c31__11_ HFSNET_30 DFFRPQX1H9R
Xu_mac16_top_u_mac_u_mul_r_s40_reg_11_ u_mac16_top_u_mac_u_mul_r_s40__11_ VDD VSS u_mac16_top_u_mac_u_mul_net781 u_mac16_top_u_mac_u_mul_s40__11_ HFSNET_28 DFFRPQX0P5H9R
Xu_mac16_top_u_mac_u_mul_r_c41_reg_17_ u_mac16_top_u_mac_u_mul_r_c41__17_ VDD VSS u_mac16_top_u_mac_u_mul_net786 n2274 HFSNET_30 DFFRPQX0P5H9R
Xu_mac16_top_u_mac_accum_reg_reg_14_ u_mac16_top_u_mac_accum_reg__14_ VDD VSS u_mac16_top_u_mac_net682 u_mac16_top_u_mac_add_tmp_comb__14_ HFSNET_29 DFFRPQX0P5H9R
Xu_mac16_top_u_mac_u_mul_product_reg_reg_6_ u_mac16_top_u_mac_mult_result__6_ VDD VSS clk u_mac16_top_u_mac_u_mul_N39 HFSNET_32 DFFRPQX0P5H9R
Xu_mac16_top_u_mac_u_mul_product_reg_reg_11_ u_mac16_top_u_mac_mult_result__11_ VDD VSS clk u_mac16_top_u_mac_u_mul_N44 HFSNET_1 DFFRPQX0P5H9R
Xu_mac16_top_u_mac_u_mul_product_reg_reg_2_ u_mac16_top_u_mac_mult_result__2_ VDD VSS clk u_mac16_top_u_mac_u_mul_N35 HFSNET_32 DFFRPQX0P5H9R
Xu_mac16_top_u_mac_u_mul_product_reg_reg_13_ u_mac16_top_u_mac_mult_result__13_ VDD VSS clk u_mac16_top_u_mac_u_mul_N46 HFSNET_1 DFFRPQX0P5H9R
Xu_mac16_top_u_mac_accum_reg_reg_9_ u_mac16_top_u_mac_accum_reg__9_ VDD VSS u_mac16_top_u_mac_net682 u_mac16_top_u_mac_add_tmp_comb__9_ HFSNET_20 DFFRPQX0P5H9R
Xu_mac16_top_u_mac_accum_reg_reg_5_ u_mac16_top_u_mac_accum_reg__5_ VDD VSS u_mac16_top_u_mac_net682 u_mac16_top_u_mac_add_tmp_comb__5_ HFSNET_20 DFFRPQX0P5H9R
Xu_mac16_top_u_mac_u_mul_r_s41_reg_21_ u_mac16_top_u_mac_u_mul_r_s41__21_ VDD VSS u_mac16_top_u_mac_u_mul_net771 u_mac16_top_u_mac_u_mul_s41__21_ HFSNET_31 DFFRPQX0P5H9R
Xu_mac16_top_u_mac_u_mul_product_reg_reg_19_ u_mac16_top_u_mac_mult_result__19_ VDD VSS clk u_mac16_top_u_mac_u_mul_N52 HFSNET_17 DFFRPQX0P5H9R
Xu_mac16_top_opA_reg_reg_0_ u_mac16_top_opA_reg__0_ VDD VSS u_mac16_top_net570 n789 HFSNET_8 DFFRPQX0P5H9R
Xu_mac16_top_opA_reg_reg_1_ u_mac16_top_opA_reg__1_ VDD VSS u_mac16_top_net570 n790 HFSNET_8 DFFRPQX0P5H9R
Xu_mac16_top_opA_reg_reg_5_ u_mac16_top_opA_reg__5_ VDD VSS u_mac16_top_net570 n794 HFSNET_14 DFFRPQX0P5H9R
Xu_mac16_top_opA_reg_reg_3_ u_mac16_top_opA_reg__3_ VDD VSS u_mac16_top_net570 n792 HFSNET_8 DFFRPQX0P5H9R
Xu_mac16_top_opB_reg_reg_12_ u_mac16_top_opB_reg__12_ VDD VSS u_mac16_top_net564 n785 HFSNET_8 DFFRPQX0P5H9R
Xu_mac16_top_opA_reg_reg_8_ u_mac16_top_opA_reg__8_ VDD VSS u_mac16_top_net570 n797 HFSNET_1 DFFRPQX0P5H9R
Xu_mac16_top_opA_reg_reg_12_ u_mac16_top_opA_reg__12_ VDD VSS u_mac16_top_net570 n801 HFSNET_14 DFFRPQX0P5H9R
Xu_mac16_top_opB_reg_reg_3_ u_mac16_top_opB_reg__3_ VDD VSS u_mac16_top_net564 n776 HFSNET_8 DFFRPQX0P5H9R
Xu_mac16_top_opB_reg_reg_5_ u_mac16_top_opB_reg__5_ VDD VSS u_mac16_top_net564 n778 HFSNET_8 DFFRPQX0P5H9R
Xu_mac16_top_opB_reg_reg_8_ u_mac16_top_opB_reg__8_ VDD VSS u_mac16_top_net564 n781 HFSNET_8 DFFRPQX0P5H9R
Xu_mac16_top_u_mac_u_mul_r_s20_reg_12_ n2243 VDD VSS u_mac16_top_u_mac_u_mul_net721 n737 HFSNET_6 DFFRPQNX0P5H9R
Xu_mac16_top_u_mac_u_mul_r_s21_reg_9_ u_mac16_top_u_mac_u_mul_r_s21__9_ VDD VSS u_mac16_top_u_mac_u_mul_net731 n757 HFSNET_3 DFFRPQX0P5H9R
XU1045 u_mac16_top_u_mac_u_mul_c21__21_ u_mac16_top_u_mac_u_mul_s21__20_ VDD VSS n1386 n968 n967 ADDFX1H9R
XU1046 u_mac16_top_u_mac_u_mul_c20__4_ n745 VDD VSS n1228 n963 n962 ADDFX1H9R
XU1047 u_mac16_top_u_mac_u_mul_c20__6_ n744 VDD VSS n1341 n1340 n1339 ADDFX1H9R
XU1048 u_mac16_top_u_mac_u_mul_c20__12_ n738 VDD VSS n1227 n1226 n1225 ADDFX1H9R
XU1049 u_mac16_top_u_mac_u_mul_c20__7_ n743 VDD VSS n966 n965 n964 ADDFX1H9R
XU1050 u_mac16_top_u_mac_u_mul_c20__5_ u_mac16_top_u_mac_u_mul_s20__4_ VDD VSS n1235 n1234 n1233 ADDFX1H9R
XU1054 n2021 n2031 VDD VSS n2025 n2024 n2023 ADDFX1H9R
XU1055 n2030 n2037 VDD VSS n2034 n2033 n2032 ADDFX1H9R
XU1056 n2036 n2043 VDD VSS n2040 n2039 n2038 ADDFX1H9R
XU1066 n2000 VDD VSS u_mac16_top_opA_reg__11_ INVX0P5H9R
XctmTdsLR_1_88 n1024 VDD VSS n1021 n1022 NAND2BX0P7H9R
XU1071 n1948 VDD VSS u_mac16_top_opB_reg__10_ INVX0P5H9R
XU1072 n1984 VDD VSS u_mac16_top_opA_reg__12_ INVX0P5H9R
XU1073 n2061 VDD VSS u_mac16_top_opB_reg__5_ INVX0P5H9R
XU1077 n2097 VDD VSS u_mac16_top_opA_reg__9_ INVX0P5H9R
XU1079 n2107 VDD VSS u_mac16_top_opA_reg__8_ INVX1H9R
XU1082 n2207 VDD VSS u_mac16_top_opB_reg__6_ INVX0P7H9R
XU1091 n1767 VDD VSS n1791 n1799 n1792 OAI21X0P7H9R
XU1096 n1551 VDD VSS n891 n1116 NOR2X1P4H9R
XctmTdsLR_1_146 n1186 VDD VSS n1147 n1146 u_mac16_top_u_mac_u_mul_r_c41__21_ XOR3X0P5H9R
XctmTdsLR_1_179 tmp_net43 VDD VSS n1113 INVX0P7H9R
XctmTdsLR_1_50 n852 VDD VSS n1822 n1811 n1310 n1263 OAI31X0P5H9R
XctmTdsLR_1_119 n1488 VDD VSS n1550 n1551 NAND2XBX0P7H9R
XctmTdsLR_1_147 n1182 VDD VSS n1194 u_mac16_top_u_mac_u_mul_r_c41__22_ n1193 XOR3X0P5H9R
XctmTdsLR_2_180 n1116 VDD VSS u_mac16_top_u_mac_u_mul_r_s40__8_ u_mac16_top_u_mac_u_mul_r_c40__8_ n1108 tmp_net43 OA211X0P7H9R
XU1151 n1153 VDD VSS u_mac16_top_u_mac_u_mul_r_c41__16_ INVX0P5H9R
XU1153 n1756 VDD VSS n1705 INVX0P5H9R
XU1156 n1849 VDD VSS n2243 INVX0P5H9R
XU1158 n2012 n2022 VDD VSS n2016 n2015 n2014 ADDFX1H9R
XU1160 u_mac16_top_u_mac_u_mul_c20__14_ n736 VDD VSS n961 n960 n959 ADDFX1H9R
XU1161 u_mac16_top_u_mac_u_mul_c22__13_ n771 VDD VSS n1206 n1205 n1204 ADDFX1H9R
XU1162 n806 VDD VSS u_mac16_top_op_fifo_rd_ptr__0_ INVX0P5H9R
XctmTdsLR_1_181 tmp_net44 VDD VSS n1504 n1845 u_mac16_top_schedule_active NAND3X0P5H9R
XctmTdsLR_1_160 n1127 VDD VSS u_mac16_top_u_mac_u_mul_r_c40__12_ ZBUF_17_8 u_mac16_top_u_mac_u_mul_r_s40__12_ XNOR3X1P4H9R
XU1172 n1038 VDD VSS n948 n1037 XOR2X0P5H9R
XU1174 n1026 VDD VSS n1025 n1024 XNOR2X0P5H9R
XU1175 n1050 VDD VSS n1049 n1048 XNOR2X0P5H9R
XU1176 n1615 VDD VSS n1604 n1603 XNOR2X0P5H9R
XU1177 n1059 VDD VSS n937 n1058 XOR2X0P5H9R
XU1178 n1530 VDD VSS n1491 n1490 NAND2X2H9R
XU1185 n1604 VDD VSS n1683 n1599 n1598 OAI21X0P5H9R
XctmTdsLR_1_155 n1474 VDD VSS n926 n1507 n1508 n1464 OAI211X0P5H9R
XU1218 n1003 VDD VSS n1606 n1001 NAND2X0P5H9R
XU1227 u_mac16_top_u_out_bits_left__1_ u_mac16_top_u_out_bits_left__0_ n1840 n1511 n936 VDD VSS AO211X0P5H9R
XU1230 n1724 VDD VSS n1742 n1753 n1743 OAI21X0P5H9R
XU1233 n1963 VDD VSS n1882 n2062 NOR2X0P5H9R
XU1234 n1873 VDD VSS n2046 n1883 NOR2X0P5H9R
XU1259 n1910 VDD VSS n1947 n2097 NOR2X0P5H9R
XU1261 n1900 VDD VSS n1948 n2000 NOR2X0P5H9R
XU1264 n1891 VDD VSS n1948 n1984 NOR2X0P5H9R
XU1274 n1228 VDD VSS n2046 n2058 NOR2X0P5H9R
XU1302 n1051 VDD VSS u_mac16_top_u_mac_last_prod__10_ u_mac16_top_u_mac_mult_result__10_ NOR2X0P5H9R
XctmTdsLR_1_822 n1065 VDD VSS n1871 n1872 n1873 XOR3X0P5H9R
XctmTdsLR_1_148 tmp_net36 VDD VSS u_mac16_top_u_mac_u_mul_r_c41__16_ ZBUF_54_10 XNOR2X0P5H9R
XU1349 n1651 VDD VSS n1650 n1649 XNOR2X0P5H9R
XU1350 n1639 VDD VSS n1626 n1625 XNOR2X0P5H9R
XU1354 n1638 VDD VSS n1637 n1636 XNOR2X0P5H9R
XU1356 n1681 VDD VSS n1680 n1679 XNOR2X0P5H9R
XU1408 n2262 VDD VSS u_mac16_top_mac_result_shadow__15_ u_mac16_top_u_out_shift_reg__15_ n926 MUX2X0P5H9R
XU1411 n2263 VDD VSS u_mac16_top_mac_result_shadow__14_ u_mac16_top_u_out_shift_reg__14_ n926 MUX2X0P5H9R
XU1413 n2246 VDD VSS u_mac16_top_mac_result_shadow__10_ u_mac16_top_u_out_shift_reg__10_ n926 MUX2X0P5H9R
XU1414 n2264 VDD VSS u_mac16_top_mac_result_shadow__13_ u_mac16_top_u_out_shift_reg__13_ n926 MUX2X0P5H9R
XU1415 n2245 VDD VSS u_mac16_top_mac_result_shadow__11_ u_mac16_top_u_out_shift_reg__11_ n926 MUX2X0P5H9R
XU1417 n2265 VDD VSS u_mac16_top_mac_result_shadow__12_ u_mac16_top_u_out_shift_reg__12_ n926 MUX2X0P5H9R
XU1418 n1202 VDD VSS n1948 n2062 NOR2X0P5H9R
XU1437 n1945 VDD VSS n1948 n2119 NOR2X0P5H9R
XU1438 n2106 VDD VSS n2118 n2097 NOR2X0P5H9R
XU1440 n1936 VDD VSS n1948 n2117 NOR2X0P5H9R
XU1443 n1927 VDD VSS n1948 n2107 NOR2X0P5H9R
XU1452 n2010 VDD VSS n2058 n2001 NOR2X0P5H9R
XU1454 n2028 VDD VSS n2058 n2107 NOR2X0P5H9R
XU1458 n2009 VDD VSS n2060 n2097 NOR2X0P5H9R
XU1468 n1224 VDD VSS n2122 n2097 NOR2X0P5H9R
XU1474 n2261 VDD VSS u_mac16_top_mac_result_shadow__16_ u_mac16_top_u_out_shift_reg__16_ n926 MUX2X0P5H9R
XU1475 n1909 VDD VSS n1948 n2001 NOR2X0P5H9R
XU1477 n1960 VDD VSS n1948 n2057 NOR2X0P5H9R
XU1479 n2260 VDD VSS u_mac16_top_mac_result_shadow__17_ u_mac16_top_u_out_shift_reg__17_ n926 MUX2X0P5H9R
XU1483 n2259 VDD VSS u_mac16_top_mac_result_shadow__18_ u_mac16_top_u_out_shift_reg__18_ n926 MUX2X0P5H9R
XU1487 n2047 VDD VSS n2207 n2059 NOR2X0P5H9R
XU1488 n2258 VDD VSS u_mac16_top_mac_result_shadow__19_ u_mac16_top_u_out_shift_reg__19_ n926 MUX2X0P5H9R
XU1495 n2257 VDD VSS u_mac16_top_mac_result_shadow__20_ u_mac16_top_u_out_shift_reg__20_ n926 MUX2X0P5H9R
XU1496 n2256 VDD VSS u_mac16_top_mac_result_shadow__21_ u_mac16_top_u_out_shift_reg__21_ n926 MUX2X0P5H9R
XU1499 n2244 VDD VSS u_mac16_top_mac_result_shadow__22_ u_mac16_top_u_out_shift_reg__22_ n926 MUX2X0P5H9R
XU1501 n1964 VDD VSS n1881 n2059 NOR2X0P5H9R
XctmTdsLR_2_182 n2348 VDD VSS n1847 n1845 u_mac16_top_schedule_active tmp_net44 OAI31X0P5H9R
XU1515 n1918 VDD VSS n1948 n2097 NOR2X0P5H9R
XU1538 n2251 VDD VSS u_mac16_top_mac_result_shadow__5_ u_mac16_top_u_out_shift_reg__5_ n926 MUX2X0P5H9R
XU1539 n2250 VDD VSS u_mac16_top_mac_result_shadow__6_ u_mac16_top_u_out_shift_reg__6_ n926 MUX2X0P5H9R
XU1540 n2249 VDD VSS u_mac16_top_mac_result_shadow__7_ u_mac16_top_u_out_shift_reg__7_ n926 MUX2X0P5H9R
XU1541 n2252 VDD VSS u_mac16_top_mac_result_shadow__4_ u_mac16_top_u_out_shift_reg__4_ n926 MUX2X0P5H9R
XU1542 n2248 VDD VSS u_mac16_top_mac_result_shadow__8_ u_mac16_top_u_out_shift_reg__8_ n926 MUX2X0P5H9R
XU1543 n2247 VDD VSS u_mac16_top_mac_result_shadow__9_ u_mac16_top_u_out_shift_reg__9_ n926 MUX2X0P5H9R
XU1544 n2253 VDD VSS u_mac16_top_mac_result_shadow__3_ u_mac16_top_u_out_shift_reg__3_ n926 MUX2X0P5H9R
XU1545 n2254 VDD VSS u_mac16_top_mac_result_shadow__2_ u_mac16_top_u_out_shift_reg__2_ n926 MUX2X0P5H9R
XU1546 n2255 VDD VSS u_mac16_top_mac_result_shadow__1_ u_mac16_top_u_out_shift_reg__1_ n926 MUX2X0P5H9R
XctmTdsLR_2_149 n1167 VDD VSS n1157 tmp_net36 n1156 XOR3X1H9R
XU1558 n854 VDD VSS n1156 ZBUF_54_10 XNOR2X0P7H9R
XctmTdsLR_1_150 n843 VDD VSS n882 n1154 n881 XNOR3X1H9R
XctmTdsLR_1_151 tmp_net37 VDD VSS u_mac16_top_u_mac_u_mul_r_c40__18_ u_mac16_top_u_mac_u_mul_r_s41__18_ XOR2X0P5H9R
XU1567 n1735 VDD VSS u_mac16_top_u_mac_mult_result__5_ u_mac16_top_u_mac_last_prod__5_ NOR2X1H9R
XU1573 n1671 VDD VSS u_mac16_top_u_mac_mult_result__9_ u_mac16_top_u_mac_last_prod__9_ NOR2X0P5H9R
Xropt_h_inst_889 ropt_net_105 VDD VSS u_mac16_top_u_mac_mult_result__12_ BUFX0P7H9R
XU1586 n1646 VDD VSS n1661 n999 NAND2X0P5H9R
XU1587 n996 VDD VSS n1724 n995 n994 AOI21X0P5H9R
XU1596 n935 VDD VSS ZBUF_17_14 u_mac16_top_u_mac_u_mul_r_c40__17_ XOR2X1H9R
XU1612 n2146 VDD VSS n1073 INVX0P7H9R
XU1613 n977 VDD VSS n976 n1717 n975 AOI21X0P5H9R
XctmTdsLR_1_89 n1625 VDD VSS n1622 n1623 NAND2BX0P7H9R
XU1628 n867 VDD VSS ZBUF_101_7 ZBUF_190_3 XOR2X0P7H9R
XU1635 n893 VDD VSS n878 u_mac16_top_u_mac_u_mul_r_s41__20_ XOR2X0P5H9R
XU1650 n1187 VDD VSS n2366 u_mac16_top_u_mac_u_mul_r_c41__20_ n893 CGENCONAX1H9R
XctmTdsLR_1_814 n1486 VDD VSS n1112 ZBUF_50_13 u_mac16_top_u_mac_u_mul_r_c40__7_ XOR3X1H9R
XctmTdsLR_2_152 n1171 VDD VSS tmp_net37 n2365 tmp_net34 XOR3X1H9R
XctmTdsLR_1_120 n873 VDD VSS n1550 n1553 n1554 OA21X1H9R
XctmTdsLR_1_52 n1691 VDD VSS n1689 n1688 NAND2XBX0P7H9R
XU1673 n1315 VDD VSS n1810 INVX0P5H9R
XU1676 n1630 VDD VSS n1015 INVX0P5H9R
Xgre_a_INV_23_inst_888 gre_a_INV_23_14 VDD VSS n1476 INVX0P5H9R
XU1680 n1326 VDD VSS n1824 INVX0P5H9R
XU1681 n1148 VDD VSS n1146 INVX0P5H9R
XU1683 n1658 VDD VSS n1051 INVX0P5H9R
XU1685 n1072 VDD VSS u_mac16_top_fifo_rd_ptr__1_ INVX0P5H9R
XU1692 n1717 VDD VSS n1735 n1749 n1736 OAI21X0P7H9R
XU1695 n1619 VDD VSS n1640 INVX0P5H9R
XU1714 n1779 VDD VSS n1761 INVX0P5H9R
XU1715 n1784 VDD VSS n1767 INVX0P5H9R
XU1716 n1754 VDD VSS n1740 INVX0P5H9R
XU1766 n1617 VDD VSS n1641 INVX0P5H9R
XU1777 n1648 VDD VSS n1627 INVX0P5H9R
XU1778 n1645 VDD VSS n1683 n1641 n1640 OAI21X0P5H9R
XU1780 n1357 VDD VSS n1533 INVX0P5H9R
XctmTdsLR_1_53 tmp_net3 VDD VSS n1683 n1054 NOR2X0P5H9R
XU1795 n1025 VDD VSS n1692 n1020 n1019 OAI21X0P7H9R
XU1796 n1019 VDD VSS n1630 n1018 n1017 AOI21X0P7H9R
XctmTdsLR_1_90 n1490 VDD VSS n1164 n1163 OR2X1H9R
XctmTdsLR_1_91 tmp_net17 VDD VSS n1661 n1692 n1662 AOI2XB1X0P5H9R
XctmTdsLR_1_121 u_mac16_top_u_mac_N59 VDD VSS u_mac16_top_u_mac_mult_valid u_mac16_top_u_mac_mode_d NOR2BX0P5H9R
XU1810 n2145 VDD VSS n1464 INVX0P5H9R
XU1819 n1371 VDD VSS u_mac16_top_sched_cnt__2_ INVX0P5H9R
XctmTdsLR_1_125 u_mac16_top_u_mac_add_tmp_comb__21_ VDD VSS n1757 n1267 n1276 n1838 AO22X0P5H9R
XU1828 n957 VDD VSS u_mac16_top_fifo_wr_ptr__1_ u_mac16_top_fifo_wr_ptr__0_ XOR2X0P5H9R
XctmTdsLR_1_122 tmp_net30 VDD VSS n1508 u_mac16_top_cal_done u_mac16_top_fifo_count__1_ u_mac16_top_fifo_count__0_ NAND4X1H9R
XctmTdsLR_2_123 tmp_net31 VDD VSS u_mac16_top_cal_done n1507 u_mac16_top_fifo_count__2_ NAND3BX0P5H9R
XU1834 u_mac16_top_u_mac_u_mul_N46 VDD VSS n1542 n1541 XNOR2X0P5H9R
XU1837 u_mac16_top_u_mac_u_mul_st4_1_gen_csa_fa_14__u_fa_N0 VDD VSS u_mac16_top_u_mac_u_mul_r_c31__14_ u_mac16_top_u_mac_u_mul_r_s23__14_ XOR2X0P5H9R
XU1843 u_mac16_top_u_mac_u_mul_st4_0_gen_csa_fa_6__u_fa_N0 VDD VSS u_mac16_top_u_mac_u_mul_r_s30__6_ u_mac16_top_u_mac_u_mul_r_c30__6_ XOR2X0P5H9R
XU1858 u_mac16_top_u_mac_u_mul_st4_1_gen_csa_fa_15__u_fa_N0 VDD VSS u_mac16_top_u_mac_u_mul_r_c31__15_ u_mac16_top_u_mac_u_mul_r_s23__15_ XOR2X0P5H9R
XU1865 u_mac16_top_u_mac_u_mul_c20__16_ n734 VDD VSS n1236 n1237 n1238 ADDFX1H9R
XU1866 u_mac16_top_u_mac_u_mul_N42 VDD VSS n1488 n2380 XNOR2X0P5H9R
XctmTdsLR_1_126 u_mac16_top_u_mac_add_tmp_comb__20_ VDD VSS n991 n1838 n1757 n1010 AO22X0P5H9R
XU1876 u_mac16_top_u_mac_u_mul_N41 VDD VSS n1562 n1561 XOR2X0P5H9R
XU1912 u_mac16_top_u_mac_u_mul_N44 VDD VSS n1499 n1498 XNOR2X0P5H9R
XU1915 n1497 VDD VSS n1494 INVX0P5H9R
XU1921 u_mac16_top_u_mac_u_mul_st4_0_gen_csa_fa_4__u_fa_N0 VDD VSS u_mac16_top_u_mac_u_mul_r_s30__4_ u_mac16_top_u_mac_u_mul_r_c30__4_ XOR2X0P5H9R
XU1922 u_mac16_top_u_mac_u_mul_st4_0_gen_csa_fa_5__u_fa_N0 VDD VSS u_mac16_top_u_mac_u_mul_r_s30__5_ u_mac16_top_u_mac_u_mul_r_c30__5_ XOR2X0P5H9R
XU1940 n1795 VDD VSS n1794 n1799 XOR2X0P5H9R
XU1941 n1796 VDD VSS n1790 n1797 XOR2X0P5H9R
XU1944 n1785 VDD VSS n1784 n1783 XOR2X0P5H9R
XU1945 n1786 VDD VSS n1779 n1778 XOR2X0P5H9R
XU1947 n1773 VDD VSS n1772 n1771 XNOR2X0P5H9R
XU1948 n1774 VDD VSS n1766 n1765 XNOR2X0P5H9R
XU1951 n1758 VDD VSS n1756 n1755 XNOR2X0P5H9R
XU1952 n1760 VDD VSS n1752 n1751 XNOR2X0P5H9R
XU1954 n1747 VDD VSS n1746 n1745 XOR2X0P5H9R
XU1955 n1748 VDD VSS n1739 n1738 XOR2X0P5H9R
XU1958 n1731 VDD VSS n1730 n1729 XOR2X0P5H9R
XU1959 n1732 VDD VSS n1723 n1722 XOR2X0P5H9R
XU1961 n1715 VDD VSS n1714 n1713 XOR2X0P5H9R
XU1962 n1716 VDD VSS n1704 n1703 XOR2X0P5H9R
XU1965 n1693 VDD VSS n1692 n1691 XOR2X0P5H9R
XU1966 n1694 VDD VSS n1683 n1687 XOR2X0P5H9R
XU1968 n1594 VDD VSS n1593 n1822 XOR2X0P5H9R
XU1969 n1595 VDD VSS n1585 n1589 XOR2X0P5H9R
XctmTdsLR_1_153 tmp_net38 VDD VSS n878 u_mac16_top_u_mac_u_mul_r_s41__20_ u_mac16_top_u_mac_u_mul_r_c41__20_ XNOR3X1H9R
XU1977 n1373 VDD VSS n1514 u_mac16_top_u_out_bits_left__4_ XOR2X0P5H9R
XU1981 n1374 VDD VSS n1511 u_mac16_top_u_out_bits_left__2_ XNOR2X0P5H9R
XU1989 u_mac16_top_u_mac_u_mul_c22__15_ n770 VDD VSS n1067 n1066 n1065 ADDFX1H9R
XU1990 u_mac16_top_u_mac_u_mul_c22__14_ u_mac16_top_u_mac_u_mul_s22_13_ VDD VSS n972 n971 n970 ADDFX1H9R
XctmTdsLR_3_124 n2345 VDD VSS tmp_net30 tmp_net31 NAND2X0P5H9R
XctmTdsLR_1_127 u_mac16_top_u_mac_add_tmp_comb__19_ VDD VSS n1757 n1247 n1256 n1838 AO22X0P5H9R
XU1996 u_mac16_top_u_mac_u_mul_N43 VDD VSS n1557 n1556 XNOR2X0P5H9R
XU1997 n1557 VDD VSS n1551 n2380 n1550 OAI2XB1X0P5H9R
XctmTdsLR_1_128 u_mac16_top_u_mac_add_tmp_comb__18_ VDD VSS n1757 n1299 n1307 n1838 AO22X0P5H9R
XU2017 u_mac16_top_u_inA_N51 VDD VSS n1808 n1807 n2201 n1806 AOI211X0P5H9R
XU2026 n1369 VDD VSS u_mac16_top_N202 INVX0P5H9R
XU2027 u_mac16_top_N204 VDD VSS n2197 n1371 n1370 n1846 AOI211X0P5H9R
XU2044 u_mac16_top_u_inB_N51 VDD VSS n1804 n1803 n2199 n1802 AOI211X0P5H9R
XctmTdsLR_2_92 n1669 VDD VSS tmp_net17 n1667 XOR2X0P5H9R
XctmTdsLR_1_129 u_mac16_top_u_mac_add_tmp_comb__22_ VDD VSS n1757 n1320 n1330 n1838 AO22X0P7H9R
XctmTdsLR_2_154 n1178 VDD VSS tmp_net38 n2366 XOR2X0P7H9R
XU2054 n1156 VDD VSS u_mac16_top_u_mac_u_mul_r_c40__16_ u_mac16_top_u_mac_u_mul_r_s40__16_ XOR2X1H9R
XU2065 n986 VDD VSS n1641 n984 NOR2X0P5H9R
XctmTdsLR_1_93 tmp_net18 VDD VSS n1653 n1683 n1654 AOI2XB1X0P5H9R
XU2068 n938 VDD VSS u_mac16_top_u_mac_u_mul_r_c30__12_ u_mac16_top_u_mac_u_mul_r_s31__12_ u_mac16_top_u_mac_u_mul_r_s30__12_ XNOR3X0P5H9R
XU2069 n939 VDD VSS u_mac16_top_fifo_wr_ptr__0_ n1470 n956 MUXIT2X0P5H9R
XU2070 n940 VDD VSS u_mac16_top_op_fifo_wr_ptr__0_ n1468 n1467 MUXIT2X0P5H9R
XctmTdsLR_2_94 n1670 VDD VSS tmp_net18 n1659 XOR2X0P5H9R
XU2072 n942 VDD VSS u_mac16_top_fifo_rd_ptr__0_ n1071 n1070 MUXIT2X0P5H9R
XctmTdsLR_1_815 n1130 VDD VSS tmp_net56 n1161 u_mac16_top_u_mac_u_mul_r_s40__14_ XOR3X1H9R
XU2075 n945 VDD VSS u_mac16_top_fifo_wr_ptr__1_ n957 n956 MUXIT2X0P5H9R
XU2076 n946 VDD VSS u_mac16_top_op_fifo_wr_ptr__1_ n955 n1467 MUXIT2X0P5H9R
XctmTdsLR_1_95 u_mac16_top_net605 VDD VSS n1472 n1467 n2339 MUXIT2X0P5H9R
XctmTdsLR_1_96 n1275 VDD VSS n1324 n1322 NAND2BX0P7H9R
XctmTdsLR_1_97 tmp_net19 VDD VSS n1574 n1822 n1577 AOI2XB1X0P5H9R
XctmTdsLR_2_98 n1320 VDD VSS tmp_net19 n1318 XOR2X0P5H9R
XctmTdsLR_1_99 tmp_net20 VDD VSS u_mac16_top_u_mac_mult_result__23_ u_mac16_top_u_mac_last_prod__23_ n1828 AOI21X0P5H9R
XctmTdsLR_1_130 tmp_net32 VDD VSS n1074 n1075 n1070 NAND3X0P5H9R
XctmTdsLR_2_54 n937 VDD VSS n1654 n1658 u_mac16_top_u_mac_mult_result__10_ u_mac16_top_u_mac_last_prod__10_ tmp_net3 AOI221X0P5H9R
XU2086 n1628 VDD VSS n1646 INVX0P5H9R
XctmTdsLR_1_55 n941 VDD VSS n1292 n1822 n1293 AOI2XB1X0P5H9R
XU2090 n1750 VDD VSS n1733 INVX0P5H9R
XU2093 n2157 VDD VSS u_mac16_top_result_fifo_3__2_ INVX0P5H9R
XU2094 n2172 VDD VSS u_mac16_top_result_fifo_3__7_ INVX0P5H9R
XU2095 n1078 VDD VSS u_mac16_top_result_fifo_3__12_ INVX0P5H9R
XU2096 n1092 VDD VSS u_mac16_top_result_fifo_3__17_ INVX0P5H9R
XU2097 n1107 VDD VSS u_mac16_top_result_fifo_3__22_ INVX0P5H9R
XU2098 n2340 VDD VSS u_mac16_top_op_fifo_count__0_ INVX0P5H9R
XU2100 n1845 VDD VSS u_mac16_top_op_fifo_count__2_ INVX0P5H9R
XU2101 n1472 VDD VSS u_mac16_top_inB_done u_mac16_top_inA_done n1845 NAND3X0P5H9R
XU2102 n1467 VDD VSS n1472 INVX0P5H9R
XU2103 n1070 VDD VSS u_mac16_top_cal_done INVX0P5H9R
XU2106 n1074 VDD VSS n1071 u_mac16_top_fifo_rd_ptr__1_ OR2X0P5H9R
XU2118 n971 VDD VSS u_mac16_top_u_mac_u_mul_st1_4_gen_csa_fa_13__u_fa_N1 n969 NOR2X0P5H9R
XU2121 n1641 VDD VSS n1653 n980 NAND2X0P7H9R
XU2122 n1600 VDD VSS u_mac16_top_u_mac_mult_result__14_ u_mac16_top_u_mac_last_prod__14_ NOR2X0P5H9R
XU2128 n984 VDD VSS n982 n1597 NAND2X0P5H9R
XU2134 n1761 VDD VSS n1787 n1797 n1788 OAI21X0P7H9R
XU2137 n1718 VDD VSS n1733 n1735 NOR2X1H9R
XU2141 n978 VDD VSS n1718 n976 NAND2X0P7H9R
XU2147 n1654 VDD VSS n1671 n1685 n1672 OAI21X0P5H9R
XU2160 n988 VDD VSS n1248 n1252 NOR2X0P5H9R
XU2165 n1834 VDD VSS n988 n1301 n987 AOI21X0P5H9R
XU2179 n992 VDD VSS n1768 n1781 n1769 OAI21X0P5H9R
XU2181 n1710 VDD VSS u_mac16_top_u_mac_mult_result__7_ u_mac16_top_u_mac_accum_reg__7_ NOR2X0P5H9R
XU2182 n995 VDD VSS n1726 n1710 NOR2X0P5H9R
XU2184 n997 VDD VSS n1725 n995 NAND2X0P5H9R
XU2199 n1004 VDD VSS n1015 n1003 n1002 OAI21X0P5H9R
XU2200 n1822 VDD VSS n1005 n1013 n1004 AOI21X1P4H9R
XU2204 n1243 VDD VSS u_mac16_top_u_mac_mult_result__19_ u_mac16_top_u_mac_accum_reg__19_ NOR2X0P5H9R
XU2205 n1007 VDD VSS n1239 n1243 NOR2X0P5H9R
XU2207 n1293 VDD VSS n1279 n1591 n1280 OAI21X0P5H9R
XU2208 n1296 VDD VSS u_mac16_top_u_mac_mult_result__18_ u_mac16_top_u_mac_accum_reg__18_ NAND2X0P7H9R
XctmTdsLR_1_158 n1169 VDD VSS n1167 n1165 NOR2XBX1P4H9R
XctmTdsLR_2_131 n944 VDD VSS n1070 u_mac16_top_fifo_rd_ptr__1_ tmp_net32 OAI21X0P5H9R
XU2233 n1066 n970 VDD VSS n1064 n1063 n1062 ADDFX1H9R
XU2234 n1883 VDD VSS u_mac16_top_opB_reg__14_ INVX0P5H9R
XctmTdsLR_1_159 u_mac16_top_u_mac_add_tmp_comb__17_ VDD VSS n1290 n1838 n1284 n1757 AO22X0P5H9R
XU2237 n1464 VDD VSS n1070 u_mac16_top_p2s_issue_hold NOR2X0P5H9R
XU2238 n1073 VDD VSS n1072 n1071 n1517 NAND3XXBX1H9R
XU2248 n1083 VDD VSS u_mac16_top_result_fifo_3__14_ INVX0P5H9R
XU2252 n1086 VDD VSS u_mac16_top_result_fifo_3__15_ INVX0P5H9R
XU2256 n1089 VDD VSS u_mac16_top_result_fifo_3__16_ INVX0P5H9R
XU2263 n1095 VDD VSS u_mac16_top_result_fifo_3__18_ INVX0P5H9R
XU2267 n1098 VDD VSS u_mac16_top_result_fifo_3__19_ INVX0P5H9R
XU2271 n1101 VDD VSS u_mac16_top_result_fifo_3__20_ INVX0P5H9R
XU2275 n1104 VDD VSS u_mac16_top_result_fifo_3__21_ INVX0P5H9R
XctmTdsLR_1_193 n1568 VDD VSS n1326 n1834 n1830 OAI21BX0P5H9R
XU2284 n1126 VDD VSS u_mac16_top_u_mac_u_mul_r_s41__11_ u_mac16_top_u_mac_u_mul_r_c40__11_ u_mac16_top_u_mac_u_mul_r_s40__11_ CGENCONAX1H9R
XU2285 n1161 VDD VSS u_mac16_top_u_mac_u_mul_r_s40__13_ u_mac16_top_u_mac_u_mul_r_c40__13_ ZBUF_17_9 CGENCONAX1H9R
XU2286 n1137 VDD VSS u_mac16_top_u_mac_u_mul_r_c40__18_ ZBUF_35_10 u_mac16_top_u_mac_u_mul_r_s41__18_ CGENCONAX1H9R
XU2289 n1179 VDD VSS u_mac16_top_u_mac_u_mul_r_c41__19_ n1134 n1133 CGENCONAX1H9R
XctmTdsLR_1_162 n1526 VDD VSS n1176 n1175 NOR2BX1H9R
XctmTdsLR_1_163 n1349 VDD VSS n1178 n1179 OR2X0P7H9R
XctmTdsLR_2_816 tmp_net56 VDD VSS u_mac16_top_u_mac_u_mul_r_s41__14_ u_mac16_top_u_mac_u_mul_r_c40__14_ XNOR2X0P5H9R
XctmTdsLR_1_164 n1128 VDD VSS u_mac16_top_u_mac_u_mul_r_s40__11_ u_mac16_top_u_mac_u_mul_r_c40__11_ u_mac16_top_u_mac_u_mul_r_s41__11_ XOR3X1H9R
XU2296 n1146 VDD VSS u_mac16_top_u_mac_u_mul_r_s41__20_ u_mac16_top_u_mac_u_mul_r_c40__20_ u_mac16_top_u_mac_u_mul_r_s40__20_ CGENCONAX1H9R
XctmTdsLR_1_194 n2381 VDD VSS n1158 n867 XOR2X1H9R
XU2300 n1183 VDD VSS u_mac16_top_u_mac_u_mul_r_c41__21_ n1147 n1148 CGENCONAX1H9R
XU2311 n972 n1205 VDD VSS n1203 n1202 n1201 ADDFX1H9R
XU2314 n960 n1221 VDD VSS n1218 n1217 n1216 ADDFX1H9R
XU2315 u_mac16_top_u_mac_u_mul_c20__13_ n737 VDD VSS n1221 n1220 n1219 ADDFX1H9R
XU2316 n1220 n1227 VDD VSS n1224 n1223 n1222 ADDFX1H9R
XU2321 n1233 n963 VDD VSS n1232 n1231 n1230 ADDFX1H9R
XctmTdsLR_1_166 n930 VDD VSS ZBUF_17_9 u_mac16_top_u_mac_u_mul_r_c40__13_ u_mac16_top_u_mac_u_mul_r_s40__13_ XNOR3X1H9R
XctmTdsLR_1_195 n1560 VDD VSS n1114 n1115 OR2X1P4H9R
XU2333 n1262 VDD VSS n1820 INVX0P5H9R
XctmTdsLR_2_100 n1584 VDD VSS n1573 tmp_net20 XOR2X0P5H9R
XctmTdsLR_1_196 n2226 VDD VSS n2224 u_mac16_top_opA_reg__15_ u_mac16_top_opB_reg__8_ n2220 AOI31X0P5H9R
XctmTdsLR_1_101 tmp_net21 VDD VSS n1822 n1242 n1296 tmp_net5 OAI211X0P5H9R
XctmTdsLR_1_817 tmp_net57 VDD VSS n1136 u_mac16_top_u_mac_u_mul_r_s41__19_ u_mac16_top_u_mac_u_mul_r_c41__19_ XNOR3X1H9R
XctmTdsLR_2_102 n1247 VDD VSS tmp_net21 n1246 XNOR2X0P5H9R
XctmTdsLR_1_132 tmp_net33 VDD VSS u_mac16_top_p2s_issue_hold u_mac16_top_cal_done u_mac16_top_u_out_busy NOR3X0P5H9R
XctmTdsLR_1_818 n869 VDD VSS n1152 tmp_net58 n935 XOR3X1H9R
XctmTdsLR_1_103 tmp_net22 VDD VSS n1585 n1825 n1834 OAI21X0P5H9R
XctmTdsLR_2_104 n991 VDD VSS tmp_net22 n989 XNOR2X0P5H9R
XctmTdsLR_1_171 n1129 VDD VSS u_mac16_top_u_mac_u_mul_r_s41__10_ ZBUF_69_7 u_mac16_top_u_mac_u_mul_r_s40__10_ CGENX1H9R
XU2360 n1340 n1235 VDD VSS n1338 n1337 n1336 ADDFX1H9R
XU2362 n2346 VDD VSS u_mac16_top_N118 u_mac16_top_cal_done u_mac16_top_fifo_count__1_ XOR3X0P5H9R
XU2363 n837 VDD VSS rst_n INVX0P5H9R
XctmTdsLR_1_35 n1017 VDD VSS n1609 n1605 n1610 OAI2XB1X0P5H9R
XHFSINV_28332_1 HFSNET_1 VDD VSS HFSNET_26 INVX1H9R
XHFSINV_3673_2 HFSNET_2 VDD VSS HFSNET_26 INVX0P7H9R
XHFSINV_7871_3 HFSNET_3 VDD VSS HFSNET_26 INVX0P7H9R
XHFSINV_4958_4 HFSNET_4 VDD VSS HFSNET_26 INVX0P7H9R
XHFSINV_6108_5 HFSNET_5 VDD VSS HFSNET_26 INVX0P7H9R
XHFSINV_2303_6 HFSNET_6 VDD VSS HFSNET_26 INVX1H9R
XHFSINV_23993_7 HFSNET_7 VDD VSS HFSNET_26 INVX0P7H9R
XHFSINV_18720_8 HFSNET_8 VDD VSS HFSNET_26 INVX0P5H9R
XHFSINV_12912_9 HFSNET_9 VDD VSS HFSNET_26 INVX0P7H9R
XHFSINV_15002_10 HFSNET_10 VDD VSS HFSNET_26 INVX1H9R
XHFSINV_9072_11 HFSNET_11 VDD VSS HFSNET_26 INVX0P5H9R
XHFSINV_10454_12 HFSNET_12 VDD VSS HFSNET_26 INVX0P7H9R
XHFSINV_16807_13 HFSNET_13 VDD VSS HFSNET_26 INVX0P7H9R
XHFSINV_21132_14 HFSNET_14 VDD VSS HFSNET_26 INVX0P7H9R
XctmTdsLR_1_36 n1698 VDD VSS n1719 n1717 n1720 OAI2XB1X0P5H9R
XHFSINV_63164_16 HFSNET_16 VDD VSS HFSNET_26 INVX2H9R
XHFSINV_61757_17 HFSNET_17 VDD VSS HFSNET_26 INVX0P5H9R
XHFSINV_52713_18 HFSNET_18 VDD VSS HFSNET_26 INVX1H9R
XHFSINV_51492_19 HFSNET_19 VDD VSS HFSNET_26 INVX0P5H9R
XHFSINV_47592_20 HFSNET_20 VDD VSS HFSNET_26 INVX0P7H9R
XHFSINV_45899_21 HFSNET_21 VDD VSS HFSNET_26 INVX1H9R
XHFSINV_51045_22 HFSNET_22 VDD VSS HFSNET_26 INVX1H9R
XHFSINV_56595_23 HFSNET_23 VDD VSS HFSNET_26 INVX0P7H9R
XHFSINV_54730_24 HFSNET_24 VDD VSS HFSNET_26 INVX0P7H9R
XHFSINV_59558_25 HFSNET_25 VDD VSS HFSNET_26 INVX1P4H9R
XHFSBUF_67202_26 HFSNET_26 VDD VSS n2367 FREEICGX2P5H9R
XHFSBUF_42529_27 HFSNET_27 VDD VSS HFSNET_32 FREEICGX0P8H9R
XHFSBUF_34608_28 HFSNET_28 VDD VSS HFSNET_32 FREEICGX0P8H9R
XHFSBUF_36427_29 HFSNET_29 VDD VSS HFSNET_32 FREEICGX0P7H9R
XHFSBUF_31684_30 HFSNET_30 VDD VSS HFSNET_32 FREEICGX1P2H9R
XHFSBUF_39107_31 HFSNET_31 VDD VSS HFSNET_32 FREEICGX0P8H9R
XHFSINV_66868_32 HFSNET_32 VDD VSS n2367 INVX1P7H9R
XctmTdsLR_1_37 n1708 VDD VSS n1726 n1724 n1727 OAI2XB1X0P5H9R
XctmTdsLR_1_38 n891 VDD VSS n899 n1108 n1118 AOI21X2H9R
XctmTdsLR_1_105 n1556 VDD VSS n1554 n1553 NAND2XBX0P7H9R
XctmTdsLR_1_40 n923 VDD VSS n1128 n1129 n886 OAI21X1P4H9R
XctmTdsLR_1_41 n1538 VDD VSS n2354 n1494 n1546 NAND3X0P7H9R
XU2408 u_mac16_top_u_mac_u_mul_s40__13_ VDD VSS u_mac16_top_u_mac_u_mul_r_c30__13_ u_mac16_top_u_mac_u_mul_r_s31__13_ u_mac16_top_u_mac_u_mul_r_s30__13_ XOR3X0P5H9R
XU2409 u_mac16_top_u_mac_u_mul_s40__19_ VDD VSS u_mac16_top_u_mac_u_mul_r_s30__19_ u_mac16_top_u_mac_u_mul_r_c30__19_ u_mac16_top_u_mac_u_mul_r_s31__19_ XOR3X0P5H9R
XU2410 u_mac16_top_u_mac_u_mul_s40__20_ VDD VSS u_mac16_top_u_mac_u_mul_r_c30__20_ u_mac16_top_u_mac_u_mul_r_s31__20_ u_mac16_top_u_mac_u_mul_r_s30__20_ XOR3X0P5H9R
XU2411 u_mac16_top_u_mac_u_mul_s40__14_ VDD VSS u_mac16_top_u_mac_u_mul_r_c30__14_ u_mac16_top_u_mac_u_mul_r_s31__14_ u_mac16_top_u_mac_u_mul_r_s30__14_ XOR3X0P5H9R
XU2412 u_mac16_top_u_mac_u_mul_s40__8_ VDD VSS u_mac16_top_u_mac_u_mul_r_c30__8_ u_mac16_top_u_mac_u_mul_r_s31__8_ u_mac16_top_u_mac_u_mul_r_s30__8_ XOR3X0P5H9R
XU2413 u_mac16_top_u_mac_u_mul_s40__15_ VDD VSS u_mac16_top_u_mac_u_mul_r_c30__15_ u_mac16_top_u_mac_u_mul_r_s31__15_ u_mac16_top_u_mac_u_mul_r_s30__15_ XOR3X0P5H9R
XU2414 u_mac16_top_u_mac_u_mul_s40__17_ VDD VSS u_mac16_top_u_mac_u_mul_r_c30__17_ u_mac16_top_u_mac_u_mul_r_s31__17_ u_mac16_top_u_mac_u_mul_r_s30__17_ XOR3X0P5H9R
XU2415 u_mac16_top_u_mac_u_mul_s40__16_ VDD VSS u_mac16_top_u_mac_u_mul_r_s30__16_ u_mac16_top_u_mac_u_mul_r_c30__16_ u_mac16_top_u_mac_u_mul_r_s31__16_ XOR3X0P5H9R
XU2416 u_mac16_top_u_mac_u_mul_s40__10_ VDD VSS u_mac16_top_u_mac_u_mul_r_c30__10_ u_mac16_top_u_mac_u_mul_r_s31__10_ u_mac16_top_u_mac_u_mul_r_s30__10_ XOR3X0P5H9R
XU2417 u_mac16_top_u_mac_u_mul_s40__7_ VDD VSS u_mac16_top_u_mac_u_mul_r_c30__7_ u_mac16_top_u_mac_u_mul_r_s31__7_ u_mac16_top_u_mac_u_mul_r_s30__7_ XOR3X0P5H9R
XU2418 u_mac16_top_u_mac_u_mul_s41__18_ VDD VSS u_mac16_top_u_mac_u_mul_r_s23__18_ u_mac16_top_u_mac_u_mul_r_c31__18_ u_mac16_top_u_mac_u_mul_r_c23__18_ XOR3X0P5H9R
XU2419 u_mac16_top_u_mac_u_mul_s41__17_ VDD VSS u_mac16_top_u_mac_u_mul_r_s23__17_ u_mac16_top_u_mac_u_mul_r_c31__17_ u_mac16_top_u_mac_u_mul_r_c23__17_ XOR3X0P5H9R
XU2420 u_mac16_top_u_mac_u_mul_s40__9_ VDD VSS u_mac16_top_u_mac_u_mul_r_c30__9_ u_mac16_top_u_mac_u_mul_r_s31__9_ u_mac16_top_u_mac_u_mul_r_s30__9_ XOR3X0P5H9R
XU2421 u_mac16_top_u_mac_u_mul_s41__16_ VDD VSS u_mac16_top_u_mac_u_mul_r_s23__16_ u_mac16_top_u_mac_u_mul_r_c31__16_ u_mac16_top_u_mac_u_mul_r_c23__16_ XOR3X0P5H9R
XU2422 u_mac16_top_u_mac_u_mul_s40__11_ VDD VSS u_mac16_top_u_mac_u_mul_r_c30__11_ u_mac16_top_u_mac_u_mul_r_s31__11_ u_mac16_top_u_mac_u_mul_r_s30__11_ XOR3X0P5H9R
XU2423 u_mac16_top_u_mac_u_mul_s40__18_ VDD VSS u_mac16_top_u_mac_u_mul_r_s30__18_ u_mac16_top_u_mac_u_mul_r_c30__18_ u_mac16_top_u_mac_u_mul_r_s31__18_ XOR3X0P5H9R
XU2424 u_mac16_top_u_mac_u_mul_s41__20_ VDD VSS u_mac16_top_u_mac_u_mul_r_s23__20_ u_mac16_top_u_mac_u_mul_r_c31__20_ u_mac16_top_u_mac_u_mul_r_c23__20_ XOR3X0P5H9R
XU2425 u_mac16_top_u_mac_u_mul_s41__19_ VDD VSS u_mac16_top_u_mac_u_mul_r_s23__19_ u_mac16_top_u_mac_u_mul_r_c31__19_ u_mac16_top_u_mac_u_mul_r_c23__19_ XOR3X0P5H9R
XU2426 u_mac16_top_u_mac_u_mul_s31__12_ VDD VSS u_mac16_top_u_mac_u_mul_r_c21__12_ u_mac16_top_u_mac_u_mul_r_c22__12_ u_mac16_top_u_mac_u_mul_r_s22__12_ XOR3X0P5H9R
XU2427 u_mac16_top_u_mac_u_mul_s41__22_ VDD VSS u_mac16_top_u_mac_u_mul_r_s23__22_ u_mac16_top_u_mac_u_mul_r_c31__22_ u_mac16_top_u_mac_u_mul_r_c23__22_ XOR3X0P5H9R
XU2428 u_mac16_top_u_mac_u_mul_s41__21_ VDD VSS u_mac16_top_u_mac_u_mul_r_s23__21_ u_mac16_top_u_mac_u_mul_r_c31__21_ u_mac16_top_u_mac_u_mul_r_c23__21_ XOR3X0P5H9R
XU2429 u_mac16_top_u_mac_u_mul_s40__21_ VDD VSS u_mac16_top_u_mac_u_mul_r_c30__21_ u_mac16_top_u_mac_u_mul_r_s31__21_ u_mac16_top_u_mac_u_mul_r_s30__21_ XOR3X0P5H9R
XU2430 n1511 VDD VSS u_mac16_top_u_out_bits_left__0_ u_mac16_top_u_out_bits_left__1_ NOR2X1H9R
XU2431 n1847 VDD VSS u_mac16_top_op_fifo_count__1_ u_mac16_top_op_fifo_count__0_ NOR2X0P5H9R
XU2432 n2339 VDD VSS n1847 u_mac16_top_op_fifo_count__2_ u_mac16_top_schedule_active AOI2XB1X0P5H9R
XctmTdsLR_1_42 tmp_net0 VDD VSS n2359 n1262 n1817 n1816 n1815 AOI221X0P5H9R
XctmTdsLR_2_43 n1839 VDD VSS n1822 n1819 n1811 tmp_net0 OAI31X0P5H9R
XctmTdsLR_1_44 tmp_net1 VDD VSS n1476 n1546 NOR2XBX1H9R
XctmTdsLR_2_45 n919 VDD VSS n1545 tmp_net1 n1494 n2385 NAND4XXXBX2H9R
XctmTdsLR_1_46 tmp_net2 VDD VSS n1357 n1355 NOR2X0P7H9R
XctmTdsLR_2_47 u_mac16_top_u_mac_u_mul_N50 VDD VSS n1536 tmp_net2 XNOR2X0P7H9R
XctmTdsLR_1_48 n1358 VDD VSS n2387 n1355 n1357 AOI2XB1X0P7H9R
XctmTdsLR_2_49 n861 VDD VSS n847 n1530 n1355 n1358 OAI31X2H9R
XctmTdsLR_1_56 tmp_net4 VDD VSS n1683 n1033 NOR2X0P5H9R
XU2443 n1514 VDD VSS n1511 n1372 NAND2X0P7H9R
XU2455 n1462 n1339 VDD VSS n1461 n1460 n1459 ADDFX1H9R
XctmTdsLR_1_172 n1162 VDD VSS u_mac16_top_u_mac_u_mul_r_c40__14_ u_mac16_top_u_mac_u_mul_r_s41__14_ u_mac16_top_u_mac_u_mul_r_s40__14_ XNOR3X0P5H9R
XctmTdsLR_1_173 n1115 VDD VSS u_mac16_top_u_mac_u_mul_r_c40__7_ ZBUF_50_13 n1113 n1112 OAI211X1H9R
XU2458 u_mac16_top_N117 VDD VSS n1517 n1474 NAND2X0P7H9R
XU2459 u_mac16_top_N123 VDD VSS n1474 u_mac16_top_fifo_wr_ptr__1_ n1470 NOR3X1H9R
XctmTdsLR_2_133 n1517 VDD VSS n1518 tmp_net33 NAND2X0P7H9R
XctmTdsLR_1_134 ZBUF_2_6 VDD VSS ZBUF_9_8 n1484 XOR2X1H9R
XU2462 u_mac16_top_N139 VDD VSS u_mac16_top_op_fifo_wr_ptr__1_ n1468 n1472 NOR3X1H9R
XU2463 u_mac16_top_N122 VDD VSS n1474 u_mac16_top_fifo_wr_ptr__0_ n1469 NOR3X1H9R
XU2464 u_mac16_top_N137 VDD VSS n1472 n1468 n1471 NOR3X1H9R
XU2465 u_mac16_top_N140 VDD VSS u_mac16_top_op_fifo_wr_ptr__0_ u_mac16_top_op_fifo_wr_ptr__1_ n1472 NOR3X1H9R
XU2466 u_mac16_top_N121 VDD VSS n1474 n1470 n1469 NOR3X1H9R
XU2467 u_mac16_top_N138 VDD VSS u_mac16_top_op_fifo_wr_ptr__0_ n1472 n1471 NOR3X1H9R
XU2468 u_mac16_top_u_inB_N48 VDD VSS n1473 n2198 NOR2X0P5H9R
XU2469 n1516 VDD VSS n1514 u_mac16_top_u_out_bits_left__5_ u_mac16_top_u_out_bits_left__4_ OR3X0P5H9R
XU2470 n732 VDD VSS n1842 n1841 NAND2X0P5H9R
XU2471 u_mac16_top_u_inA_N48 VDD VSS n1473 n2200 NOR2X0P5H9R
XU2472 u_mac16_top_N124 VDD VSS n1474 u_mac16_top_fifo_wr_ptr__0_ u_mac16_top_fifo_wr_ptr__1_ NOR3X1H9R
XU2473 n2266 VDD VSS u_mac16_top_u_mac_u_mul_r_c30__8_ u_mac16_top_u_mac_u_mul_r_s31__8_ u_mac16_top_u_mac_u_mul_r_s30__8_ CGENX1H9R
XU2474 n2267 VDD VSS u_mac16_top_u_mac_u_mul_r_c30__13_ u_mac16_top_u_mac_u_mul_r_s31__13_ u_mac16_top_u_mac_u_mul_r_s30__13_ CGENX1H9R
XU2476 n2269 VDD VSS u_mac16_top_u_mac_u_mul_r_c30__15_ u_mac16_top_u_mac_u_mul_r_s31__15_ u_mac16_top_u_mac_u_mul_r_s30__15_ CGENX1H9R
XU2477 n2270 VDD VSS u_mac16_top_u_mac_u_mul_r_s30__16_ u_mac16_top_u_mac_u_mul_r_c30__16_ u_mac16_top_u_mac_u_mul_r_s31__16_ CGENX1H9R
XU2478 n2271 VDD VSS u_mac16_top_u_mac_u_mul_r_s23__18_ u_mac16_top_u_mac_u_mul_r_c31__18_ u_mac16_top_u_mac_u_mul_r_c23__18_ CGENX1H9R
XU2479 n2272 VDD VSS u_mac16_top_u_mac_u_mul_r_s23__19_ u_mac16_top_u_mac_u_mul_r_c31__19_ u_mac16_top_u_mac_u_mul_r_c23__19_ CGENX1H9R
XU2480 n2273 VDD VSS u_mac16_top_u_mac_u_mul_r_s23__17_ u_mac16_top_u_mac_u_mul_r_c31__17_ u_mac16_top_u_mac_u_mul_r_c23__17_ CGENX1H9R
XU2481 n2274 VDD VSS u_mac16_top_u_mac_u_mul_r_s23__16_ u_mac16_top_u_mac_u_mul_r_c31__16_ u_mac16_top_u_mac_u_mul_r_c23__16_ CGENX1H9R
XU2482 n2275 VDD VSS u_mac16_top_u_mac_u_mul_r_c30__7_ u_mac16_top_u_mac_u_mul_r_s31__7_ u_mac16_top_u_mac_u_mul_r_s30__7_ CGENX1H9R
XU2483 n2276 VDD VSS u_mac16_top_u_mac_u_mul_r_c30__9_ u_mac16_top_u_mac_u_mul_r_s31__9_ u_mac16_top_u_mac_u_mul_r_s30__9_ CGENX1H9R
XU2484 n2277 VDD VSS u_mac16_top_u_mac_u_mul_r_s30__10_ u_mac16_top_u_mac_u_mul_r_c30__10_ u_mac16_top_u_mac_u_mul_r_s31__10_ CGENX1H9R
XU2485 n2278 VDD VSS u_mac16_top_u_mac_u_mul_r_s30__11_ u_mac16_top_u_mac_u_mul_r_c30__11_ u_mac16_top_u_mac_u_mul_r_s31__11_ CGENX1H9R
XU2486 n2279 VDD VSS u_mac16_top_u_mac_u_mul_r_s30__14_ u_mac16_top_u_mac_u_mul_r_c30__14_ u_mac16_top_u_mac_u_mul_r_s31__14_ CGENX1H9R
XU2487 n2280 VDD VSS u_mac16_top_u_mac_u_mul_r_c30__17_ u_mac16_top_u_mac_u_mul_r_s31__17_ u_mac16_top_u_mac_u_mul_r_s30__17_ CGENX1H9R
XU2488 n2281 VDD VSS u_mac16_top_u_mac_u_mul_r_c30__18_ u_mac16_top_u_mac_u_mul_r_s31__18_ u_mac16_top_u_mac_u_mul_r_s30__18_ CGENX1H9R
XU2489 n2282 VDD VSS u_mac16_top_u_mac_u_mul_r_c30__19_ u_mac16_top_u_mac_u_mul_r_s31__19_ u_mac16_top_u_mac_u_mul_r_s30__19_ CGENX1H9R
XU2490 n2283 VDD VSS u_mac16_top_u_mac_u_mul_r_s23__22_ u_mac16_top_u_mac_u_mul_r_c31__22_ u_mac16_top_u_mac_u_mul_r_c23__22_ CGENX1H9R
XU2491 n2284 VDD VSS u_mac16_top_u_mac_u_mul_r_s23__21_ u_mac16_top_u_mac_u_mul_r_c31__21_ u_mac16_top_u_mac_u_mul_r_c23__21_ CGENX1H9R
XU2492 n2285 VDD VSS u_mac16_top_u_mac_u_mul_r_s23__20_ u_mac16_top_u_mac_u_mul_r_c31__20_ u_mac16_top_u_mac_u_mul_r_c23__20_ CGENX1H9R
XU2493 n2286 VDD VSS u_mac16_top_u_mac_u_mul_r_c30__20_ u_mac16_top_u_mac_u_mul_r_s31__20_ u_mac16_top_u_mac_u_mul_r_s30__20_ CGENX1H9R
XU2494 n2287 VDD VSS u_mac16_top_u_mac_u_mul_r_c30__21_ u_mac16_top_u_mac_u_mul_r_s31__21_ u_mac16_top_u_mac_u_mul_r_s30__21_ CGENX1H9R
XU2495 n2288 VDD VSS u_mac16_top_u_mac_u_mul_r_c21__12_ u_mac16_top_u_mac_u_mul_r_c22__12_ u_mac16_top_u_mac_u_mul_r_s22__12_ CGENX1H9R
XU2499 n1500 VDD VSS u_mac16_top_op_fifo_count__1_ u_mac16_top_op_fifo_count__0_ XOR2X0P5H9R
XctmTdsLR_2_819 tmp_net58 VDD VSS u_mac16_top_u_mac_u_mul_r_s41__17_ u_mac16_top_u_mac_u_mul_r_c41__17_ XNOR2X0P5H9R
XctmTdsLR_1_197 n2080 VDD VSS n2072 n2073 n2074 AOI21X0P5H9R
XctmTdsLR_1_135 n1139 VDD VSS u_mac16_top_u_mac_u_mul_r_c40__18_ u_mac16_top_u_mac_u_mul_r_s41__18_ u_mac16_top_u_mac_u_mul_r_s40__18_ XOR3X0P5H9R
XU2511 u_mac16_top_N91 VDD VSS n926 n1518 n2145 n1517 OAI31X0P5H9R
XctmTdsLR_1_106 tmp_net23 VDD VSS u_mac16_top_u_inA_cnt__0_ u_mac16_top_u_inA_cnt__1_ n1808 OAI21X0P5H9R
XU2516 u_mac16_top_u_mac_u_mul_N39 VDD VSS n1563 n1564 XOR2X0P5H9R
XU2521 n1582 VDD VSS n1579 n1822 n1578 OAI21X0P5H9R
XU2522 u_mac16_top_u_mac_add_tmp_comb__23_ VDD VSS n1584 n1838 n1757 n1583 AO22X0P5H9R
XctmTdsLR_1_174 tmp_net41 VDD VSS n1500 n1845 u_mac16_top_schedule_active NAND3X0P5H9R
XU2536 u_mac16_top_u_mac_add_tmp_comb__13_ VDD VSS n1639 n1838 n1757 n1638 AO22X0P5H9R
XU2540 u_mac16_top_u_mac_add_tmp_comb__12_ VDD VSS n1652 n1838 n1757 n1651 AO22X0P5H9R
XctmTdsLR_2_107 u_mac16_top_u_inA_N50 VDD VSS n1806 tmp_net23 NOR2X0P5H9R
XctmTdsLR_1_137 n1147 VDD VSS u_mac16_top_u_mac_u_mul_r_s40__21_ u_mac16_top_u_mac_u_mul_r_s41__21_ u_mac16_top_u_mac_u_mul_r_c40__21_ XOR3X0P7H9R
XctmTdsLR_1_108 tmp_net24 VDD VSS n1585 n1251 n1250 OAI21X0P5H9R
XctmTdsLR_2_109 n1256 VDD VSS tmp_net24 n1255 XNOR2X0P5H9R
XctmTdsLR_1_820 n1527 VDD VSS tmp_net59 n1175 AND2X1H9R
XctmTdsLR_1_110 tmp_net25 VDD VSS n1538 n2369 n1477 n1476 AOI31X1H9R
XU2554 n1686 VDD VSS n1684 INVX0P5H9R
XctmTdsLR_2_111 tmp_net26 VDD VSS n922 n2385 NAND2XBX0P5H9R
XctmTdsLR_2_57 n948 VDD VSS n1031 n1619 n1030 tmp_net4 AOI211X0P7H9R
XctmTdsLR_1_198 n1577 VDD VSS n1315 n1820 n1816 OAI21BX0P5H9R
XctmTdsLR_1_199 n889 VDD VSS n1114 n1115 AND2X2H9R
XctmTdsLR_1_186 n1495 VDD VSS n1111 n1122 NAND2BX1P4H9R
XctmTdsLR_1_187 n1783 VDD VSS n1781 n1780 NAND2XBX0P7H9R
XU2590 n730 VDD VSS n1842 out_ready n1841 OAI2XB1X0P5H9R
XctmTdsLR_1_58 n949 VDD VSS n1565 n1585 n1568 AOI2XB1X0P5H9R
XU2594 n1835 VDD VSS n1833 n1825 OR2X0P5H9R
XU2596 n729 VDD VSS n1838 n1839 n1837 OAI2XB1X0P5H9R
XU2597 u_mac16_top_N205 VDD VSS n1847 n1846 n1845 NAND3X0P5H9R
XU2600 u_mac16_top_u_mac_u_mul_c31__23_ u_mac16_top_u_mac_u_mul_s31__22_ VDD VSS u_mac16_top_u_mac_u_mul_r_c21__22_ u_mac16_top_u_mac_u_mul_r_c22__22_ u_mac16_top_u_mac_u_mul_r_s22__22_ ADDFX1H9R
XU2601 u_mac16_top_u_mac_u_mul_c31__22_ u_mac16_top_u_mac_u_mul_s31__21_ VDD VSS u_mac16_top_u_mac_u_mul_r_c21__21_ u_mac16_top_u_mac_u_mul_r_c22__21_ u_mac16_top_u_mac_u_mul_r_s22__21_ ADDFX1H9R
XU2602 u_mac16_top_u_mac_u_mul_c31__21_ u_mac16_top_u_mac_u_mul_s31__20_ VDD VSS u_mac16_top_u_mac_u_mul_r_c21__20_ u_mac16_top_u_mac_u_mul_r_c22__20_ u_mac16_top_u_mac_u_mul_r_s22__20_ ADDFX1H9R
XU2603 u_mac16_top_u_mac_u_mul_c31__20_ u_mac16_top_u_mac_u_mul_s31__19_ VDD VSS u_mac16_top_u_mac_u_mul_r_c21__19_ u_mac16_top_u_mac_u_mul_r_c22__19_ u_mac16_top_u_mac_u_mul_r_s22__19_ ADDFX1H9R
XU2604 u_mac16_top_u_mac_u_mul_c31__19_ u_mac16_top_u_mac_u_mul_s31__18_ VDD VSS u_mac16_top_u_mac_u_mul_r_c21__18_ u_mac16_top_u_mac_u_mul_r_c22__18_ u_mac16_top_u_mac_u_mul_r_s22__18_ ADDFX1H9R
XU2605 u_mac16_top_u_mac_u_mul_c31__18_ u_mac16_top_u_mac_u_mul_s31__17_ VDD VSS u_mac16_top_u_mac_u_mul_r_c21__17_ u_mac16_top_u_mac_u_mul_r_c22__17_ u_mac16_top_u_mac_u_mul_r_s22__17_ ADDFX1H9R
XU2606 u_mac16_top_u_mac_u_mul_c31__17_ u_mac16_top_u_mac_u_mul_s31__16_ VDD VSS u_mac16_top_u_mac_u_mul_r_c21__16_ u_mac16_top_u_mac_u_mul_r_c22__16_ u_mac16_top_u_mac_u_mul_r_s22__16_ ADDFX1H9R
XU2607 u_mac16_top_u_mac_u_mul_c31__16_ u_mac16_top_u_mac_u_mul_s31__15_ VDD VSS u_mac16_top_u_mac_u_mul_r_c21__15_ u_mac16_top_u_mac_u_mul_r_c22__15_ u_mac16_top_u_mac_u_mul_r_s22__15_ ADDFX1H9R
XU2608 u_mac16_top_u_mac_u_mul_c31__15_ u_mac16_top_u_mac_u_mul_s31__14_ VDD VSS u_mac16_top_u_mac_u_mul_r_c21__14_ u_mac16_top_u_mac_u_mul_r_c22__14_ u_mac16_top_u_mac_u_mul_r_s22__14_ ADDFX1H9R
XU2609 u_mac16_top_u_mac_u_mul_c31__14_ u_mac16_top_u_mac_u_mul_s31__13_ VDD VSS u_mac16_top_u_mac_u_mul_r_c21__13_ u_mac16_top_u_mac_u_mul_r_c22__13_ u_mac16_top_u_mac_u_mul_r_s22__13_ ADDFX1H9R
XU2610 u_mac16_top_u_mac_u_mul_c30__19_ u_mac16_top_u_mac_u_mul_s30__18_ VDD VSS u_mac16_top_u_mac_u_mul_r_s20__18_ u_mac16_top_u_mac_u_mul_r_s21__18_ u_mac16_top_u_mac_u_mul_r_c20__18_ ADDFX1H9R
XU2611 u_mac16_top_u_mac_u_mul_c30__18_ u_mac16_top_u_mac_u_mul_s30__17_ VDD VSS u_mac16_top_u_mac_u_mul_r_s20__17_ u_mac16_top_u_mac_u_mul_r_s21__17_ u_mac16_top_u_mac_u_mul_r_c20__17_ ADDFX1H9R
XU2612 u_mac16_top_u_mac_u_mul_c30__17_ u_mac16_top_u_mac_u_mul_s30__16_ VDD VSS u_mac16_top_u_mac_u_mul_r_s20__16_ u_mac16_top_u_mac_u_mul_r_s21__16_ u_mac16_top_u_mac_u_mul_r_c20__16_ ADDFX1H9R
XU2613 u_mac16_top_u_mac_u_mul_c30__16_ u_mac16_top_u_mac_u_mul_s30__15_ VDD VSS n1848 u_mac16_top_u_mac_u_mul_r_s21__15_ u_mac16_top_u_mac_u_mul_r_c20__15_ ADDFX1H9R
XU2614 u_mac16_top_u_mac_u_mul_c30__15_ u_mac16_top_u_mac_u_mul_s30__14_ VDD VSS u_mac16_top_u_mac_u_mul_r_s20__14_ u_mac16_top_u_mac_u_mul_r_s21__14_ u_mac16_top_u_mac_u_mul_r_c20__14_ ADDFX1H9R
XU2615 u_mac16_top_u_mac_u_mul_c30__14_ u_mac16_top_u_mac_u_mul_s30__13_ VDD VSS u_mac16_top_u_mac_u_mul_r_s20__13_ u_mac16_top_u_mac_u_mul_r_s21__13_ u_mac16_top_u_mac_u_mul_r_c20__13_ ADDFX1H9R
XU2616 u_mac16_top_u_mac_u_mul_c30__13_ u_mac16_top_u_mac_u_mul_s30__12_ VDD VSS n1849 u_mac16_top_u_mac_u_mul_r_s21__12_ u_mac16_top_u_mac_u_mul_r_c20__12_ ADDFX1H9R
XU2617 u_mac16_top_u_mac_u_mul_c30__12_ u_mac16_top_u_mac_u_mul_s30__11_ VDD VSS u_mac16_top_u_mac_u_mul_r_s20__11_ u_mac16_top_u_mac_u_mul_r_s21__11_ u_mac16_top_u_mac_u_mul_r_c20__11_ ADDFX1H9R
XU2618 u_mac16_top_u_mac_u_mul_c30__11_ u_mac16_top_u_mac_u_mul_s30__10_ VDD VSS u_mac16_top_u_mac_u_mul_r_s20__10_ u_mac16_top_u_mac_u_mul_r_s21__10_ u_mac16_top_u_mac_u_mul_r_c20__10_ ADDFX1H9R
XU2619 u_mac16_top_u_mac_u_mul_c30__10_ u_mac16_top_u_mac_u_mul_s30__9_ VDD VSS u_mac16_top_u_mac_u_mul_r_s20__9_ u_mac16_top_u_mac_u_mul_r_s21__9_ u_mac16_top_u_mac_u_mul_r_c20__9_ ADDFX1H9R
XU2620 u_mac16_top_u_mac_u_mul_c30__9_ u_mac16_top_u_mac_u_mul_s30__8_ VDD VSS u_mac16_top_u_mac_u_mul_r_s20__8_ u_mac16_top_u_mac_u_mul_r_s21__8_ u_mac16_top_u_mac_u_mul_r_c20__8_ ADDFX1H9R
XU2621 u_mac16_top_u_mac_u_mul_c30__8_ u_mac16_top_u_mac_u_mul_s30__7_ VDD VSS u_mac16_top_u_mac_u_mul_r_s20__7_ u_mac16_top_u_mac_u_mul_r_s21__7_ u_mac16_top_u_mac_u_mul_r_c20__7_ ADDFX1H9R
XU2622 u_mac16_top_u_mac_u_mul_c30__7_ u_mac16_top_u_mac_u_mul_s30__6_ VDD VSS u_mac16_top_u_mac_u_mul_r_s20__6_ u_mac16_top_u_mac_u_mul_r_s21__6_ u_mac16_top_u_mac_u_mul_r_c20__6_ ADDFX1H9R
XU2623 u_mac16_top_u_mac_u_mul_c30__6_ u_mac16_top_u_mac_u_mul_s30__5_ VDD VSS u_mac16_top_u_mac_u_mul_r_s20__5_ u_mac16_top_u_mac_u_mul_r_s21__5_ u_mac16_top_u_mac_u_mul_r_c20__5_ ADDFX1H9R
XU2633 n1931 VDD VSS n1883 n2057 NOR2X0P5H9R
XctmTdsLR_1_832 n1518 VDD VSS n1508 tmp_net60 NAND2X0P7H9R
XU2656 n1888 n1898 VDD VSS n1892 n1891 n1890 ADDFX1H9R
XU2657 n1455 n1896 VDD VSS n1895 n1894 n1893 ADDFX1H9R
XU2658 u_mac16_top_u_mac_u_mul_c22__23_ n762 VDD VSS n1898 n1897 n1896 ADDFX1H9R
XU2659 n1897 n1907 VDD VSS n1901 n1900 n1899 ADDFX1H9R
XctmTdsLR_2_833 tmp_net60 VDD VSS n1507 INVX0P5H9R
XU2661 u_mac16_top_u_mac_u_mul_c22__22_ n763 VDD VSS n1907 n1906 n1905 ADDFX1H9R
XU2662 n1906 n1916 VDD VSS n1910 n1909 n1908 ADDFX1H9R
XU2663 n1853 n1914 VDD VSS n1913 n1912 n1911 ADDFX1H9R
XU2664 u_mac16_top_u_mac_u_mul_c22__21_ n764 VDD VSS n1916 n1915 n1914 ADDFX1H9R
XU2665 n1915 n1925 VDD VSS n1919 n1918 n1917 ADDFX1H9R
XctmTdsLR_1_834 n1585 VDD VSS tmp_net61 tmp_net62 n983 AND3X1H9R
XU2667 u_mac16_top_u_mac_u_mul_c22__20_ n765 VDD VSS n1925 n1924 n1923 ADDFX1H9R
XU2668 n1924 n1934 VDD VSS n1928 n1927 n1926 ADDFX1H9R
XU2669 n1859 n1932 VDD VSS n1931 n1930 n1929 ADDFX1H9R
XU2670 u_mac16_top_u_mac_u_mul_c22__19_ n766 VDD VSS n1933 n1934 n1932 ADDFX1H9R
XU2671 n1933 n1943 VDD VSS n1937 n1936 n1935 ADDFX1H9R
XctmTdsLR_2_835 tmp_net61 VDD VSS n1027 n986 NAND2X0P5H9R
XU2674 u_mac16_top_u_mac_u_mul_c22__18_ n767 VDD VSS n1943 n1942 n1941 ADDFX1H9R
XU2675 n1942 n1955 VDD VSS n1946 n1945 n1944 ADDFX1H9R
XU2677 n1865 n1953 VDD VSS n1952 n1951 n1950 ADDFX1H9R
XU2678 u_mac16_top_u_mac_u_mul_c22__17_ n768 VDD VSS n1955 n1954 n1953 ADDFX1H9R
XU2679 n1954 n1967 VDD VSS n1958 n1957 n1956 ADDFX1H9R
XU2680 n1966 n1067 VDD VSS n1961 n1960 n1959 ADDFX1H9R
XctmTdsLR_3_836 tmp_net62 VDD VSS n1640 n984 OR2X0P5H9R
XU2682 u_mac16_top_u_mac_u_mul_c22__16_ n769 VDD VSS n1965 n1966 n1967 ADDFX1H9R
XU2683 n967 n1973 VDD VSS n1970 n1969 n1968 ADDFX1H9R
XU2684 u_mac16_top_u_mac_u_mul_c21__20_ n747 VDD VSS n1973 n1972 n1971 ADDFX1H9R
XU2688 n1972 n1978 VDD VSS n1977 n1976 n1975 ADDFX1H9R
XU2689 u_mac16_top_u_mac_u_mul_c21__19_ n748 VDD VSS n1980 n1979 n1978 ADDFX1H9R
XU2690 n1979 n1987 VDD VSS n1983 n1982 n1981 ADDFX1H9R
XU2693 u_mac16_top_u_mac_u_mul_c21__18_ n749 VDD VSS n1987 n1986 n1985 ADDFX1H9R
XU2694 n1986 n1996 VDD VSS n1990 n1989 n1988 ADDFX1H9R
XU2697 n1994 n1236 VDD VSS n1993 n1992 n1991 ADDFX1H9R
XU2698 u_mac16_top_u_mac_u_mul_c21__17_ n750 VDD VSS n1996 n1995 n1994 ADDFX1H9R
XU2699 n1995 n2004 VDD VSS n1999 n1998 n1997 ADDFX1H9R
XU2704 u_mac16_top_u_mac_u_mul_c21__16_ n751 VDD VSS n2004 n2003 n2002 ADDFX1H9R
XU2705 n2003 n2013 VDD VSS n2007 n2006 n2005 ADDFX1H9R
XU2706 n2016 VDD VSS n2206 n2121 NOR2X0P7H9R
XU2709 n2011 n961 VDD VSS n2010 n2009 n2008 ADDFX1H9R
XU2710 u_mac16_top_u_mac_u_mul_c21__15_ n752 VDD VSS n2013 n2012 n2011 ADDFX1H9R
XU2711 n2025 VDD VSS n2206 n2057 NOR2X0P7H9R
XU2714 n2020 n1219 VDD VSS n2019 n2018 n2017 ADDFX1H9R
XU2715 u_mac16_top_u_mac_u_mul_c21__14_ n753 VDD VSS n2022 n2021 n2020 ADDFX1H9R
XU2716 n2034 VDD VSS n2206 n2059 NOR2X0P7H9R
XU2719 n2029 n1225 VDD VSS n2028 n2027 n2026 ADDFX1H9R
XU2720 u_mac16_top_u_mac_u_mul_c21__13_ n754 VDD VSS n2031 n2030 n2029 ADDFX1H9R
XU2725 u_mac16_top_u_mac_u_mul_c21__12_ n755 VDD VSS n2037 n2036 n2035 ADDFX1H9R
XU2726 n2049 VDD VSS n2206 n2044 NOR2X0P7H9R
XU2728 u_mac16_top_u_mac_u_mul_c21__11_ n756 VDD VSS n2042 n2043 n2041 ADDFX1H9R
XU2731 n2042 n2050 VDD VSS n2047 n2048 n2049 ADDFX1H9R
XU2732 u_mac16_top_u_mac_u_mul_c21__10_ n757 VDD VSS n2052 n2051 n2050 ADDFX1H9R
XU2733 n2051 n2064 VDD VSS n2056 n2055 n2054 ADDFX1H9R
XU2735 u_mac16_top_u_mac_u_mul_c21__9_ u_mac16_top_u_mac_u_mul_s21__8_ VDD VSS n2229 n2064 n2063 ADDFX1H9R
XU2736 n1980 n2068 VDD VSS n2067 n2066 n2065 ADDFX1H9R
XU2738 n2081 n1238 VDD VSS n2071 n2070 n2072 ADDFX1H9R
XU2740 n1985 n2079 VDD VSS n2078 n2077 n2076 ADDFX1H9R
XU2741 u_mac16_top_u_mac_u_mul_c20__17_ u_mac16_top_u_mac_u_mul_s20__16_ VDD VSS n2081 n2080 n2079 ADDFX1H9R
XU2742 n1237 n2093 VDD VSS n2084 n2082 n2083 ADDFX1H9R
XU2743 n2092 n959 VDD VSS n2087 n2086 n2085 ADDFX1H9R
XU2744 n2002 n2091 VDD VSS n2090 n2089 n2088 ADDFX1H9R
XU2745 u_mac16_top_u_mac_u_mul_c20__15_ n735 VDD VSS n2093 n2092 n2091 ADDFX1H9R
XU2746 n2035 n2103 VDD VSS n2094 n2095 n2096 ADDFX1H9R
XU2747 n2105 VDD VSS n2120 n2107 NOR2X0P7H9R
XU2748 n1226 n2101 VDD VSS n2100 n2099 n2098 ADDFX1H9R
XU2749 u_mac16_top_u_mac_u_mul_c20__11_ n739 VDD VSS n2103 n2102 n2101 ADDFX1H9R
XU2750 n2102 n2113 VDD VSS n2106 n2104 n2105 ADDFX1H9R
XU2752 n2041 n2111 VDD VSS n2110 n2109 n2108 ADDFX1H9R
XU2753 u_mac16_top_u_mac_u_mul_c20__10_ n740 VDD VSS n2113 n2112 n2111 ADDFX1H9R
XU2754 n2112 n2128 VDD VSS n2116 n2115 n2114 ADDFX1H9R
XU2756 n2052 n2126 VDD VSS n2125 n2124 n2123 ADDFX1H9R
XU2757 u_mac16_top_u_mac_u_mul_c20__9_ n741 VDD VSS n2127 n2128 n2126 ADDFX1H9R
XU2758 n2127 n2140 VDD VSS n2131 n2130 n2129 ADDFX1H9R
XU2760 n2063 n2138 VDD VSS n2137 n2136 n2135 ADDFX1H9R
XU2761 u_mac16_top_u_mac_u_mul_c20__8_ n742 VDD VSS n2139 n2140 n2138 ADDFX1H9R
XU2762 n1971 u_mac16_top_u_mac_u_mul_s11__18_ VDD VSS n2143 n2142 n2141 ADDFX1H9R
XU2763 n2151 VDD VSS u_mac16_top_result_fifo_3__0_ INVX0P5H9R
XU2767 n2154 VDD VSS u_mac16_top_result_fifo_3__1_ INVX0P5H9R
XU2772 n2160 VDD VSS u_mac16_top_result_fifo_3__3_ INVX0P5H9R
XU2775 n2163 VDD VSS u_mac16_top_result_fifo_3__4_ INVX0P5H9R
XU2778 n2166 VDD VSS u_mac16_top_result_fifo_3__5_ INVX0P5H9R
XU2781 n2169 VDD VSS u_mac16_top_result_fifo_3__6_ INVX0P5H9R
XU2786 n2175 VDD VSS u_mac16_top_result_fifo_3__8_ INVX0P5H9R
XU2789 n2178 VDD VSS u_mac16_top_result_fifo_3__9_ INVX0P5H9R
XU2792 n2182 VDD VSS u_mac16_top_result_fifo_3__10_ INVX0P5H9R
XU2795 n2188 VDD VSS u_mac16_top_result_fifo_3__11_ INVX0P5H9R
XU2798 n2195 VDD VSS u_mac16_top_result_fifo_3__23_ INVX0P5H9R
XU2806 u_mac16_top_N178 VDD VSS n2213 n2212 OR2X0P5H9R
XU2807 n1204 n2218 VDD VSS n2216 n2215 n2214 ADDFX1H9R
XU2810 n2225 n2209 VDD VSS n2224 n2223 n2222 ADDFX1H9R
XU2811 n2233 n964 VDD VSS n2232 n2231 n2230 ADDFX1H9R
XU2813 n962 n2240 VDD VSS n2238 n2237 n2236 ADDFX1H9R
Xu_mac16_top_u_mac_u_mul_r_c41_reg_19_ u_mac16_top_u_mac_u_mul_r_c41__19_ VDD VSS u_mac16_top_u_mac_u_mul_net771 n2271 HFSNET_28 optlc_net_104 optlc_net_104 SDFFRPQX0P5H9R
Xu_mac16_top_u_mac_u_mul_r_c40_reg_11_ u_mac16_top_u_mac_u_mul_r_c40__11_ VDD VSS u_mac16_top_u_mac_u_mul_net786 n2277 HFSNET_28 DFFRPQX0P5H9R
Xu_mac16_top_u_mac_u_mul_r_s40_reg_14_ u_mac16_top_u_mac_u_mul_r_s40__14_ VDD VSS u_mac16_top_u_mac_u_mul_net781 u_mac16_top_u_mac_u_mul_s40__14_ HFSNET_28 DFFRPQX0P5H9R
Xu_mac16_top_u_mac_u_mul_product_reg_reg_18_ u_mac16_top_u_mac_mult_result__18_ VDD VSS clk u_mac16_top_u_mac_u_mul_N51 HFSNET_32 DFFRPQX0P5H9R
Xu_mac16_top_u_mac_u_mul_product_reg_reg_7_ u_mac16_top_u_mac_mult_result__7_ VDD VSS clk u_mac16_top_u_mac_u_mul_N40 HFSNET_32 DFFRPQX0P5H9R
Xu_mac16_top_u_mac_u_mul_product_reg_reg_14_ u_mac16_top_u_mac_mult_result__14_ VDD VSS clk u_mac16_top_u_mac_u_mul_N47 HFSNET_17 DFFRPQX0P5H9R
Xu_mac16_top_u_mac_u_mul_product_reg_reg_10_ u_mac16_top_u_mac_mult_result__10_ VDD VSS clk u_mac16_top_u_mac_u_mul_N43 HFSNET_32 DFFRPQX0P5H9R
Xu_mac16_top_u_mac_u_mul_r_c40_reg_19_ u_mac16_top_u_mac_u_mul_r_c40__19_ VDD VSS u_mac16_top_u_mac_u_mul_net786 n2281 HFSNET_30 DFFRPQX0P5H9R
Xu_mac16_top_u_mac_last_prod_reg_3_ u_mac16_top_u_mac_last_prod__3_ VDD VSS u_mac16_top_u_mac_net693 u_mac16_top_u_mac_mult_result__3_ HFSNET_29 DFFRPQX0P5H9R
Xu_mac16_top_u_mac_last_prod_reg_8_ u_mac16_top_u_mac_last_prod__8_ VDD VSS u_mac16_top_u_mac_net693 u_mac16_top_u_mac_mult_result__8_ HFSNET_29 DFFRPQX0P5H9R
Xu_mac16_top_u_mac_last_prod_reg_1_ u_mac16_top_u_mac_last_prod__1_ VDD VSS u_mac16_top_u_mac_net693 u_mac16_top_u_mac_mult_result__1_ HFSNET_29 DFFRPQX0P5H9R
Xu_mac16_top_u_mac_u_mul_r_s40_reg_8_ u_mac16_top_u_mac_u_mul_r_s40__8_ VDD VSS u_mac16_top_u_mac_u_mul_net781 u_mac16_top_u_mac_u_mul_s40__8_ HFSNET_28 DFFRPQX0P5H9R
Xu_mac16_top_u_mac_u_mul_r_s40_reg_7_ u_mac16_top_u_mac_u_mul_r_s40__7_ VDD VSS u_mac16_top_u_mac_u_mul_net781 u_mac16_top_u_mac_u_mul_s40__7_ HFSNET_30 DFFRPQX0P5H9R
Xu_mac16_top_u_mac_u_mul_r_s41_reg_18_ u_mac16_top_u_mac_u_mul_r_s41__18_ VDD VSS u_mac16_top_u_mac_u_mul_net771 u_mac16_top_u_mac_u_mul_s41__18_ HFSNET_30 DFFRPQX0P5H9R
Xu_mac16_top_u_mac_u_mul_r_s41_reg_17_ u_mac16_top_u_mac_u_mul_r_s41__17_ VDD VSS u_mac16_top_u_mac_u_mul_net771 u_mac16_top_u_mac_u_mul_s41__17_ HFSNET_30 DFFRPQX0P5H9R
Xu_mac16_top_u_mac_u_mul_product_reg_reg_1_ u_mac16_top_u_mac_mult_result__1_ VDD VSS clk u_mac16_top_u_mac_u_mul_N34 HFSNET_32 DFFRPQX0P5H9R
Xu_mac16_top_u_mac_u_mul_product_reg_reg_8_ u_mac16_top_u_mac_mult_result__8_ VDD VSS clk u_mac16_top_u_mac_u_mul_N41 HFSNET_17 DFFRPQX0P5H9R
Xu_mac16_top_u_mac_u_mul_product_reg_reg_9_ u_mac16_top_u_mac_mult_result__9_ VDD VSS clk u_mac16_top_u_mac_u_mul_N42 HFSNET_1 DFFRPQX0P5H9R
Xu_mac16_top_u_mac_u_mul_product_reg_reg_16_ u_mac16_top_u_mac_mult_result__16_ VDD VSS clk u_mac16_top_u_mac_u_mul_N49 HFSNET_17 DFFRPQX0P5H9R
Xu_mac16_top_u_mac_last_prod_reg_19_ u_mac16_top_u_mac_last_prod__19_ VDD VSS u_mac16_top_u_mac_net693 u_mac16_top_u_mac_mult_result__19_ HFSNET_29 DFFRPQX0P5H9R
XU1163 n1346 VDD VSS n892 INVX0P5H9R
XctmTdsLR_2_175 n2347 VDD VSS n1502 u_mac16_top_schedule_active tmp_net41 OAI21X0P5H9R
XU1566 n933 VDD VSS n1210 n1209 n1346 n1208 OAI211X1H9R
XU1173 n1209 VDD VSS n1356 n1174 n1173 AOI21X2H9R
XU1588 n881 VDD VSS ZBUF_190_3 ZBUF_101_7 NOR2X1H9R
XU1638 n882 VDD VSS ZBUF_190_3 ZBUF_17_13 NOR2X0P5H9R
Xu_mac16_top_u_mac_last_prod_reg_12_ u_mac16_top_u_mac_net693 ropt_net_105 u_mac16_top_u_mac_last_prod__12_ n2367 VDD VSS DFFRQX1H9R
Xu_mac16_top_opA_reg_reg_10_ u_mac16_top_net570 n799 u_mac16_top_opA_reg_reg_10__Q_NC n2001 n2368 VDD VSS DFFRX1H9R
Xu_mac16_top_u_mac_u_mul_r_c40_reg_16_ u_mac16_top_u_mac_u_mul_r_c40__16_ VDD VSS u_mac16_top_u_mac_u_mul_net786 n2269 HFSNET_28 DFFRPQX0P5H9R
Xu_mac16_top_u_mac_accum_reg_reg_3_ u_mac16_top_u_mac_accum_reg__3_ VDD VSS u_mac16_top_u_mac_net682 u_mac16_top_u_mac_add_tmp_comb__3_ HFSNET_20 DFFRPQX0P5H9R
Xu_mac16_top_u_mac_u_mul_product_reg_reg_3_ u_mac16_top_u_mac_mult_result__3_ VDD VSS clk u_mac16_top_u_mac_u_mul_N36 HFSNET_32 DFFRPQX0P5H9R
Xu_mac16_top_u_mac_u_mul_r_s20_reg_14_ u_mac16_top_u_mac_u_mul_r_s20__14_ VDD VSS u_mac16_top_u_mac_u_mul_net721 n735 HFSNET_6 DFFRPQX0P5H9R
Xu_mac16_top_u_mac_last_prod_reg_7_ u_mac16_top_u_mac_net693 u_mac16_top_u_mac_mult_result__7_ u_mac16_top_u_mac_last_prod__7_ n2368 VDD VSS DFFRQX1H9R
Xu_mac16_top_u_mac_sum_out_reg_11_ u_mac16_top_mac_result__11_ VDD VSS u_mac16_top_u_mac_net688 u_mac16_top_u_mac_add_tmp_comb__11_ HFSNET_18 DFFRPQX0P5H9R
Xu_mac16_top_u_mac_sum_out_reg_15_ u_mac16_top_mac_result__15_ VDD VSS u_mac16_top_u_mac_net688 u_mac16_top_u_mac_add_tmp_comb__15_ HFSNET_16 DFFRPQX0P5H9R
Xu_mac16_top_u_mac_u_mul_r_s20_reg_4_ u_mac16_top_u_mac_u_mul_r_s20__4_ VDD VSS u_mac16_top_u_mac_u_mul_net721 u_mac16_top_u_mac_u_mul_s20__4_ HFSNET_6 DFFRPQX0P5H9R
Xu_mac16_top_u_mac_mode_d_reg u_mac16_top_u_mac_u_mul_net721 mode u_mac16_top_u_mac_mode_d n1838 HFSNET_26 VDD VSS DFFRX1H9R
Xu_mac16_top_u_mac_last_prod_reg_9_ u_mac16_top_u_mac_last_prod__9_ VDD VSS u_mac16_top_u_mac_net693 u_mac16_top_u_mac_mult_result__9_ HFSNET_29 DFFRPQX0P5H9R
Xu_mac16_top_u_mac_last_prod_reg_18_ u_mac16_top_u_mac_last_prod__18_ VDD VSS u_mac16_top_u_mac_net693 copt_net_93 HFSNET_29 DFFRPQX0P5H9R
Xu_mac16_top_u_mac_u_mul_r_s41_reg_15_ u_mac16_top_u_mac_u_mul_r_s41__15_ VDD VSS u_mac16_top_u_mac_u_mul_net771 u_mac16_top_u_mac_u_mul_st4_1_gen_csa_fa_15__u_fa_N0 HFSNET_31 optlc_net_104 optlc_net_104 SDFFRPQX0P5H9R
Xu_mac16_top_u_mac_u_mul_r_s41_reg_20_ u_mac16_top_u_mac_u_mul_r_s41__20_ VDD VSS u_mac16_top_u_mac_u_mul_net771 u_mac16_top_u_mac_u_mul_s41__20_ HFSNET_30 DFFRPQX0P5H9R
Xu_mac16_top_u_mac_u_mul_r_c40_reg_17_ u_mac16_top_u_mac_u_mul_r_c40__17_ VDD VSS u_mac16_top_u_mac_u_mul_net786 n2270 HFSNET_28 DFFRPQX0P5H9R
Xu_mac16_top_u_mac_u_mul_r_s22_reg_19_ u_mac16_top_u_mac_u_mul_r_s22__19_ VDD VSS u_mac16_top_u_mac_u_mul_net741 n765 HFSNET_2 DFFRPQX0P5H9R
Xu_mac16_top_u_mac_u_mul_r_s41_reg_19_ u_mac16_top_u_mac_u_mul_r_s41__19_ VDD VSS u_mac16_top_u_mac_u_mul_net771 u_mac16_top_u_mac_u_mul_s41__19_ HFSNET_4 DFFRPQX0P5H9R
Xu_mac16_top_opB_reg_reg_9_ u_mac16_top_net564 n782 u_mac16_top_opB_reg__9_ n1949 HFSNET_26 VDD VSS DFFRX1H9R
Xu_mac16_top_u_mac_u_mul_r_s20_reg_15_ n2242 VDD VSS u_mac16_top_u_mac_u_mul_net721 n734 HFSNET_1 DFFRPQNX0P5H9R
Xu_mac16_top_opB_reg_reg_1_ u_mac16_top_net564 n774 u_mac16_top_opB_reg__1_ n2120 n2368 VDD VSS DFFRX1H9R
Xu_mac16_top_mac_result_shadow_reg_2_ u_mac16_top_mac_result_shadow__2_ VDD VSS u_mac16_top_net622 u_mac16_top_N94 HFSNET_21 DFFRPQX0P5H9R
XctmTdsLR_1_176 tmp_net42 VDD VSS n1828 n1827 NOR2X0P5H9R
XctmTdsLR_2_177 n1832 VDD VSS n1830 n1831 u_mac16_top_u_mac_mult_result__23_ u_mac16_top_u_mac_last_prod__23_ tmp_net42 AOI221X0P5H9R
XU1057 n1252 VDD VSS u_mac16_top_u_mac_mult_result__19_ u_mac16_top_u_mac_last_prod__19_ NOR2X0P7H9R
Xcopt_h_inst_837 copt_net_63 VDD VSS u_mac16_top_u_inB_shift_reg__0_ DLY2X0P5H9R
XU1063 u_mac16_top_u_mac_u_mul_N55 VDD VSS n1214 n1215 XOR2X2H9R
XctmTdsLR_1_188 tmp_net46 VDD VSS u_mac16_top_u_mac_mult_result__0_ u_mac16_top_u_mac_accum_reg__0_ u_mac16_top_u_mac_mode_d n1799 OAI211X0P5H9R
XctmTdsLR_2_189 tmp_net47 VDD VSS u_mac16_top_u_mac_mult_result__0_ u_mac16_top_u_mac_last_prod__0_ n1838 n1797 OAI211X0P5H9R
XU1069 n1132 VDD VSS n930 n1125 XOR2X0P7H9R
XU1074 n902 VDD VSS n930 n1125 NOR2X1H9R
XU1078 n1131 VDD VSS n1127 n1126 NOR2X1P4H9R
XU1084 n1125 VDD VSS u_mac16_top_u_mac_u_mul_r_c40__12_ ZBUF_17_8 u_mac16_top_u_mac_u_mul_r_s40__12_ CGENCONAX1H9R
XU1122 n864 VDD VSS n847 n907 n1350 OAI21X1P4H9R
XU1125 n1597 VDD VSS n1622 n1616 NOR2X0P5H9R
XU1127 n1345 VDD VSS n1524 n909 n1343 AOI21X1H9R
XctmTdsLR_1_200 n1836 VDD VSS n1585 n1835 n1833 n1834 n1832 OAI221X0P5H9R
XctmTdsLR_1_201 u_mac16_top_u_mac_add_tmp_comb__11_ VDD VSS n1050 n1757 n1059 n1838 AO22X0P5H9R
Xcopt_h_inst_838 copt_net_64 VDD VSS u_mac16_top_u_inB_shift_reg__1_ DLY2X0P5H9R
XctmTdsLR_1_202 tmp_net48 VDD VSS n1875 n2107 NOR2X0P5H9R
XU1138 n1158 VDD VSS ZBUF_17_13 u_mac16_top_u_mac_u_mul_r_c40__15_ XOR2X2H9R
XctmTdsLR_1_178 n1491 VDD VSS n1168 n1167 OR2X1H9R
XU1141 n1267 VDD VSS n852 n1266 XNOR2X0P5H9R
XctmTdsLR_2_821 tmp_net59 VDD VSS n1176 INVX0P5H9R
XctmTdsLR_3_190 u_mac16_top_u_mac_add_tmp_comb__0_ VDD VSS tmp_net46 tmp_net47 NAND2X0P5H9R
XU1145 n876 VDD VSS n1179 n1178 NAND2X1P4H9R
XctmTdsLR_1_139 tmp_net34 VDD VSS ZBUF_35_10 u_mac16_top_u_mac_u_mul_r_c41__18_ XOR2X0P7H9R
XctmTdsLR_1_191 n1794 VDD VSS n1792 n1791 NAND2XBX0P7H9R
XctmTdsLR_1_192 u_mac16_top_u_mac_add_tmp_comb__15_ VDD VSS n1026 n1757 n1038 n1838 AO22X0P5H9R
XU1168 n1749 VDD VSS u_mac16_top_u_mac_mult_result__4_ u_mac16_top_u_mac_last_prod__4_ NAND2X0P7H9R
XU1169 n2210 n968 VDD VSS n2204 n2203 n2202 ADDFX1H9R
XU1170 n1640 VDD VSS n980 n1654 n979 AOI21X0P5H9R
XU1180 n1091 VDD VSS n2190 u_mac16_top_mac_result__17_ n2146 u_mac16_top_result_fifo_0__17_ AOI22X0P5H9R
XctmTdsLR_1_59 n950 VDD VSS n1300 n1585 n1301 AOI2XB1X0P5H9R
XU1183 n1605 VDD VSS n1633 n1647 n1634 OAI21X0P5H9R
XU1184 n1633 VDD VSS u_mac16_top_u_mac_mult_result__13_ u_mac16_top_u_mac_accum_reg__13_ NOR2X0P5H9R
XU1186 n1013 VDD VSS n997 n1705 n996 OAI21X0P7H9R
XU1187 n1705 VDD VSS n1767 n993 n992 AOI21X0P7H9R
XU1191 n1215 VDD VSS n2376 n1525 n1532 n933 AOI31X1H9R
XU1192 n993 VDD VSS n1768 n1780 NOR2X0P5H9R
XctmTdsLR_1_60 tmp_net5 VDD VSS n1293 n1297 NAND2X0P5H9R
XctmTdsLR_2_203 u_mac16_top_u_mac_u_mul_st2_3_gen_csa_fa_23__u_fa_N0 VDD VSS n1457 tmp_net48 n1455 MUXIT2X0P5H9R
XU1197 n1683 VDD VSS n1027 INVX1H9R
XU1199 u_mac16_top_u_mac_add_tmp_comb__10_ VDD VSS n1669 u_mac16_top_u_mac_mode_d n1670 n1838 AO22X0P5H9R
XU1200 u_mac16_top_u_mac_add_tmp_comb__9_ VDD VSS n1682 n1838 n1681 n1757 AO22X0P5H9R
XctmTdsLR_1_204 n1525 VDD VSS n1530 n1174 NOR2XBX2H9R
XU1204 n1596 VDD VSS n1622 n1642 n1623 OAI21X0P5H9R
XU1205 n1622 VDD VSS u_mac16_top_u_mac_mult_result__13_ u_mac16_top_u_mac_last_prod__13_ NOR2X0P5H9R
XU1208 n1001 VDD VSS n1609 n1021 NOR2X0P5H9R
XU1209 n2198 VDD VSS u_mac16_top_u_inB_cnt__0_ u_mac16_top_u_inB_cnt__1_ u_mac16_top_u_inB_cnt__3_ u_mac16_top_u_inB_cnt__2_ NAND4X0P5H9R
XU1210 n2200 VDD VSS u_mac16_top_u_inA_cnt__0_ u_mac16_top_u_inA_cnt__1_ u_mac16_top_u_inA_cnt__3_ u_mac16_top_u_inA_cnt__2_ NAND4X0P5H9R
XctmTdsLR_1_142 n1194 VDD VSS u_mac16_top_u_mac_u_mul_r_s40__22_ u_mac16_top_u_mac_u_mul_r_s41__22_ u_mac16_top_u_mac_u_mul_r_c40__22_ XOR3X0P5H9R
XU1212 n859 VDD VSS n847 n908 n1345 OAI21X1P4H9R
XU1213 n1565 VDD VSS n1825 n1326 NOR2X0P5H9R
XU1214 n1825 VDD VSS n1300 n988 NAND2X0P5H9R
XU1215 n2363 VDD VSS n1495 n1496 OR2X0P7H9R
Xcopt_h_inst_839 copt_net_65 VDD VSS u_mac16_top_u_inB_shift_reg__2_ DLY2X0P5H9R
XU1229 n899 VDD VSS ZBUF_59_10 u_mac16_top_u_mac_u_mul_r_s40__9_ n1111 OAI21X2H9R
XU1231 n1108 VDD VSS u_mac16_top_u_mac_u_mul_r_s40__8_ u_mac16_top_u_mac_u_mul_r_c40__8_ NAND2X1P4H9R
XZBUF_190_inst_715 ZBUF_190_3 VDD VSS u_mac16_top_u_mac_u_mul_r_c41__15_ FREEICGX2H9R
XU1240 n1499 VDD VSS n2354 INVX0P5H9R
XU1242 n1579 VDD VSS n1574 n1576 NAND2X0P5H9R
XU1243 n1170 VDD VSS n1153 n1157 n854 CGENCONAX1H9R
XU1244 n1552 VDD VSS n1561 n889 n1560 OAI21X2H9R
XU1245 n1733 VDD VSS u_mac16_top_u_mac_mult_result__4_ u_mac16_top_u_mac_last_prod__4_ NOR2X0P5H9R
XU1246 n1279 VDD VSS u_mac16_top_u_mac_mult_result__17_ u_mac16_top_u_mac_accum_reg__17_ NOR2X0P7H9R
XU1248 n841 VDD VSS n843 n842 NAND2X1H9R
Xcopt_h_inst_840 copt_net_66 VDD VSS u_mac16_top_u_inB_shift_reg__3_ DLY2X0P5H9R
XctmTdsLR_1_62 tmp_net6 VDD VSS n1585 INVX0P5H9R
XU1254 n1150 VDD VSS n935 u_mac16_top_u_mac_u_mul_r_s41__17_ XNOR2X0P5H9R
XU1255 n1616 VDD VSS u_mac16_top_u_mac_mult_result__12_ u_mac16_top_u_mac_last_prod__12_ NOR2X0P7H9R
XU1256 n1791 VDD VSS u_mac16_top_u_mac_mult_result__1_ u_mac16_top_u_mac_accum_reg__1_ NOR2X0P7H9R
XctmTdsLR_2_63 tmp_net7 VDD VSS n1825 INVX0P5H9R
XU1262 n1657 VDD VSS u_mac16_top_u_mac_last_prod__10_ u_mac16_top_u_mac_mult_result__10_ NAND2X0P7H9R
XU1263 n1642 VDD VSS u_mac16_top_u_mac_mult_result__12_ u_mac16_top_u_mac_last_prod__12_ NAND2X0P7H9R
XU1265 n1842 VDD VSS n1516 n926 NAND2X0P7H9R
XU1271 n1276 VDD VSS n952 n1275 XOR2X0P5H9R
XctmTdsLR_3_112 u_mac16_top_u_mac_u_mul_N47 VDD VSS tmp_net25 tmp_net26 XNOR2X0P5H9R
XU1273 n1507 VDD VSS u_mac16_top_fifo_count__0_ u_mac16_top_fifo_count__1_ OR2X0P7H9R
XU1275 n1217 VDD VSS n2120 n2000 NOR2X0P5H9R
XU1276 n1222 VDD VSS n2118 n2000 NOR2X0P5H9R
XU1277 n1223 VDD VSS n2120 n2001 NOR2X0P5H9R
XU1278 n1992 VDD VSS n2060 n2000 NOR2X0P5H9R
XU1279 n1997 VDD VSS n2207 n2097 NOR2X0P5H9R
XU1280 n1999 VDD VSS n2206 n2117 NOR2X0P5H9R
XU1281 n2005 VDD VSS n2207 n2107 NOR2X0P5H9R
XU1282 n1902 VDD VSS n1883 n2117 NOR2X0P5H9R
XU1283 n1911 VDD VSS n1883 n2119 NOR2X0P5H9R
XU1285 n1805 VDD VSS n2200 in_ready AND2X0P5H9R
XU1286 n1801 VDD VSS n2198 in_ready AND2X0P5H9R
Xcopt_h_inst_841 copt_net_67 VDD VSS u_mac16_top_u_inB_shift_reg__4_ DLY2X0P5H9R
XctmTdsLR_1_113 tmp_net27 VDD VSS n1499 n1497 n2363 OAI21X0P5H9R
XU1289 u_mac16_top_N93 VDD VSS n2144 n2154 n2153 n2152 OAI211X0P5H9R
XU1290 n2153 VDD VSS n2184 u_mac16_top_mac_result__1_ n2146 u_mac16_top_result_fifo_0__1_ AOI22X0P5H9R
XU1291 u_mac16_top_N96 VDD VSS n2144 n2163 n2162 n2161 OAI211X0P5H9R
XU1292 n2162 VDD VSS n2184 u_mac16_top_mac_result__4_ n2146 u_mac16_top_result_fifo_0__4_ AOI22X0P5H9R
XU1294 n2165 VDD VSS n2184 u_mac16_top_mac_result__5_ n2146 u_mac16_top_result_fifo_0__5_ AOI22X0P5H9R
XU1295 u_mac16_top_N99 VDD VSS n2144 n2172 n2171 n2170 OAI211X0P5H9R
XU1296 n2171 VDD VSS n2184 u_mac16_top_mac_result__7_ n2146 u_mac16_top_result_fifo_0__7_ AOI22X0P5H9R
XU1298 n2174 VDD VSS n2184 u_mac16_top_mac_result__8_ n2146 u_mac16_top_result_fifo_0__8_ AOI22X0P5H9R
XU1299 u_mac16_top_N102 VDD VSS n2144 n2182 n2181 n2180 OAI211X0P5H9R
XU1300 n2181 VDD VSS n2184 u_mac16_top_mac_result__10_ n2146 u_mac16_top_result_fifo_0__10_ AOI22X0P5H9R
XU1301 n1080 VDD VSS n2190 u_mac16_top_mac_result__13_ n2146 u_mac16_top_result_fifo_0__13_ AOI22X0P5H9R
XU1303 n1082 VDD VSS n2190 u_mac16_top_mac_result__14_ n2146 u_mac16_top_result_fifo_0__14_ AOI22X0P5H9R
XU1304 n1088 VDD VSS n2190 u_mac16_top_mac_result__16_ n2146 u_mac16_top_result_fifo_0__16_ AOI22X0P5H9R
XU1305 u_mac16_top_N113 VDD VSS n2144 n1104 n1103 n1102 OAI211X0P5H9R
XU1306 u_mac16_top_N114 VDD VSS n2144 n1107 n1106 n1105 OAI211X0P5H9R
XctmTdsLR_3_64 tmp_net8 VDD VSS n1834 n1321 n1323 OAI21X0P5H9R
XctmTdsLR_2_114 u_mac16_top_u_mac_u_mul_N45 VDD VSS tmp_net27 n1548 XNOR2X0P5H9R
XU1310 n1218 VDD VSS n2122 n2001 NOR2X0P5H9R
XU1311 n1998 VDD VSS n2045 n2107 NOR2X0P5H9R
XU1312 n1771 VDD VSS u_mac16_top_u_mac_mult_result__3_ u_mac16_top_u_mac_accum_reg__3_ n1769 OAI21X0P5H9R
XU1313 n1787 VDD VSS u_mac16_top_u_mac_mult_result__1_ u_mac16_top_u_mac_last_prod__1_ NOR2X0P5H9R
XU1314 n1304 VDD VSS u_mac16_top_u_mac_mult_result__18_ u_mac16_top_u_mac_last_prod__18_ NAND2X0P5H9R
XU1315 n1288 VDD VSS u_mac16_top_u_mac_mult_result__17_ u_mac16_top_u_mac_last_prod__17_ n1286 OAI21X0P5H9R
XctmTdsLR_1_115 tmp_net28 VDD VSS n1349 n1142 NAND2XBX0P7H9R
XctmTdsLR_2_116 ZBUF_2_10 VDD VSS n864 tmp_net28 XNOR2X1P4H9R
XU1318 n1892 VDD VSS n1947 n2000 NOR2X0P5H9R
XU1319 n1903 VDD VSS n2107 n1882 NOR2X0P5H9R
XU1320 n1745 VDD VSS n1743 n1742 NAND2XBX0P5H9R
XU1321 n1762 VDD VSS u_mac16_top_u_mac_mult_result__3_ u_mac16_top_u_mac_last_prod__3_ NOR2X0P5H9R
XU1322 n1031 VDD VSS n1597 n1600 NOR2BX0P5H9R
XctmTdsLR_2_823 n1877 VDD VSS n1873 n1872 n1871 CGENCONAX1H9R
XU1324 n1263 VDD VSS u_mac16_top_u_mac_mult_result__20_ u_mac16_top_u_mac_accum_reg__20_ n1262 n1261 AOI22X0P5H9R
XU1325 n2104 VDD VSS n2122 n2117 NOR2X0P5H9R
XU1326 n2048 VDD VSS n2045 n2062 NOR2X0P5H9R
XU1327 n1901 VDD VSS n1947 n2001 NOR2X0P5H9R
XU1328 n1729 VDD VSS u_mac16_top_u_mac_mult_result__6_ u_mac16_top_u_mac_accum_reg__6_ n1727 OAI21X0P5H9R
XU1329 n1018 VDD VSS n1633 n1609 n1627 NOR3X0P5H9R
XU1330 n1034 VDD VSS u_mac16_top_u_mac_mult_result__15_ u_mac16_top_u_mac_last_prod__15_ NOR2X0P5H9R
XU1331 n1788 VDD VSS u_mac16_top_u_mac_mult_result__1_ u_mac16_top_u_mac_last_prod__1_ NAND2X0P5H9R
XU1332 n1058 VDD VSS u_mac16_top_u_mac_mult_result__11_ u_mac16_top_u_mac_last_prod__11_ n1056 OAI21X0P5H9R
XctmTdsLR_1_117 tmp_net29 VDD VSS n1346 n1347 NAND2X0P5H9R
XU1334 n1578 VDD VSS u_mac16_top_u_mac_mult_result__22_ u_mac16_top_u_mac_accum_reg__22_ n1577 CGENCONAX1H9R
XU1335 n2083 VDD VSS n2205 n2120 NOR2X0P5H9R
XU1337 n2007 VDD VSS n2206 n2119 NOR2X0P5H9R
XU1339 n1917 VDD VSS n1947 n2107 NOR2X0P5H9R
XU1341 n1962 VDD VSS n2044 n1883 NOR2X0P5H9R
XctmTdsLR_1_143 n1152 VDD VSS ZBUF_54_10 u_mac16_top_u_mac_u_mul_r_s40__16_ u_mac16_top_u_mac_u_mul_r_c40__16_ CGENCONAX1H9R
XU1343 n1713 VDD VSS n1710 n1711 NAND2BX0P5H9R
Xcopt_h_inst_842 copt_net_68 VDD VSS u_mac16_top_u_inB_shift_reg__10_ DLY2X0P5H9R
XZBUF_101_inst_720 ZBUF_101_7 VDD VSS u_mac16_top_u_mac_u_mul_r_s41__15_ BUFX1P4H9R
XctmTdsLR_2_118 u_mac16_top_u_mac_u_mul_N54 VDD VSS n859 tmp_net29 XNOR2X1P4H9R
XU1351 n1739 VDD VSS u_mac16_top_u_mac_mult_result__4_ u_mac16_top_u_mac_last_prod__4_ n1752 n1750 AOI22X0P5H9R
XU1352 n1255 VDD VSS n1252 n1253 NAND2BX0P5H9R
XU1355 n1216 VDD VSS n2118 n1984 NOR2X0P5H9R
XU1357 n1904 VDD VSS n1881 n2097 NOR2X0P5H9R
XU1358 n1063 VDD VSS n1948 n2059 NOR2X0P5H9R
XU1359 n1413 VDD VSS n806 u_mac16_top_op_fifo_rd_ptr__1_ NOR2X1H9R
XctmTdsLR_1_144 tmp_net35 VDD VSS n1585 n1586 n1587 OAI21X0P5H9R
XU1361 n1612 VDD VSS u_mac16_top_u_mac_mult_result__14_ u_mac16_top_u_mac_accum_reg__14_ n1610 OAI21X0P5H9R
XU1362 n1176 VDD VSS u_mac16_top_u_mac_u_mul_r_c41__18_ n2365 n1139 CGENCONAX1H9R
XU1363 n842 VDD VSS u_mac16_top_u_mac_u_mul_r_c40__14_ u_mac16_top_u_mac_u_mul_r_s41__14_ u_mac16_top_u_mac_u_mul_r_s40__14_ CGENX1P4H9R
XU1364 n1045 VDD VSS u_mac16_top_u_mac_mult_result__11_ u_mac16_top_u_mac_accum_reg__11_ NOR2X0P5H9R
XU1365 n840 VDD VSS u_mac16_top_u_mac_u_mul_r_s40__8_ u_mac16_top_u_mac_u_mul_r_c40__8_ XOR2X1H9R
XU1366 n1030 VDD VSS n1600 n1596 n1601 OAI2XB1X0P5H9R
XU1367 n1282 VDD VSS u_mac16_top_u_mac_mult_result__17_ u_mac16_top_u_mac_accum_reg__17_ n1280 OAI21X0P5H9R
XU1368 n1886 VDD VSS n1881 n2000 NOR2X0P5H9R
XU1370 n1672 VDD VSS u_mac16_top_u_mac_mult_result__9_ u_mac16_top_u_mac_last_prod__9_ NAND2X0P5H9R
XctmTdsLR_4_65 n952 VDD VSS tmp_net6 tmp_net7 n1270 tmp_net8 AOI31X0P5H9R
XU1373 n2359 VDD VSS n1819 INVX0P5H9R
XU1374 n1704 VDD VSS n1752 n1718 n2360 n1698 AOI31X0P5H9R
XU1375 n2360 VDD VSS n1719 INVX0P5H9R
XU1376 n1246 VDD VSS u_mac16_top_u_mac_accum_reg__19_ u_mac16_top_u_mac_mult_result__19_ n1244 OAI21X0P5H9R
XU1377 n1993 VDD VSS n2058 n1984 NOR2X0P5H9R
XU1378 n2006 VDD VSS n2045 n2117 NOR2X0P5H9R
XU1379 n1064 VDD VSS n1947 n2062 NOR2X0P5H9R
XU1380 n2201 VDD VSS n1807 n1808 NOR2X0P5H9R
XU1381 n2199 VDD VSS n1803 n1804 NOR2X0P5H9R
XctmTdsLR_2_145 n1290 VDD VSS tmp_net35 n1288 XNOR2X0P5H9R
XU1383 u_mac16_top_u_mac_u_mul_s41__23_ VDD VSS u_mac16_top_u_mac_u_mul_r_c31__23_ u_mac16_top_u_mac_u_mul_r_c23__23_ u_mac16_top_u_mac_u_mul_r_s23__23_ XOR3X0P5H9R
XU1384 n2046 n1875 n1877 u_mac16_top_u_mac_u_mul_st2_3_gen_csa_fa_15__u_fa_N1 u_mac16_top_u_mac_u_mul_st2_3_gen_csa_fa_15__u_fa_N0 VDD VSS OAOI211X2H9R
XU1385 u_mac16_top_u_mac_u_mul_r_s22__9_ u_mac16_top_u_mac_u_mul_r_c21__9_ u_mac16_top_u_mac_u_mul_st3_1_gen_csa_fa_9__u_fa_N1 u_mac16_top_u_mac_u_mul_st3_1_gen_csa_fa_9__u_fa_N0 VDD VSS AOI2BB1X0P5H9R
XU1386 u_mac16_top_u_mac_u_mul_r_s22__11_ u_mac16_top_u_mac_u_mul_r_c21__11_ u_mac16_top_u_mac_u_mul_st3_1_gen_csa_fa_11__u_fa_N1 u_mac16_top_u_mac_u_mul_st3_1_gen_csa_fa_11__u_fa_N0 VDD VSS AOI2BB1X0P5H9R
XU1387 n1593 VDD VSS n1590 n1591 NAND2BX0P5H9R
Xcopt_h_inst_843 copt_net_69 VDD VSS u_mac16_top_u_inA_shift_reg__14_ DLY2X0P5H9R
XU1389 n1020 VDD VSS n1628 n1018 NAND2X0P5H9R
XU1390 n1775 VDD VSS u_mac16_top_u_mac_mult_result__2_ u_mac16_top_u_mac_last_prod__2_ NOR2X0P5H9R
XU1391 n1250 VDD VSS u_mac16_top_u_mac_mult_result__18_ u_mac16_top_u_mac_last_prod__18_ n1305 n1301 AOI22X0P5H9R
XZBUF_69_inst_722 ZBUF_69_7 VDD VSS u_mac16_top_u_mac_u_mul_r_c40__10_ FREEICGX2H9R
XU1394 n2380 VDD VSS n889 n1561 n1560 OAI21X0P5H9R
Xcopt_h_inst_844 copt_net_70 VDD VSS u_mac16_top_u_inB_shift_reg__14_ DLY2X0P5H9R
XZBUF_9_inst_724 ZBUF_9_8 VDD VSS n847 BUFX1H9R
Xcopt_h_inst_845 copt_net_71 VDD VSS u_mac16_top_u_inA_shift_reg__4_ FREEICGX0P5H9R
XZBUF_17_inst_727 ZBUF_17_8 VDD VSS u_mac16_top_u_mac_u_mul_r_s41__12_ BUFX2H9R
XU1399 n1636 VDD VSS u_mac16_top_u_mac_mult_result__13_ u_mac16_top_u_mac_accum_reg__13_ n1634 OAI21X0P5H9R
XU1400 n1746 VDD VSS u_mac16_top_u_mac_mult_result__4_ u_mac16_top_u_mac_accum_reg__4_ n1756 n1754 AOI22X0P5H9R
XU1401 n1722 VDD VSS u_mac16_top_u_mac_mult_result__6_ u_mac16_top_u_mac_last_prod__6_ n1720 OAI21X0P5H9R
XU1402 n1703 VDD VSS n1700 n1701 NAND2BX0P5H9R
XU1403 n1603 VDD VSS u_mac16_top_u_mac_mult_result__14_ u_mac16_top_u_mac_last_prod__14_ n1601 OAI21X0P5H9R
Xcopt_h_inst_846 copt_net_72 VDD VSS u_mac16_top_u_inA_shift_reg__2_ FREEICGX0P5H9R
XU1405 n1983 VDD VSS n2206 n2097 NOR2X0P5H9R
XU1406 n2206 VDD VSS u_mac16_top_opB_reg__8_ INVX0P5H9R
XU1407 n1912 VDD VSS n1882 n2117 NOR2X0P5H9R
XU1409 n1957 VDD VSS n1948 n2121 NOR2X0P5H9R
XU1410 n1808 VDD VSS u_mac16_top_u_inA_cnt__0_ u_mac16_top_u_inA_cnt__1_ NAND2X0P5H9R
XU1412 n1804 VDD VSS u_mac16_top_u_inB_cnt__0_ u_mac16_top_u_inB_cnt__1_ NAND2X0P5H9R
XU1416 n1529 VDD VSS n1532 n1525 n1524 AOI21X1H9R
XU1419 n1103 VDD VSS n2146 u_mac16_top_result_fifo_0__21_ n2190 u_mac16_top_mac_result__21_ AOI22X0P5H9R
XU1420 u_mac16_top_u_out_N16 VDD VSS n2361 n1841 n2362 n1842 OAI22X0P5H9R
XU1421 n2361 VDD VSS u_mac16_top_mac_result_shadow__23_ INVX0P5H9R
XU1422 n2362 VDD VSS u_mac16_top_u_out_shift_reg__23_ INVX0P5H9R
XU1423 n1875 n2044 n1870 u_mac16_top_u_mac_u_mul_st2_3_gen_csa_fa_16__u_fa_N1 u_mac16_top_u_mac_u_mul_st2_3_gen_csa_fa_16__u_fa_N0 VDD VSS OAOI211X0P5H9R
XU1424 n2044 VDD VSS u_mac16_top_opA_reg__1_ INVX1H9R
XU1425 u_mac16_top_u_mac_u_mul_r_c20__3_ u_mac16_top_u_mac_u_mul_r_s20__3_ u_mac16_top_u_mac_u_mul_st3_0_gen_csa_fa_3__u_fa_N1 u_mac16_top_u_mac_u_mul_st3_0_gen_csa_fa_3__u_fa_N0 VDD VSS AOI2BB1X0P5H9R
XU1426 u_mac16_top_u_mac_u_mul_r_s31__22_ u_mac16_top_u_mac_u_mul_r_s30__22_ u_mac16_top_u_mac_u_mul_st4_0_gen_csa_fa_22__u_fa_N2 u_mac16_top_u_mac_u_mul_s40__22_ VDD VSS AOI2BB1X0P5H9R
XU1427 u_mac16_top_u_mac_u_mul_s31__23_ VDD VSS u_mac16_top_u_mac_u_mul_r_c21__23_ u_mac16_top_u_mac_u_mul_r_c22__23_ u_mac16_top_u_mac_u_mul_r_s22__23_ XOR3X0P5H9R
XZBUF_17_inst_729 ZBUF_17_9 VDD VSS u_mac16_top_u_mac_u_mul_r_s41__13_ BUFX1P4H9R
XU1429 n2143 VDD VSS n2205 n2061 NOR2X0P5H9R
XU1430 n2205 VDD VSS u_mac16_top_opA_reg__13_ INVX0P7H9R
XU1431 u_mac16_top_u_mac_u_mul_pp_9__9_ VDD VSS n2046 n1949 NOR2X0P5H9R
XU1432 n2046 VDD VSS u_mac16_top_opA_reg__0_ INVX1H9R
XZBUF_59_inst_732 ZBUF_59_10 VDD VSS u_mac16_top_u_mac_u_mul_r_c40__9_ BUFX1P7H9R
XU1435 n1054 VDD VSS n1653 n1658 NAND2X0P5H9R
XZBUF_35_inst_733 ZBUF_35_10 VDD VSS u_mac16_top_u_mac_u_mul_r_s40__18_ BUFX1P4H9R
XZBUF_54_inst_734 ZBUF_54_10 VDD VSS u_mac16_top_u_mac_u_mul_r_s41__16_ FREEICGX2H9R
XU1441 n1037 VDD VSS u_mac16_top_u_mac_mult_result__15_ u_mac16_top_u_mac_last_prod__15_ n1035 OAI21X0P5H9R
XU1442 n1048 VDD VSS u_mac16_top_u_mac_mult_result__11_ u_mac16_top_u_mac_accum_reg__11_ n1046 OAI21X0P5H9R
XU1444 n1679 VDD VSS u_mac16_top_u_mac_mult_result__9_ u_mac16_top_u_mac_accum_reg__9_ n1677 OAI21X0P5H9R
XU1445 n1361 VDD VSS u_mac16_top_mode_reg u_mac16_top_mode_reg_d1 XOR2X0P5H9R
Xcopt_h_inst_847 copt_net_73 VDD VSS u_mac16_top_u_inB_shift_reg__5_ FREEICGX0P5H9R
XU1447 n1650 VDD VSS n1692 n1646 n1015 OAI21X0P5H9R
XU1448 n1692 VDD VSS n1013 INVX1H9R
XU1449 n1790 VDD VSS u_mac16_top_u_mac_mult_result__1_ u_mac16_top_u_mac_last_prod__1_ n1788 OAI21X0P5H9R
XU1450 n1778 VDD VSS u_mac16_top_u_mac_mult_result__2_ u_mac16_top_u_mac_last_prod__2_ n1776 OAI21X0P5H9R
XU1451 n1765 VDD VSS u_mac16_top_u_mac_mult_result__3_ u_mac16_top_u_mac_last_prod__3_ n1763 OAI21X0P5H9R
XU1453 n1738 VDD VSS n1735 n1736 NAND2BX0P5H9R
XU1455 n1714 VDD VSS n1756 n1725 n2364 n1708 AOI31X0P5H9R
XU1456 n2364 VDD VSS n1726 INVX0P5H9R
XU1457 n1589 VDD VSS u_mac16_top_u_mac_mult_result__16_ u_mac16_top_u_mac_last_prod__16_ n1587 OAI21X0P5H9R
XU1459 n1266 VDD VSS u_mac16_top_u_mac_mult_result__21_ u_mac16_top_u_mac_accum_reg__21_ n1311 OAI21X0P5H9R
XU1460 n1991 VDD VSS n2061 n2001 NOR2X0P5H9R
XU1461 n1958 VDD VSS n1947 n2057 NOR2X0P5H9R
XU1462 n1947 VDD VSS u_mac16_top_opB_reg__11_ INVX0P5H9R
XZBUF_2_inst_797 ZBUF_2_9 VDD VSS u_mac16_top_u_mac_u_mul_N50 BUFX1P7H9R
XU1464 u_mac16_top_u_mac_u_mul_N40 VDD VSS n1485 n1486 n1561 OA21X0P5H9R
XZBUF_50_inst_806 ZBUF_50_13 VDD VSS u_mac16_top_u_mac_u_mul_r_s40__7_ BUFX1P7H9R
XU1466 n1106 VDD VSS n2146 u_mac16_top_result_fifo_0__22_ n2190 u_mac16_top_mac_result__22_ AOI22X0P5H9R
XU1467 u_mac16_top_u_mac_u_mul_r_c20__4_ u_mac16_top_u_mac_u_mul_r_s20__4_ u_mac16_top_u_mac_u_mul_st3_0_gen_csa_fa_4__u_fa_N1 u_mac16_top_u_mac_u_mul_st3_0_gen_csa_fa_4__u_fa_N0 VDD VSS AOI2BB1X0P5H9R
XU1469 u_mac16_top_u_mac_u_mul_r_s21__19_ u_mac16_top_u_mac_u_mul_r_s20__19_ u_mac16_top_u_mac_u_mul_st3_0_gen_csa_fa_19__u_fa_N2 u_mac16_top_u_mac_u_mul_s30__19_ VDD VSS AOI2BB1X0P5H9R
XU1470 u_mac16_top_u_mac_u_mul_r_s21__20_ u_mac16_top_u_mac_u_mul_r_s20__20_ u_mac16_top_u_mac_u_mul_st3_0_gen_csa_fa_20__u_fa_N2 u_mac16_top_u_mac_u_mul_s30__20_ VDD VSS AOI2BB1X0P5H9R
XU1471 u_mac16_top_u_mac_u_mul_s40__23_ VDD VSS u_mac16_top_u_mac_u_mul_r_s31__23_ u_mac16_top_u_mac_u_mul_r_s30__23_ XOR2X0P5H9R
XU1472 u_mac16_top_u_mac_u_mul_r_s22__10_ u_mac16_top_u_mac_u_mul_r_c21__10_ u_mac16_top_u_mac_u_mul_st3_1_gen_csa_fa_10__u_fa_N1 u_mac16_top_u_mac_u_mul_st3_1_gen_csa_fa_10__u_fa_N0 VDD VSS AOI2BB1X0P5H9R
XU1473 n1581 VDD VSS u_mac16_top_u_mac_mult_result__23_ u_mac16_top_u_mac_accum_reg__23_ n1812 OAI21X0P5H9R
XctmTdsLR_1_824 n1905 VDD VSS n1902 n1903 n1904 XOR3X0P5H9R
XU1478 n1513 VDD VSS u_mac16_top_u_out_bits_left__1_ u_mac16_top_u_out_bits_left__0_ u_mac16_top_u_out_bits_left__2_ u_mac16_top_u_out_bits_left__3_ OAI31X0P5H9R
XU1480 n2069 VDD VSS n2208 n2122 n2072 NOR3X0P5H9R
XU1481 n2240 n2239 u_mac16_top_u_mac_u_mul_st2_0_gen_csa_fa_2__u_fa_N1 n746 VDD VSS AOI2BB1X0P5H9R
XU1482 n2226 n2225 u_mac16_top_u_mac_u_mul_st2_1_gen_csa_fa_22__u_fa_N4 n759 VDD VSS AOI2BB1X0P5H9R
XU1484 n2234 n2233 u_mac16_top_u_mac_u_mul_st2_1_gen_csa_fa_7__u_fa_N1 n758 VDD VSS AOI2BB1X0P5H9R
XU1485 n2053 n1462 u_mac16_top_u_mac_u_mul_st2_1_gen_csa_fa_6__u_fa_N1 u_mac16_top_u_mac_u_mul_st2_1_gen_csa_fa_6__u_fa_N0 VDD VSS AOI2BB1X0P5H9R
XU1486 n2218 n2217 u_mac16_top_u_mac_u_mul_st2_2_gen_csa_fa_11__u_fa_N1 n772 VDD VSS AOI2BB1X0P5H9R
XU1489 n969 VDD VSS u_mac16_top_opA_reg__0_ u_mac16_top_opB_reg__13_ u_mac16_top_opA_reg__1_ u_mac16_top_opB_reg__12_ AOI22X0P5H9R
XZBUF_17_inst_807 ZBUF_17_13 VDD VSS u_mac16_top_u_mac_u_mul_r_s40__15_ BUFX1P7H9R
XU1492 n2366 VDD VSS u_mac16_top_u_mac_u_mul_r_s41__19_ u_mac16_top_u_mac_u_mul_r_c40__19_ u_mac16_top_u_mac_u_mul_r_s40__19_ CGENX1H9R
XU1494 n983 VDD VSS n982 n1596 n981 AOI21X0P7H9R
XU1497 n1613 VDD VSS n1692 n1608 n1607 OAI21X0P5H9R
XU1498 n1350 VDD VSS n1524 n848 n1527 AOI21X1H9R
XU1500 n2367 VDD VSS n1361 n837 NOR2X1P4H9R
XU1502 n2368 VDD VSS n1361 n837 NOR2X0P5H9R
XZBUF_17_inst_808 ZBUF_17_14 VDD VSS u_mac16_top_u_mac_u_mul_r_s40__17_ BUFX1P4H9R
XU1505 n2139 n966 VDD VSS n2134 n2133 n2132 ADDFX1H9R
XU1506 n1164 VDD VSS n2381 n842 XOR2X0P7H9R
XU1507 n2369 VDD VSS n923 n1547 OR2X0P7H9R
XU1508 n1134 VDD VSS n1137 INVX0P5H9R
XctmTdsLR_1_67 tmp_net9 VDD VSS n1568 n1567 NAND2X0P5H9R
XU1511 n886 VDD VSS n1495 n883 NAND2X1H9R
XctmTdsLR_2_68 n1573 VDD VSS n1585 n1570 n1827 tmp_net9 OAI211X1H9R
XctmTdsLR_1_69 tmp_net10 VDD VSS n1027 n1686 n1685 AOI21BX0P5H9R
XU1514 n1484 VDD VSS n1490 n1489 NAND2X0P5H9R
XctmTdsLR_2_70 n1674 VDD VSS n1671 n1672 NAND2BX0P7H9R
Xcopt_h_inst_848 copt_net_74 VDD VSS u_mac16_top_u_inA_shift_reg__0_ FREEICGX0P5H9R
XU1520 n965 n1341 VDD VSS n1335 n1334 n1333 ADDFX1H9R
XctmTdsLR_1_810 n2144 VDD VSS u_mac16_top_fifo_rd_ptr__1_ u_mac16_top_fifo_rd_ptr__0_ n1517 NAND3XXBX1H9R
XU1523 n1797 VDD VSS u_mac16_top_u_mac_mult_result__0_ u_mac16_top_u_mac_last_prod__0_ NAND2X0P7H9R
XU1525 n907 VDD VSS n1525 n848 NAND2X0P7H9R
XU1526 n909 VDD VSS n1342 INVX0P7H9R
XctmTdsLR_1_811 n1175 VDD VSS tmp_net57 n1137 XOR2X1H9R
XU1530 n1005 VDD VSS n1646 n1003 NOR2X0P5H9R
XU1531 n1002 VDD VSS n1001 n1605 n1000 AOI21X0P5H9R
XU1532 n1154 VDD VSS u_mac16_top_u_mac_u_mul_r_c40__15_ ZBUF_190_3 NOR2X1H9R
XU1533 n879 VDD VSS n1168 n1167 NAND2X1P4H9R
XctmTdsLR_2_825 n1852 VDD VSS n1903 n1904 n1902 CGENCONAX1H9R
XU1536 n1356 VDD VSS n1489 n1169 n879 OAI21X2H9R
XU1547 n1533 VDD VSS n869 n1170 NAND2X0P7H9R
XU1549 n1352 VDD VSS n1171 n1172 NOR2X2H9R
XctmTdsLR_1_826 n1923 VDD VSS n1922 n1921 n1920 XOR3X0P5H9R
XU1553 n1492 VDD VSS n1491 n879 NAND2X0P5H9R
XU1554 n1214 VDD VSS n1213 n1212 NAND2X0P5H9R
XU1555 n2376 VDD VSS n1344 n1347 AND2X0P5H9R
XU1556 n1344 VDD VSS n1526 n1142 NOR2X1H9R
XU1557 n1347 VDD VSS n1186 n1187 NAND2X1P4H9R
XctmTdsLR_2_827 n1858 VDD VSS n1922 n1920 n1921 CGENCONAX1H9R
XctmTdsLR_3_71 n1682 VDD VSS tmp_net10 n1674 XOR2X0P5H9R
XU1570 n1583 VDD VSS n1582 n1581 XNOR2X0P5H9R
XctmTdsLR_1_828 n1941 VDD VSS n1939 n1938 n1940 XOR3X0P5H9R
XctmTdsLR_2_829 n1939 n1940 n1938 n1864 VDD VSS MAOI222X0P5H9R
XctmTdsLR_1_830 n1965 VDD VSS n1962 n1963 n1964 XOR3X0P5H9R
XctmTdsLR_2_831 n1870 VDD VSS n1964 n1963 n1962 CGENCONAX1H9R
Xcopt_h_inst_849 copt_net_75 VDD VSS u_mac16_top_u_inA_shift_reg__13_ DLY2X0P5H9R
XU1582 n1142 VDD VSS n876 INVX1H9R
XU1583 n1536 VDD VSS n1532 n1530 n2387 AOI2XB1X1P4H9R
Xcopt_h_inst_850 copt_net_76 VDD VSS u_mac16_top_u_inB_shift_reg__7_ DLY2X0P5H9R
XU1585 n1062 VDD VSS n1949 n2057 NOR2X0P5H9R
XU1589 n1899 VDD VSS n1949 n1984 NOR2X0P5H9R
XU1590 n1956 VDD VSS n1949 n2119 NOR2X0P5H9R
XU1591 n1890 VDD VSS n1949 n2205 NOR2X0P5H9R
XU1592 n1919 VDD VSS n1949 n2001 NOR2X0P5H9R
XU1593 n1203 VDD VSS n1949 n2059 NOR2X0P7H9R
Xcopt_h_inst_851 copt_net_77 VDD VSS u_mac16_top_u_inA_shift_reg__8_ DLY2X0P5H9R
XU1595 n980 VDD VSS n1055 n1051 NOR2X0P5H9R
XctmTdsLR_1_73 tmp_net11 VDD VSS n1619 n1643 NAND2X0P5H9R
Xcopt_h_inst_852 copt_net_78 VDD VSS u_mac16_top_u_inB_shift_reg__9_ DLY2X0P5H9R
XU1602 n1151 VDD VSS u_mac16_top_u_mac_u_mul_r_c41__17_ INVX0P5H9R
XctmTdsLR_2_74 n1626 VDD VSS n1683 n1621 n1642 tmp_net11 OAI211X0P5H9R
XU1606 n998 VDD VSS n1045 n1665 n1046 OAI21X0P5H9R
XU1607 n1299 VDD VSS n941 n1298 XOR2X0P5H9R
Xcopt_h_inst_853 copt_net_79 VDD VSS u_mac16_top_u_inA_shift_reg__11_ DLY2X0P5H9R
XU1609 n1342 VDD VSS n1344 INVX0P7H9R
Xcopt_h_inst_854 copt_net_80 VDD VSS u_mac16_top_u_inA_shift_reg__10_ DLY2X0P5H9R
XU1614 n1283 VDD VSS n1822 n1590 n1591 OAI21X0P5H9R
XU1615 n999 VDD VSS n1045 n1041 NOR2X0P5H9R
XU1616 n1041 VDD VSS u_mac16_top_u_mac_mult_result__10_ u_mac16_top_u_mac_accum_reg__10_ NOR2X0P7H9R
XU1617 n1009 VDD VSS n1822 n1811 n1820 OAI21X0P5H9R
XU1618 n1010 VDD VSS n1009 n1008 XNOR2X0P5H9R
Xcopt_h_inst_855 copt_net_81 VDD VSS u_mac16_top_u_inB_shift_reg__6_ FREEICGX0P5H9R
XU1622 n1133 VDD VSS u_mac16_top_u_mac_u_mul_r_s41__19_ n1136 XOR2X0P7H9R
XctmTdsLR_1_75 tmp_net12 VDD VSS n1630 n1648 NAND2X0P5H9R
XU1624 n1700 VDD VSS u_mac16_top_u_mac_last_prod__7_ u_mac16_top_u_mac_mult_result__7_ NOR2X0P5H9R
XU1626 n982 VDD VSS n1600 n1034 NOR2X0P5H9R
XU1629 n1574 VDD VSS n1811 n1315 NOR2X0P5H9R
XU1630 n1811 VDD VSS n1292 n1007 NAND2X0P5H9R
Xcopt_h_inst_856 copt_net_82 VDD VSS u_mac16_top_u_inB_shift_reg__11_ DLY2X0P5H9R
Xcopt_h_inst_857 copt_net_83 VDD VSS u_mac16_top_u_inA_shift_reg__5_ FREEICGX0P5H9R
Xcopt_h_inst_858 copt_net_84 VDD VSS u_mac16_top_u_inA_shift_reg__9_ FREEICGX0P5H9R
XU1634 n908 VDD VSS n909 n1525 NAND2X0P7H9R
Xcopt_h_inst_859 copt_net_85 VDD VSS u_mac16_top_u_inA_shift_reg__1_ FREEICGX0P5H9R
XU1637 n1136 VDD VSS u_mac16_top_u_mac_u_mul_r_s40__19_ u_mac16_top_u_mac_u_mul_r_c40__19_ XOR2X1H9R
XU1639 n1647 VDD VSS u_mac16_top_u_mac_mult_result__12_ u_mac16_top_u_mac_accum_reg__12_ NAND2X0P7H9R
Xcopt_h_inst_860 copt_net_86 VDD VSS u_mac16_top_u_inB_shift_reg__8_ FREEICGX0P5H9R
XU1647 n1496 VDD VSS n1128 n1129 XNOR2X0P7H9R
XU1653 n1355 VDD VSS n1170 n869 NOR2X2H9R
XU1655 n973 VDD VSS n1762 n1776 n1763 OAI21X0P7H9R
XU1657 n979 VDD VSS n1055 n1657 n1056 OAI21X0P5H9R
XU1659 n1321 VDD VSS u_mac16_top_u_mac_mult_result__20_ u_mac16_top_u_mac_last_prod__20_ NOR2X0P5H9R
XU1660 n1823 VDD VSS u_mac16_top_u_mac_mult_result__22_ u_mac16_top_u_mac_last_prod__22_ NOR2X0P5H9R
XU1661 n1280 VDD VSS u_mac16_top_u_mac_mult_result__17_ u_mac16_top_u_mac_accum_reg__17_ NAND2X0P5H9R
XU1662 n1122 VDD VSS n1117 ZBUF_69_7 XOR2X0P7H9R
XU1663 n1623 VDD VSS u_mac16_top_u_mac_mult_result__13_ u_mac16_top_u_mac_last_prod__13_ NAND2X0P5H9R
XU1665 n1643 VDD VSS n1616 INVX0P5H9R
XU1666 n2147 VDD VSS n1517 n1074 NOR2X1P4H9R
XU1667 n2148 VDD VSS n1517 n1075 NOR2X1P4H9R
XU1668 n1781 VDD VSS u_mac16_top_u_mac_mult_result__2_ u_mac16_top_u_mac_accum_reg__2_ NAND2X0P5H9R
XU1670 n1769 VDD VSS u_mac16_top_u_mac_mult_result__3_ u_mac16_top_u_mac_accum_reg__3_ NAND2X0P5H9R
XU1672 n1736 VDD VSS u_mac16_top_u_mac_mult_result__5_ u_mac16_top_u_mac_last_prod__5_ NAND2X0P5H9R
XU1674 n1701 VDD VSS u_mac16_top_u_mac_mult_result__7_ u_mac16_top_u_mac_last_prod__7_ NAND2X0P5H9R
XU1675 n1688 VDD VSS u_mac16_top_u_mac_mult_result__8_ u_mac16_top_u_mac_accum_reg__8_ NOR2X0P5H9R
XU1677 n1661 VDD VSS n1688 n1676 NOR2X0P5H9R
XU1679 n1046 VDD VSS u_mac16_top_u_mac_mult_result__11_ u_mac16_top_u_mac_accum_reg__11_ NAND2X0P5H9R
XU1684 n1601 VDD VSS u_mac16_top_u_mac_mult_result__14_ u_mac16_top_u_mac_last_prod__14_ NAND2X0P7H9R
XU1686 n1022 VDD VSS u_mac16_top_u_mac_mult_result__15_ u_mac16_top_u_mac_accum_reg__15_ NAND2X0P5H9R
XU1687 n1590 VDD VSS u_mac16_top_u_mac_mult_result__16_ u_mac16_top_u_mac_accum_reg__16_ NOR2X0P5H9R
XU1688 n1586 VDD VSS u_mac16_top_u_mac_mult_result__16_ u_mac16_top_u_mac_last_prod__16_ NOR2X0P5H9R
XU1689 n1292 VDD VSS n1590 n1279 NOR2X0P5H9R
XU1690 n1297 VDD VSS n1239 INVX0P5H9R
XU1691 n1300 VDD VSS n1586 n1285 NOR2X0P5H9R
XU1693 n1312 VDD VSS u_mac16_top_u_mac_mult_result__20_ u_mac16_top_u_mac_accum_reg__20_ NAND2X0P5H9R
XU1694 n1261 VDD VSS n1310 INVX0P5H9R
XU1696 n1324 VDD VSS u_mac16_top_u_mac_mult_result__21_ u_mac16_top_u_mac_last_prod__21_ NOR2X0P5H9R
XU1697 n1828 VDD VSS u_mac16_top_u_mac_mult_result__23_ u_mac16_top_u_mac_last_prod__23_ NOR2X0P5H9R
XU1698 n1812 VDD VSS u_mac16_top_u_mac_mult_result__23_ u_mac16_top_u_mac_accum_reg__23_ NAND2X0P5H9R
XU1699 n1827 VDD VSS u_mac16_top_u_mac_mult_result__22_ u_mac16_top_u_mac_last_prod__22_ NAND2X0P5H9R
XU1700 n1567 VDD VSS n1823 INVX0P5H9R
XU1701 n2122 VDD VSS u_mac16_top_opB_reg__2_ INVX0P5H9R
XU1702 n1974 VDD VSS u_mac16_top_opA_reg__14_ INVX0P7H9R
XU1703 n2060 VDD VSS u_mac16_top_opB_reg__4_ INVX0P5H9R
Xcopt_h_inst_861 copt_net_87 VDD VSS u_mac16_top_u_inA_shift_reg__3_ FREEICGX0P5H9R
XU1707 n2190 VDD VSS n2145 INVX0P5H9R
XctmTdsLR_2_76 n1637 VDD VSS n1692 n1632 n1647 tmp_net12 OAI211X0P5H9R
XU1709 n2057 VDD VSS u_mac16_top_opA_reg__4_ INVX1P4H9R
XU1710 n2059 VDD VSS u_mac16_top_opA_reg__3_ INVX1H9R
XU1711 n2062 VDD VSS u_mac16_top_opA_reg__2_ INVX1H9R
XU1712 n1752 VDD VSS n1695 INVX0P5H9R
XU1713 n1727 VDD VSS u_mac16_top_u_mac_mult_result__6_ u_mac16_top_u_mac_accum_reg__6_ NAND2X0P5H9R
XU1717 n1689 VDD VSS u_mac16_top_u_mac_mult_result__8_ u_mac16_top_u_mac_accum_reg__8_ NAND2X0P7H9R
XU1718 n1610 VDD VSS u_mac16_top_u_mac_mult_result__14_ u_mac16_top_u_mac_accum_reg__14_ NAND2X0P5H9R
Xcopt_h_inst_862 copt_net_88 VDD VSS u_mac16_top_u_inA_shift_reg__12_ FREEICGX0P5H9R
XU1720 n1757 VDD VSS n1838 INVX0P5H9R
XU1721 n2058 VDD VSS u_mac16_top_opB_reg__3_ INVX0P5H9R
XU1722 n2208 VDD VSS u_mac16_top_opA_reg__15_ INVX0P5H9R
XU1723 n2118 VDD VSS u_mac16_top_opB_reg__0_ INVX0P5H9R
XU1725 n1248 VDD VSS u_mac16_top_u_mac_mult_result__18_ u_mac16_top_u_mac_last_prod__18_ NOR2X0P5H9R
XU1726 n1286 VDD VSS u_mac16_top_u_mac_mult_result__17_ u_mac16_top_u_mac_last_prod__17_ NAND2X0P5H9R
Xcopt_h_inst_863 copt_net_89 VDD VSS u_mac16_top_u_inB_shift_reg__12_ FREEICGX0P5H9R
XU1728 n1816 VDD VSS n1313 n1312 n1311 OAI21X0P5H9R
XU1729 n1810 VDD VSS n1310 n1313 NOR2X0P5H9R
XU1730 n1817 VDD VSS n1809 n1814 NOR2X0P5H9R
XU1731 n1305 VDD VSS n1248 INVX0P5H9R
XU1732 n1253 VDD VSS u_mac16_top_u_mac_mult_result__19_ u_mac16_top_u_mac_last_prod__19_ NAND2X0P5H9R
XU1733 n1242 VDD VSS n1292 n1297 NAND2X0P5H9R
XU1734 n1244 VDD VSS u_mac16_top_u_mac_mult_result__19_ u_mac16_top_u_mac_accum_reg__19_ NAND2X0P5H9R
XU1735 n1323 VDD VSS u_mac16_top_u_mac_mult_result__20_ u_mac16_top_u_mac_last_prod__20_ NAND2X0P5H9R
XU1736 n1270 VDD VSS n1321 INVX0P5H9R
XU1737 n1322 VDD VSS u_mac16_top_u_mac_mult_result__21_ u_mac16_top_u_mac_last_prod__21_ NAND2X0P5H9R
XU1738 n1313 VDD VSS u_mac16_top_u_mac_mult_result__21_ u_mac16_top_u_mac_accum_reg__21_ NOR2X0P5H9R
XU1739 n1311 VDD VSS u_mac16_top_u_mac_mult_result__21_ u_mac16_top_u_mac_accum_reg__21_ NAND2X0P5H9R
XU1740 n2238 VDD VSS n2044 n2120 NOR2X0P5H9R
XU1741 n2045 VDD VSS u_mac16_top_opB_reg__7_ INVX0P7H9R
XU1742 n2056 VDD VSS n2045 n2044 NOR2X0P5H9R
XU1743 n1882 VDD VSS u_mac16_top_opB_reg__13_ INVX0P7H9R
XU1744 n2216 VDD VSS n2044 n1948 NOR2X0P5H9R
Xcopt_h_inst_864 copt_net_90 VDD VSS u_mac16_top_u_inB_shift_reg__13_ DLY2X0P5H9R
Xcopt_h_inst_865 copt_net_91 VDD VSS u_mac16_top_u_inA_shift_reg__7_ FREEICGX0P5H9R
XU1749 n1471 VDD VSS u_mac16_top_op_fifo_wr_ptr__1_ INVX0P5H9R
XU1750 n1468 VDD VSS u_mac16_top_op_fifo_wr_ptr__0_ INVX0P5H9R
XU1751 n1075 VDD VSS n1071 u_mac16_top_fifo_rd_ptr__1_ NAND2X0P5H9R
XU1752 n1071 VDD VSS u_mac16_top_fifo_rd_ptr__0_ INVX0P5H9R
XctmTdsLR_1_77 n1562 VDD VSS n1560 n889 NAND2XBX0P5H9R
XU1754 n2184 VDD VSS n2145 INVX0P5H9R
XU1756 n1006 VDD VSS n1243 n1296 n1244 OAI21X0P5H9R
XU1757 n1815 VDD VSS n1814 n1813 n1812 OAI21X0P5H9R
XU1758 n1819 VDD VSS n1810 n1817 NAND2X0P5H9R
Xcopt_h_inst_866 copt_net_92 VDD VSS u_mac16_top_u_inA_shift_reg__6_ FREEICGX0P5H9R
Xcopt_h_inst_867 copt_net_93 VDD VSS u_mac16_top_u_mac_mult_result__18_ FREEICGX0P5H9R
XU1761 n1833 VDD VSS n1824 n1831 NAND2X0P5H9R
XU1762 n1841 VDD VSS n1840 u_mac16_top_p2s_load NAND2X0P5H9R
XU1764 n1871 VDD VSS n2044 n1882 NOR2X0P5H9R
XU1765 n2117 VDD VSS u_mac16_top_opA_reg__7_ INVX1H9R
XU1767 n2119 VDD VSS u_mac16_top_opA_reg__6_ INVX1H9R
XU1768 n2121 VDD VSS u_mac16_top_opA_reg__5_ INVX1H9R
XU1770 n1861 VDD VSS n1859 INVX0P5H9R
XU1772 n1867 VDD VSS n1865 INVX0P5H9R
XU1775 n1792 VDD VSS u_mac16_top_u_mac_mult_result__1_ u_mac16_top_u_mac_accum_reg__1_ NAND2X0P5H9R
XU1776 n1776 VDD VSS u_mac16_top_u_mac_mult_result__2_ u_mac16_top_u_mac_last_prod__2_ NAND2X0P7H9R
XU1781 n1763 VDD VSS u_mac16_top_u_mac_mult_result__3_ u_mac16_top_u_mac_last_prod__3_ NAND2X0P5H9R
XU1782 n1772 VDD VSS n1784 n1780 n1781 OAI21X0P5H9R
XU1783 n1766 VDD VSS n1779 n1775 n1776 OAI21X0P5H9R
XU1784 n1755 VDD VSS n1754 n1753 NAND2X0P5H9R
XU1785 n1743 VDD VSS u_mac16_top_u_mac_mult_result__5_ u_mac16_top_u_mac_accum_reg__5_ NAND2X0P5H9R
XU1786 n1723 VDD VSS n1752 n1718 n1717 AOI21X0P5H9R
XU1788 n1730 VDD VSS n1756 n1725 n1724 AOI21X0P5H9R
XU1789 n1711 VDD VSS u_mac16_top_u_mac_mult_result__7_ u_mac16_top_u_mac_accum_reg__7_ NAND2X0P5H9R
XctmTdsLR_1_78 n1498 VDD VSS n1497 n2363 NOR2XBX0P5H9R
XctmTdsLR_1_79 tmp_net13 VDD VSS u_mac16_top_u_inB_cnt__0_ u_mac16_top_u_inB_cnt__1_ n1804 OAI21X0P5H9R
XU1792 n1687 VDD VSS n1686 n1685 NAND2X0P5H9R
XU1793 n1044 VDD VSS n1661 n1666 NAND2X0P5H9R
XU1794 n1599 VDD VSS n1617 n1597 NAND2X0P5H9R
XU1797 n1598 VDD VSS n1619 n1597 n1596 AOI21X0P5H9R
XU1798 n1608 VDD VSS n1628 n1606 NAND2X0P5H9R
XU1799 n1607 VDD VSS n1630 n1606 n1605 AOI21X0P5H9R
Xoptlc_880 optlc_net_99 VDD VSS TIELOX1H9R
XU1801 n1570 VDD VSS n1565 n1567 NAND2X0P5H9R
XctmTdsLR_2_80 u_mac16_top_u_inB_N50 VDD VSS n1802 tmp_net13 NOR2X0P5H9R
XU1805 n1508 VDD VSS u_mac16_top_fifo_count__2_ INVX0P5H9R
XU1806 n1372 VDD VSS u_mac16_top_u_out_bits_left__3_ u_mac16_top_u_out_bits_left__2_ NOR2X0P5H9R
XU1808 n1840 VDD VSS n926 INVX0P5H9R
XU1809 n926 VDD VSS u_mac16_top_u_out_busy BUFX2H9R
XctmTdsLR_1_81 tmp_net14 VDD VSS n1662 n1666 NAND2X0P5H9R
XU1812 n2142 VDD VSS n1974 n2060 NOR2X0P5H9R
XU1813 n2073 VDD VSS n2208 n2122 NOR2X0P5H9R
XU1814 n2070 VDD VSS n2208 n2118 NOR2X0P5H9R
XU1815 n2071 VDD VSS n2122 n2205 NOR2X0P5H9R
XU1816 n1336 VDD VSS n2118 n2057 NOR2X0P5H9R
XU1817 n1338 VDD VSS n2122 n2062 NOR2X0P5H9R
XU1818 n1337 VDD VSS n2120 n2059 NOR2X0P5H9R
XU1820 n1232 VDD VSS n2118 n2059 NOR2X0P5H9R
XU1822 n1231 VDD VSS n2120 n2062 NOR2X0P5H9R
XU1823 n1230 VDD VSS n2044 n2122 NOR2X0P5H9R
XU1824 n2224 VDD VSS n2045 n1974 NOR2X0P5H9R
XU1825 n1461 VDD VSS n2044 n2060 NOR2X0P7H9R
XU1826 n2077 VDD VSS n2058 n2205 NOR2X0P5H9R
XU1827 n2078 VDD VSS n2060 n1984 NOR2X0P5H9R
XU1829 n2076 VDD VSS n2000 n2061 NOR2X0P5H9R
XU1830 n1806 VDD VSS n1805 INVX0P5H9R
XU1831 n1846 VDD VSS u_mac16_top_schedule_active INVX0P5H9R
XU1835 n1504 VDD VSS u_mac16_top_op_fifo_count__0_ u_mac16_top_op_fifo_count__1_ AND2X0P5H9R
XU1836 n1802 VDD VSS n1801 INVX0P5H9R
XU1838 n776 VDD VSS n1444 n1443 NAND2X0P5H9R
XU1839 n1443 VDD VSS n1442 u_mac16_top_opB_fifo_3__3_ n1421 u_mac16_top_opB_fifo_0__3_ AOI22X0P5H9R
XU1840 n1444 VDD VSS n1440 u_mac16_top_opB_fifo_2__3_ n2212 u_mac16_top_opB_fifo_1__3_ AOI22X0P5H9R
XU1841 n790 VDD VSS n1388 n1387 NAND2X0P5H9R
XU1842 n1387 VDD VSS n1442 u_mac16_top_opA_fifo_3__1_ n1421 u_mac16_top_opA_fifo_0__1_ AOI22X0P5H9R
XU1844 n1388 VDD VSS n1450 u_mac16_top_opA_fifo_2__1_ n1413 u_mac16_top_opA_fifo_1__1_ AOI22X0P5H9R
XU1845 n789 VDD VSS n1412 n1411 NAND2X0P5H9R
XU1846 n1411 VDD VSS n1442 u_mac16_top_opA_fifo_3__0_ n1421 u_mac16_top_opA_fifo_0__0_ AOI22X0P5H9R
XU1847 n1412 VDD VSS n1450 u_mac16_top_opA_fifo_2__0_ n1413 u_mac16_top_opA_fifo_1__0_ AOI22X0P5H9R
XU1848 n1284 VDD VSS n1283 n1282 XNOR2X0P5H9R
XU1849 n1667 VDD VSS n1666 n1665 NAND2X0P5H9R
XU1850 n775 VDD VSS n1423 n1422 NAND2X0P5H9R
XU1851 n1422 VDD VSS n1452 u_mac16_top_opB_fifo_3__2_ n1421 u_mac16_top_opB_fifo_0__2_ AOI22X0P5H9R
XU1852 n1423 VDD VSS n1440 u_mac16_top_opB_fifo_2__2_ n2212 u_mac16_top_opB_fifo_1__2_ AOI22X0P5H9R
XU1853 n777 VDD VSS n1420 n1419 NAND2X0P7H9R
XU1854 n1419 VDD VSS n1452 u_mac16_top_opB_fifo_3__4_ n1421 u_mac16_top_opB_fifo_0__4_ AOI22X0P5H9R
XU1855 n1420 VDD VSS n1440 u_mac16_top_opB_fifo_2__4_ n2212 u_mac16_top_opB_fifo_1__4_ AOI22X0P5H9R
XU1856 n803 VDD VSS n1382 n1381 NAND2X0P5H9R
XU1857 n1382 VDD VSS n1440 u_mac16_top_opA_fifo_2__14_ n2212 u_mac16_top_opA_fifo_1__14_ AOI22X0P5H9R
XU1859 n1381 VDD VSS n1452 u_mac16_top_opA_fifo_3__14_ n1421 u_mac16_top_opA_fifo_0__14_ AOI22X0P5H9R
XU1860 n804 VDD VSS n1448 n1447 NAND2X0P5H9R
XU1861 n1447 VDD VSS n1452 u_mac16_top_opA_fifo_3__15_ n1421 u_mac16_top_opA_fifo_0__15_ AOI22X0P5H9R
XU1862 n1448 VDD VSS n1450 u_mac16_top_opA_fifo_2__15_ n2212 u_mac16_top_opA_fifo_1__15_ AOI22X0P5H9R
XU1863 n1652 VDD VSS n1645 n1644 XNOR2X0P5H9R
XU1864 n1649 VDD VSS n1648 n1647 NAND2X0P5H9R
XU1867 u_mac16_top_N115 VDD VSS n2144 n2195 n2194 n2193 OAI211X0P5H9R
XU1869 n2193 VDD VSS n2147 u_mac16_top_result_fifo_1__23_ n2148 u_mac16_top_result_fifo_2__23_ AOI22X0P5H9R
XU1870 u_mac16_top_N118 VDD VSS u_mac16_top_fifo_count__0_ INVX0P5H9R
XU1871 n733 VDD VSS n1370 u_mac16_top_schedule_active NAND2X0P5H9R
XU1874 n975 VDD VSS n1700 n1720 n1701 OAI21X0P5H9R
XU1877 n1809 VDD VSS u_mac16_top_u_mac_mult_result__22_ u_mac16_top_u_mac_accum_reg__22_ NOR2X0P5H9R
XU1878 n1830 VDD VSS n1324 n1323 n1322 OAI21X0P5H9R
XU1881 n848 VDD VSS n1526 INVX0P5H9R
XU1882 n1653 VDD VSS n1684 n1671 NOR2X0P5H9R
XU1883 n1824 VDD VSS n1321 n1324 NOR2X0P5H9R
XU1884 n1831 VDD VSS n1823 n1828 NOR2X0P5H9R
Xoptlc_881 optlc_net_100 VDD VSS TIELOX1H9R
XU1886 n1768 VDD VSS u_mac16_top_u_mac_mult_result__3_ u_mac16_top_u_mac_accum_reg__3_ NOR2X0P5H9R
XU1887 n1684 VDD VSS u_mac16_top_u_mac_mult_result__8_ u_mac16_top_u_mac_last_prod__8_ NOR2X0P5H9R
XU1888 n1056 VDD VSS u_mac16_top_u_mac_mult_result__11_ u_mac16_top_u_mac_last_prod__11_ NAND2X0P5H9R
XctmTdsLR_2_82 n1049 VDD VSS n1692 n1044 n1665 tmp_net14 OAI211X0P5H9R
Xoptlc_882 optlc_net_101 VDD VSS TIELOX1H9R
XU1891 n1033 VDD VSS n1031 n1617 NAND2X0P5H9R
XU1892 n1035 VDD VSS u_mac16_top_u_mac_mult_result__15_ u_mac16_top_u_mac_last_prod__15_ NAND2X0P5H9R
XU1893 n981 VDD VSS n1034 n1601 n1035 OAI21X0P5H9R
XU1894 n1813 VDD VSS u_mac16_top_u_mac_mult_result__22_ u_mac16_top_u_mac_accum_reg__22_ NAND2X0P5H9R
XU1896 n1576 VDD VSS n1809 INVX0P5H9R
XU1897 n1814 VDD VSS u_mac16_top_u_mac_mult_result__23_ u_mac16_top_u_mac_accum_reg__23_ NOR2X0P5H9R
XU1898 n1378 VDD VSS u_mac16_top_op_fifo_rd_ptr__1_ INVX0P5H9R
XU1899 n1469 VDD VSS u_mac16_top_fifo_wr_ptr__1_ INVX0P5H9R
XU1900 n1564 VDD VSS u_mac16_top_u_mac_u_mul_r_s40__5_ u_mac16_top_u_mac_u_mul_r_c40__5_ NAND2X0P5H9R
Xoptlc_883 optlc_net_102 VDD VSS TIELOX1H9R
XU1902 n1665 VDD VSS u_mac16_top_u_mac_mult_result__10_ u_mac16_top_u_mac_accum_reg__10_ NAND2X0P5H9R
XU1903 n1666 VDD VSS n1041 INVX0P5H9R
XU1904 n1659 VDD VSS n1658 n1657 NAND2X0P5H9R
XU1905 n1880 VDD VSS n1947 n1984 NOR2X0P5H9R
XU1906 n1878 VDD VSS n1948 n2205 NOR2X0P5H9R
XU1907 n1879 VDD VSS n1974 n1949 NOR2X0P5H9R
XU1908 n1885 VDD VSS n1882 n2001 NOR2X0P5H9R
XU1909 n1677 VDD VSS u_mac16_top_u_mac_mult_result__9_ u_mac16_top_u_mac_accum_reg__9_ NAND2X0P5H9R
Xoptlc_884 optlc_net_103 VDD VSS TIELOX1H9R
XU1911 n1680 VDD VSS n1692 n1688 n1689 OAI21X0P5H9R
XU1913 n1452 VDD VSS n1416 DLY2X1H9R
Xoptlc_885 optlc_net_104 VDD VSS TIELOX1H9R
XU1916 n1470 VDD VSS u_mac16_top_fifo_wr_ptr__0_ INVX0P5H9R
XU1917 n956 VDD VSS u_mac16_top_fifo_count__2_ n1070 n1518 OAI21X0P5H9R
XU1918 n1634 VDD VSS u_mac16_top_u_mac_mult_result__13_ u_mac16_top_u_mac_accum_reg__13_ NAND2X0P5H9R
XU1920 n1621 VDD VSS n1617 n1643 NAND2X0P5H9R
XU1925 n1632 VDD VSS n1628 n1648 NAND2X0P5H9R
XU1926 n1644 VDD VSS n1643 n1642 NAND2X0P5H9R
XU1928 n1855 VDD VSS n1853 INVX0P5H9R
XU1930 n1875 VDD VSS u_mac16_top_opB_reg__15_ INVX0P5H9R
XU1931 n1306 VDD VSS n1305 n1304 NAND2X0P5H9R
XU1932 n1298 VDD VSS n1297 n1296 NAND2X0P5H9R
XU1933 n1251 VDD VSS n1300 n1305 NAND2X0P5H9R
XU1934 n1008 VDD VSS n1261 n1312 NAND2X0P5H9R
XU1935 n989 VDD VSS n1270 n1323 NAND2X0P5H9R
XU1937 n1318 VDD VSS n1576 n1813 NAND2X0P5H9R
XU1938 n1329 VDD VSS n1567 n1827 NAND2X0P5H9R
XU1939 n2082 VDD VSS n2122 n1984 NOR2X0P5H9R
XU1942 n2084 VDD VSS n1974 n2118 NOR2X0P5H9R
XU1943 n2085 VDD VSS n2118 n2205 NOR2X0P5H9R
XU1946 n2086 VDD VSS n2120 n1984 NOR2X0P5H9R
XU1949 n2087 VDD VSS n2122 n2000 NOR2X0P5H9R
XU1950 n2100 VDD VSS n2118 n2001 NOR2X0P5H9R
XU1953 n2099 VDD VSS n2120 n2097 NOR2X0P5H9R
XU1956 n2098 VDD VSS n2122 n2107 NOR2X0P5H9R
XU1957 n2116 VDD VSS n2122 n2119 NOR2X0P5H9R
XU1960 n2115 VDD VSS n2120 n2117 NOR2X0P5H9R
XU1963 n2114 VDD VSS n2118 n2107 NOR2X0P5H9R
XU1964 n2129 VDD VSS n2122 n2121 NOR2X0P5H9R
XU1967 n2131 VDD VSS n2118 n2117 NOR2X0P5H9R
XU1970 n2130 VDD VSS n2120 n2119 NOR2X0P5H9R
XU1972 n2132 VDD VSS n2118 n2119 NOR2X0P5H9R
XU1973 n2134 VDD VSS n2122 n2057 NOR2X0P5H9R
XU1974 n2133 VDD VSS n2120 n2121 NOR2X0P5H9R
XU1975 n1333 VDD VSS n2118 n2121 NOR2X0P5H9R
XU1976 n1335 VDD VSS n2122 n2059 NOR2X0P5H9R
XU1978 n1334 VDD VSS n2120 n2057 NOR2X0P5H9R
XU1979 n2236 VDD VSS n2118 n2062 NOR2X0P5H9R
XU1980 n2237 VDD VSS n2046 n2122 NOR2X0P5H9R
XU1982 n2239 VDD VSS n2238 u_mac16_top_u_mac_u_mul_pp_0__0_ AND2X0P5H9R
XU1984 n2220 VDD VSS u_mac16_top_opA_reg__15_ u_mac16_top_opB_reg__7_ u_mac16_top_opA_reg__14_ u_mac16_top_opB_reg__8_ AOI22X0P5H9R
XU1986 n2223 VDD VSS n2206 n2205 NOR2X0P5H9R
XU1987 n2222 VDD VSS n2208 n2207 NOR2X0P5H9R
XU1988 n2204 VDD VSS n2045 n2205 NOR2X0P5H9R
XU1991 n2203 VDD VSS n2206 n1984 NOR2X0P5H9R
XU1993 n2202 VDD VSS n1974 n2207 NOR2X0P5H9R
XU1995 n1386 VDD VSS u_mac16_top_u_mac_u_mul_pp_5__20_ n2142 AND2X0P5H9R
XU1999 n1968 VDD VSS n2206 n2000 NOR2X0P5H9R
XU2000 n1969 VDD VSS n2045 n1984 NOR2X0P5H9R
XU2001 n1970 VDD VSS n2207 n2205 NOR2X0P5H9R
XU2002 n1976 VDD VSS n2045 n2000 NOR2X0P5H9R
XU2003 n1975 VDD VSS n2207 n1984 NOR2X0P5H9R
XU2004 n1977 VDD VSS n2206 n2001 NOR2X0P5H9R
XU2005 n2065 VDD VSS n1974 n2058 NOR2X0P5H9R
XU2006 n2066 VDD VSS n2060 n2205 NOR2X0P5H9R
XU2007 n2067 VDD VSS n1984 n2061 NOR2X0P5H9R
XU2008 n1981 VDD VSS n2207 n2000 NOR2X0P5H9R
XU2009 n1982 VDD VSS n2045 n2001 NOR2X0P5H9R
XU2010 n1988 VDD VSS n2207 n2001 NOR2X0P5H9R
XU2011 n1989 VDD VSS n2045 n2097 NOR2X0P5H9R
XU2012 n1990 VDD VSS n2206 n2107 NOR2X0P5H9R
XU2013 n2090 VDD VSS n2058 n2000 NOR2X0P5H9R
XU2014 n2089 VDD VSS n2060 n2001 NOR2X0P5H9R
XU2015 n2088 VDD VSS n2097 n2061 NOR2X0P5H9R
XU2016 n2008 VDD VSS n2107 n2061 NOR2X0P5H9R
XU2018 n2015 VDD VSS n2045 n2119 NOR2X0P5H9R
XU2019 n2014 VDD VSS n2207 n2117 NOR2X0P5H9R
XU2020 n2017 VDD VSS n2061 n2117 NOR2X0P5H9R
XU2021 n2019 VDD VSS n2058 n2097 NOR2X0P5H9R
XU2022 n2018 VDD VSS n2060 n2107 NOR2X0P5H9R
XU2023 n2024 VDD VSS n2045 n2121 NOR2X0P5H9R
XU2024 n2023 VDD VSS n2207 n2119 NOR2X0P5H9R
XU2025 n2027 VDD VSS n2060 n2117 NOR2X0P5H9R
XU2028 n2026 VDD VSS n2119 n2061 NOR2X0P5H9R
XU2029 n2033 VDD VSS n2045 n2057 NOR2X0P5H9R
XU2030 n2032 VDD VSS n2207 n2121 NOR2X0P5H9R
XU2031 n2094 VDD VSS n2058 n2117 NOR2X0P5H9R
XU2032 n2095 VDD VSS n2060 n2119 NOR2X0P5H9R
XU2033 n2096 VDD VSS n2121 n2061 NOR2X0P5H9R
XU2034 n2039 VDD VSS n2045 n2059 NOR2X0P5H9R
XU2035 n2038 VDD VSS n2207 n2057 NOR2X0P5H9R
XU2036 n2040 VDD VSS n2206 n2062 NOR2X0P5H9R
XU2037 n2110 VDD VSS n2058 n2119 NOR2X0P5H9R
XU2038 n2109 VDD VSS n2060 n2121 NOR2X0P5H9R
XU2039 n2108 VDD VSS n2061 n2057 NOR2X0P5H9R
XU2040 n2125 VDD VSS n2058 n2121 NOR2X0P5H9R
XU2041 n2124 VDD VSS n2060 n2057 NOR2X0P5H9R
XU2042 n2123 VDD VSS n2059 n2061 NOR2X0P5H9R
XU2043 n2229 VDD VSS n2053 n2056 AND2X0P5H9R
XU2045 n2054 VDD VSS n2207 n2062 NOR2X0P5H9R
XU2048 n2055 VDD VSS n2206 n2046 NOR2X0P5H9R
XU2049 n2137 VDD VSS n2058 n2057 NOR2X0P5H9R
XU2050 n2136 VDD VSS n2060 n2059 NOR2X0P5H9R
XU2052 n2135 VDD VSS n2062 n2061 NOR2X0P5H9R
XU2053 n2234 VDD VSS n2229 n2228 NOR2X0P5H9R
XU2055 n2228 VDD VSS u_mac16_top_opB_reg__7_ u_mac16_top_opA_reg__0_ u_mac16_top_opB_reg__6_ u_mac16_top_opA_reg__1_ AOI22X0P5H9R
XU2056 n2231 VDD VSS n2058 n2059 NOR2X0P5H9R
XU2058 n2232 VDD VSS n2060 n2062 NOR2X0P5H9R
XU2059 n2230 VDD VSS n2044 n2061 NOR2X0P5H9R
XU2060 n2053 VDD VSS n2046 n2207 NOR2X0P5H9R
XU2061 n1460 VDD VSS n2058 n2062 NOR2X0P5H9R
XU2063 n1459 VDD VSS n2046 n2061 NOR2X0P5H9R
XU2064 n1895 VDD VSS n1881 n2001 NOR2X0P5H9R
XU2066 n1894 VDD VSS n1882 n2097 NOR2X0P5H9R
XU2073 n1893 VDD VSS n1883 n2107 NOR2X0P5H9R
XU2077 n1908 VDD VSS n1949 n2000 NOR2X0P5H9R
XU2084 n1921 VDD VSS n1882 n2119 NOR2X0P5H9R
XU2087 n1922 VDD VSS n1881 n2117 NOR2X0P5H9R
XU2089 n1920 VDD VSS n1883 n2121 NOR2X0P5H9R
XU2091 n1929 VDD VSS n1881 n2119 NOR2X0P5H9R
XU2099 n1930 VDD VSS n1882 n2121 NOR2X0P5H9R
XU2104 n1928 VDD VSS n1947 n2117 NOR2X0P5H9R
XU2105 n1926 VDD VSS n1949 n2097 NOR2X0P5H9R
XU2107 n1939 VDD VSS n1882 n2057 NOR2X0P5H9R
XU2108 n1940 VDD VSS n1881 n2121 NOR2X0P5H9R
XU2109 n1938 VDD VSS n1883 n2059 NOR2X0P5H9R
XU2110 n1937 VDD VSS n1947 n2119 NOR2X0P5H9R
XU2111 n1935 VDD VSS n1949 n2107 NOR2X0P5H9R
XU2112 n1951 VDD VSS n1882 n2059 NOR2X0P5H9R
XU2113 n1952 VDD VSS n1881 n2057 NOR2X0P5H9R
XU2114 n1950 VDD VSS n1883 n2062 NOR2X0P5H9R
XU2115 n1944 VDD VSS n1949 n2117 NOR2X0P5H9R
XU2116 n1946 VDD VSS n1947 n2121 NOR2X0P5H9R
XU2117 n1872 VDD VSS n1881 n2062 NOR2X0P5H9R
XU2119 n1959 VDD VSS n1949 n2121 NOR2X0P5H9R
XU2120 n1961 VDD VSS n1947 n2059 NOR2X0P5H9R
XU2123 n1201 VDD VSS n2044 n1947 NOR2X0P5H9R
XU2124 n1206 VDD VSS n2046 n1881 NOR2X0P7H9R
XU2125 n2214 VDD VSS n1949 n2062 NOR2X0P5H9R
XU2126 n2215 VDD VSS n2046 n1947 NOR2X0P5H9R
XU2127 n2217 VDD VSS n2216 u_mac16_top_u_mac_u_mul_pp_9__9_ AND2X0P5H9R
XU2129 n1807 VDD VSS u_mac16_top_u_inA_cnt__2_ INVX0P5H9R
XU2130 n1416 VDD VSS n806 n1378 NOR2X0P5H9R
XU2131 n1421 VDD VSS u_mac16_top_op_fifo_rd_ptr__0_ u_mac16_top_op_fifo_rd_ptr__1_ NOR2X1P4H9R
XctmTdsLR_1_84 tmp_net15 VDD VSS n848 n1527 NAND2XBX0P7H9R
XU2133 n1440 VDD VSS n2213 FREEICGX0P5H9R
XU2135 n1450 VDD VSS n2213 FREEICGX0P7H9R
XU2136 n1442 VDD VSS n1416 FREEICGX0P6H9R
XctmTdsLR_2_85 u_mac16_top_u_mac_u_mul_N52 VDD VSS n1529 tmp_net15 XOR2X2H9R
XU2139 n2213 VDD VSS u_mac16_top_op_fifo_rd_ptr__0_ n1378 NOR2X0P5H9R
XU2140 n2212 VDD VSS u_mac16_top_op_fifo_rd_ptr__1_ n806 NOR2X1H9R
XU2142 n2197 VDD VSS u_mac16_top_sched_cnt__1_ u_mac16_top_sched_cnt__0_ NAND2X0P5H9R
XU2143 n1370 VDD VSS n2197 n1371 NOR2X0P5H9R
XU2144 n1803 VDD VSS u_mac16_top_u_inB_cnt__2_ INVX0P5H9R
XU2145 n1473 VDD VSS in_ready INVX0P5H9R
XU2148 u_mac16_top_u_mac_N58 VDD VSS u_mac16_top_u_mac_mult_valid u_mac16_top_u_mac_mode_d AND2X0P5H9R
XU2150 n781 VDD VSS n1425 n1424 NAND2X0P5H9R
XU2151 n1424 VDD VSS n1442 u_mac16_top_opB_fifo_3__8_ n1421 u_mac16_top_opB_fifo_0__8_ AOI22X0P5H9R
XU2152 n1425 VDD VSS n1440 u_mac16_top_opB_fifo_2__8_ n2212 u_mac16_top_opB_fifo_1__8_ AOI22X0P5H9R
XU2153 n778 VDD VSS n1427 n1426 NAND2X0P5H9R
XU2154 n1426 VDD VSS n1442 u_mac16_top_opB_fifo_3__5_ n1421 u_mac16_top_opB_fifo_0__5_ AOI22X0P5H9R
XU2155 n1427 VDD VSS n1440 u_mac16_top_opB_fifo_2__5_ n2212 u_mac16_top_opB_fifo_1__5_ AOI22X0P5H9R
XU2156 n801 VDD VSS n1384 n1383 NAND2X0P5H9R
XU2157 n1384 VDD VSS n1440 u_mac16_top_opA_fifo_2__12_ n2212 u_mac16_top_opA_fifo_1__12_ AOI22X0P5H9R
XU2158 n1383 VDD VSS n1452 u_mac16_top_opA_fifo_3__12_ n1421 u_mac16_top_opA_fifo_0__12_ AOI22X0P5H9R
XU2159 n797 VDD VSS n1446 n1445 NAND2X0P5H9R
XU2161 n1445 VDD VSS n1452 u_mac16_top_opA_fifo_3__8_ n1421 u_mac16_top_opA_fifo_0__8_ AOI22X0P5H9R
XU2162 n1446 VDD VSS n1450 u_mac16_top_opA_fifo_2__8_ n2212 u_mac16_top_opA_fifo_1__8_ AOI22X0P5H9R
XU2163 n785 VDD VSS n1390 n1389 NAND2X0P5H9R
XU2166 n1389 VDD VSS n1442 u_mac16_top_opB_fifo_3__12_ n1421 u_mac16_top_opB_fifo_0__12_ AOI22X0P5H9R
XU2167 n1390 VDD VSS n1440 u_mac16_top_opB_fifo_2__12_ n1413 u_mac16_top_opB_fifo_1__12_ AOI22X0P5H9R
XU2168 n792 VDD VSS n1404 n1403 NAND2X0P5H9R
XU2169 n1403 VDD VSS n1452 u_mac16_top_opA_fifo_3__3_ n1421 u_mac16_top_opA_fifo_0__3_ AOI22X0P5H9R
XU2170 n1404 VDD VSS n1450 u_mac16_top_opA_fifo_2__3_ n1413 u_mac16_top_opA_fifo_1__3_ AOI22X0P5H9R
XU2171 n794 VDD VSS n1392 n1391 NAND2X0P5H9R
XU2172 n1391 VDD VSS n1452 u_mac16_top_opA_fifo_3__5_ n1421 u_mac16_top_opA_fifo_0__5_ AOI22X0P5H9R
XU2173 n1392 VDD VSS n1450 u_mac16_top_opA_fifo_2__5_ n1413 u_mac16_top_opA_fifo_1__5_ AOI22X0P5H9R
XU2177 n1541 VDD VSS gre_a_INV_23_14 n1477 NAND2X0P5H9R
XU2178 n1542 VDD VSS n1538 n2369 NAND2X0P5H9R
XU2180 u_mac16_top_u_mac_u_mul_N38 VDD VSS u_mac16_top_u_mac_u_mul_r_s40__5_ u_mac16_top_u_mac_u_mul_r_c40__5_ n1564 OA21X0P5H9R
XU2186 u_mac16_top_u_mac_u_mul_st4_0_gen_csa_fa_5__u_fa_N1 VDD VSS u_mac16_top_u_mac_u_mul_r_s30__5_ u_mac16_top_u_mac_u_mul_r_c30__5_ AND2X0P5H9R
XU2187 n795 VDD VSS n1402 n1401 NAND2X0P5H9R
XU2188 n1401 VDD VSS n1452 u_mac16_top_opA_fifo_3__6_ n1421 u_mac16_top_opA_fifo_0__6_ AOI22X0P5H9R
XU2189 n1402 VDD VSS n1450 u_mac16_top_opA_fifo_2__6_ n1413 u_mac16_top_opA_fifo_1__6_ AOI22X0P5H9R
XU2191 n1548 VDD VSS n1547 n883 n1546 OAI21X0P5H9R
XU2192 n802 VDD VSS n1398 n1397 NAND2X0P5H9R
XU2193 n1397 VDD VSS n1452 u_mac16_top_opA_fifo_3__13_ n1421 u_mac16_top_opA_fifo_0__13_ AOI22X0P5H9R
XU2194 n1398 VDD VSS n1450 u_mac16_top_opA_fifo_2__13_ n1413 u_mac16_top_opA_fifo_1__13_ AOI22X0P5H9R
XU2195 n786 VDD VSS n1408 n1407 NAND2X0P5H9R
XU2196 n1407 VDD VSS n1442 u_mac16_top_opB_fifo_3__13_ n1421 u_mac16_top_opB_fifo_0__13_ AOI22X0P5H9R
XU2197 n1408 VDD VSS n1450 u_mac16_top_opB_fifo_2__13_ n1413 u_mac16_top_opB_fifo_1__13_ AOI22X0P5H9R
XU2198 u_mac16_top_u_mac_u_mul_st4_0_gen_csa_fa_4__u_fa_N1 VDD VSS u_mac16_top_u_mac_u_mul_r_s30__4_ u_mac16_top_u_mac_u_mul_r_c30__4_ AND2X0P5H9R
XU2201 n800 VDD VSS n1454 n1453 NAND2X0P5H9R
XU2202 n1453 VDD VSS n1452 u_mac16_top_opA_fifo_3__11_ n1421 u_mac16_top_opA_fifo_0__11_ AOI22X0P5H9R
XU2203 n1454 VDD VSS n1450 u_mac16_top_opA_fifo_2__11_ n2212 u_mac16_top_opA_fifo_1__11_ AOI22X0P5H9R
XU2206 n784 VDD VSS n1435 n1434 NAND2X0P5H9R
XU2209 n1434 VDD VSS n1442 u_mac16_top_opB_fifo_3__11_ n1421 u_mac16_top_opB_fifo_0__11_ AOI22X0P5H9R
XU2210 n1435 VDD VSS n1440 u_mac16_top_opB_fifo_2__11_ n2212 u_mac16_top_opB_fifo_1__11_ AOI22X0P5H9R
XU2211 n799 VDD VSS n1380 n1379 NAND2X0P5H9R
XU2212 n1380 VDD VSS n2213 u_mac16_top_opA_fifo_2__10_ n2212 u_mac16_top_opA_fifo_1__10_ AOI22X0P5H9R
XU2213 n1379 VDD VSS n1452 u_mac16_top_opA_fifo_3__10_ n1421 u_mac16_top_opA_fifo_0__10_ AOI22X0P5H9R
XU2215 n798 VDD VSS n1394 n1393 NAND2X0P5H9R
XU2216 n1393 VDD VSS n1452 u_mac16_top_opA_fifo_3__9_ n1421 u_mac16_top_opA_fifo_0__9_ AOI22X0P5H9R
XU2217 n1394 VDD VSS n1450 u_mac16_top_opA_fifo_2__9_ n1413 u_mac16_top_opA_fifo_1__9_ AOI22X0P5H9R
XU2219 n761 VDD VSS n1889 n1888 n1887 XOR3X0P5H9R
XU2220 n1887 VDD VSS n1886 n1885 n1884 XOR3X0P5H9R
XU2221 n1889 VDD VSS n1880 n1879 n1878 XOR3X0P5H9R
XU2222 n1884 VDD VSS n1883 n2097 NOR2X0P5H9R
XU2223 n783 VDD VSS n1433 n1432 NAND2X0P5H9R
XU2224 n1432 VDD VSS n1442 u_mac16_top_opB_fifo_3__10_ n1421 u_mac16_top_opB_fifo_0__10_ AOI22X0P5H9R
XU2225 n1433 VDD VSS n1440 u_mac16_top_opB_fifo_2__10_ n2212 u_mac16_top_opB_fifo_1__10_ AOI22X0P5H9R
XU2226 n782 VDD VSS n1431 n1430 NAND2X0P5H9R
XU2227 n1430 VDD VSS n1442 u_mac16_top_opB_fifo_3__9_ n1421 u_mac16_top_opB_fifo_0__9_ AOI22X0P5H9R
XU2228 n1431 VDD VSS n1440 u_mac16_top_opB_fifo_2__9_ n2212 u_mac16_top_opB_fifo_1__9_ AOI22X0P5H9R
XU2229 n793 VDD VSS n1396 n1395 NAND2X0P5H9R
XU2230 n1395 VDD VSS n1452 u_mac16_top_opA_fifo_3__4_ n1421 u_mac16_top_opA_fifo_0__4_ AOI22X0P5H9R
XU2231 n1396 VDD VSS n1450 u_mac16_top_opA_fifo_2__4_ n1413 u_mac16_top_opA_fifo_1__4_ AOI22X0P5H9R
XU2232 n796 VDD VSS n1400 n1399 NAND2X0P5H9R
XU2236 n1399 VDD VSS n1452 u_mac16_top_opA_fifo_3__7_ n1421 u_mac16_top_opA_fifo_0__7_ AOI22X0P5H9R
XU2240 n1400 VDD VSS n1450 u_mac16_top_opA_fifo_2__7_ n1413 u_mac16_top_opA_fifo_1__7_ AOI22X0P5H9R
XU2241 n791 VDD VSS n1410 n1409 NAND2X0P5H9R
XU2242 n1409 VDD VSS n1442 u_mac16_top_opA_fifo_3__2_ n1421 u_mac16_top_opA_fifo_0__2_ AOI22X0P5H9R
XU2243 n1410 VDD VSS n1450 u_mac16_top_opA_fifo_2__2_ n1413 u_mac16_top_opA_fifo_1__2_ AOI22X0P5H9R
XU2244 n779 VDD VSS n1429 n1428 NAND2X0P5H9R
XU2245 n1428 VDD VSS n1442 u_mac16_top_opB_fifo_3__6_ n1421 u_mac16_top_opB_fifo_0__6_ AOI22X0P5H9R
XU2246 n1429 VDD VSS n1440 u_mac16_top_opB_fifo_2__6_ n2212 u_mac16_top_opB_fifo_1__6_ AOI22X0P5H9R
XU2247 n773 VDD VSS n1437 n1436 NAND2X0P5H9R
XU2249 n1436 VDD VSS n1442 u_mac16_top_opB_fifo_3__0_ n1421 u_mac16_top_opB_fifo_0__0_ AOI22X0P5H9R
XU2250 n1437 VDD VSS n1440 u_mac16_top_opB_fifo_2__0_ n2212 u_mac16_top_opB_fifo_1__0_ AOI22X0P5H9R
XU2251 n780 VDD VSS n1439 n1438 NAND2X0P5H9R
XU2254 n1438 VDD VSS n1442 u_mac16_top_opB_fifo_3__7_ n1421 u_mac16_top_opB_fifo_0__7_ AOI22X0P5H9R
XU2255 n1439 VDD VSS n1440 u_mac16_top_opB_fifo_2__7_ n2212 u_mac16_top_opB_fifo_1__7_ AOI22X0P5H9R
XU2257 u_mac16_top_u_mac_u_mul_st4_0_gen_csa_fa_6__u_fa_N1 VDD VSS u_mac16_top_u_mac_u_mul_r_s30__6_ u_mac16_top_u_mac_u_mul_r_c30__6_ AND2X0P5H9R
XU2258 n955 VDD VSS u_mac16_top_op_fifo_wr_ptr__0_ u_mac16_top_op_fifo_wr_ptr__1_ n1471 n1468 AOI22X0P5H9R
XU2261 n2149 VDD VSS n2147 u_mac16_top_result_fifo_1__0_ n2148 u_mac16_top_result_fifo_2__0_ AOI22X0P5H9R
XU2262 u_mac16_top_u_mac_u_mul_st4_1_gen_csa_fa_15__u_fa_N1 VDD VSS u_mac16_top_u_mac_u_mul_r_c31__15_ u_mac16_top_u_mac_u_mul_r_s23__15_ AND2X0P5H9R
XU2265 n2152 VDD VSS n2147 u_mac16_top_result_fifo_1__1_ n2148 u_mac16_top_result_fifo_2__1_ AOI22X0P5H9R
XU2266 n2155 VDD VSS n2147 u_mac16_top_result_fifo_1__2_ n2148 u_mac16_top_result_fifo_2__2_ AOI22X0P5H9R
XU2270 n2158 VDD VSS n2147 u_mac16_top_result_fifo_1__3_ n2148 u_mac16_top_result_fifo_2__3_ AOI22X0P5H9R
XU2273 n2161 VDD VSS n2147 u_mac16_top_result_fifo_1__4_ n2148 u_mac16_top_result_fifo_2__4_ AOI22X0P5H9R
XU2274 n2164 VDD VSS n2147 u_mac16_top_result_fifo_1__5_ n2148 u_mac16_top_result_fifo_2__5_ AOI22X0P5H9R
XU2277 n2167 VDD VSS n2147 u_mac16_top_result_fifo_1__6_ n2148 u_mac16_top_result_fifo_2__6_ AOI22X0P5H9R
XU2278 n2170 VDD VSS n2147 u_mac16_top_result_fifo_1__7_ n2148 u_mac16_top_result_fifo_2__7_ AOI22X0P5H9R
XU2279 n2173 VDD VSS n2147 u_mac16_top_result_fifo_1__8_ n2148 u_mac16_top_result_fifo_2__8_ AOI22X0P5H9R
XU2281 n2176 VDD VSS n2147 u_mac16_top_result_fifo_1__9_ n2148 u_mac16_top_result_fifo_2__9_ AOI22X0P5H9R
XU2283 n2180 VDD VSS n2147 u_mac16_top_result_fifo_1__10_ n2148 u_mac16_top_result_fifo_2__10_ AOI22X0P5H9R
XU2288 n2186 VDD VSS n2147 u_mac16_top_result_fifo_1__11_ n2148 u_mac16_top_result_fifo_2__11_ AOI22X0P5H9R
XU2293 n1076 VDD VSS n2147 u_mac16_top_result_fifo_1__12_ n2148 u_mac16_top_result_fifo_2__12_ AOI22X0P5H9R
XU2294 n1079 VDD VSS n2147 u_mac16_top_result_fifo_1__13_ n2148 u_mac16_top_result_fifo_2__13_ AOI22X0P5H9R
XU2298 n1081 VDD VSS n2147 u_mac16_top_result_fifo_1__14_ n2148 u_mac16_top_result_fifo_2__14_ AOI22X0P5H9R
XU2301 n1084 VDD VSS n2147 u_mac16_top_result_fifo_1__15_ n2148 u_mac16_top_result_fifo_2__15_ AOI22X0P5H9R
XU2302 n1087 VDD VSS n2147 u_mac16_top_result_fifo_1__16_ n2148 u_mac16_top_result_fifo_2__16_ AOI22X0P5H9R
XU2304 n1090 VDD VSS n2147 u_mac16_top_result_fifo_1__17_ n2148 u_mac16_top_result_fifo_2__17_ AOI22X0P5H9R
XU2306 n1093 VDD VSS n2147 u_mac16_top_result_fifo_1__18_ n2148 u_mac16_top_result_fifo_2__18_ AOI22X0P5H9R
XU2312 n1096 VDD VSS n2147 u_mac16_top_result_fifo_1__19_ n2148 u_mac16_top_result_fifo_2__19_ AOI22X0P5H9R
XU2317 n1099 VDD VSS n2147 u_mac16_top_result_fifo_1__20_ n2148 u_mac16_top_result_fifo_2__20_ AOI22X0P5H9R
XU2318 n1102 VDD VSS n2147 u_mac16_top_result_fifo_1__21_ n2148 u_mac16_top_result_fifo_2__21_ AOI22X0P5H9R
XU2319 n1105 VDD VSS n2147 u_mac16_top_result_fifo_1__22_ n2148 u_mac16_top_result_fifo_2__22_ AOI22X0P5H9R
XU2320 u_mac16_top_u_mac_u_mul_st4_1_gen_csa_fa_14__u_fa_N1 VDD VSS u_mac16_top_u_mac_u_mul_r_c31__14_ u_mac16_top_u_mac_u_mul_r_s23__14_ AND2X0P5H9R
XctmTdsLR_1_86 tmp_net16 VDD VSS n1353 n1352 NAND2XBX0P7H9R
XU2323 n1837 VDD VSS n1836 n1838 carry AOI21X0P5H9R
XU2325 n1502 VDD VSS n1847 u_mac16_top_op_fifo_count__2_ n1504 AOI21X0P5H9R
XU2327 n2353 VDD VSS u_mac16_top_u_out_bits_left__0_ n926 NAND2X0P5H9R
XU2328 n788 VDD VSS n1406 n1405 NAND2X0P5H9R
XU2329 n1405 VDD VSS n1442 u_mac16_top_opB_fifo_3__15_ n1421 u_mac16_top_opB_fifo_0__15_ AOI22X0P5H9R
XU2331 n1406 VDD VSS n1450 u_mac16_top_opB_fifo_2__15_ n1413 u_mac16_top_opB_fifo_1__15_ AOI22X0P5H9R
XU2334 n1457 VDD VSS u_mac16_top_opB_reg__15_ u_mac16_top_opA_reg__8_ NAND2X0P5H9R
XU2337 u_mac16_top_u_mac_u_mul_st2_3_gen_csa_fa_22__u_fa_N0 VDD VSS n1852 n1851 u_mac16_top_u_mac_u_mul_st2_3_gen_csa_fa_22__u_fa_N1 AOI21X0P5H9R
XU2338 n1851 VDD VSS u_mac16_top_opB_reg__15_ u_mac16_top_opA_reg__7_ NAND2X0P5H9R
XU2339 u_mac16_top_u_mac_u_mul_st2_3_gen_csa_fa_21__u_fa_N0 VDD VSS n1855 n1854 u_mac16_top_u_mac_u_mul_st2_3_gen_csa_fa_21__u_fa_N1 AOI21X0P5H9R
XU2340 n1854 VDD VSS u_mac16_top_opB_reg__15_ u_mac16_top_opA_reg__6_ NAND2X0P5H9R
XU2341 u_mac16_top_u_mac_u_mul_st2_3_gen_csa_fa_20__u_fa_N0 VDD VSS n1858 n1857 u_mac16_top_u_mac_u_mul_st2_3_gen_csa_fa_20__u_fa_N1 AOI21X0P5H9R
XU2342 n1857 VDD VSS u_mac16_top_opB_reg__15_ u_mac16_top_opA_reg__5_ NAND2X0P5H9R
XU2346 u_mac16_top_u_mac_u_mul_st2_3_gen_csa_fa_19__u_fa_N0 VDD VSS n1861 n1860 u_mac16_top_u_mac_u_mul_st2_3_gen_csa_fa_19__u_fa_N1 AOI21X0P5H9R
XU2348 n1860 VDD VSS u_mac16_top_opB_reg__15_ u_mac16_top_opA_reg__4_ NAND2X0P5H9R
XU2350 u_mac16_top_u_mac_u_mul_st2_3_gen_csa_fa_18__u_fa_N0 VDD VSS n1864 n1863 u_mac16_top_u_mac_u_mul_st2_3_gen_csa_fa_18__u_fa_N1 AOI21X0P5H9R
XU2354 n1863 VDD VSS u_mac16_top_opB_reg__15_ u_mac16_top_opA_reg__3_ NAND2X0P5H9R
XU2357 u_mac16_top_u_mac_u_mul_st2_3_gen_csa_fa_17__u_fa_N0 VDD VSS n1867 n1866 u_mac16_top_u_mac_u_mul_st2_3_gen_csa_fa_17__u_fa_N1 AOI21X0P5H9R
XU2359 n1866 VDD VSS u_mac16_top_opB_reg__15_ u_mac16_top_opA_reg__2_ NAND2X0P5H9R
XU2361 u_mac16_top_u_mac_u_mul_st1_4_gen_csa_fa_13__u_fa_N1 VDD VSS n1206 n1871 AND2X0P5H9R
XU2364 u_mac16_top_u_mac_u_mul_st2_3_gen_csa_fa_22__u_fa_N1 VDD VSS n1875 n1852 n2117 NOR3X1H9R
XU2365 u_mac16_top_u_mac_u_mul_st2_3_gen_csa_fa_21__u_fa_N1 VDD VSS n1875 n1855 n2119 NOR3X0P5H9R
XU2366 u_mac16_top_u_mac_u_mul_st2_3_gen_csa_fa_20__u_fa_N1 VDD VSS n1875 n1858 n2121 NOR3X0P5H9R
XU2395 u_mac16_top_u_mac_u_mul_st2_3_gen_csa_fa_19__u_fa_N1 VDD VSS n1875 n1861 n2057 NOR3X1H9R
XU2405 u_mac16_top_u_mac_u_mul_st2_3_gen_csa_fa_18__u_fa_N1 VDD VSS n1875 n1864 n2059 NOR3X0P5H9R
XU2406 u_mac16_top_u_mac_u_mul_st2_3_gen_csa_fa_17__u_fa_N1 VDD VSS n1875 n1867 n2062 NOR3X0P5H9R
XU2442 u_mac16_top_u_mac_u_mul_st2_3_gen_csa_fa_16__u_fa_N1 VDD VSS n2044 n1875 n1870 NOR3X0P5H9R
XU2444 u_mac16_top_u_mac_u_mul_st2_3_gen_csa_fa_15__u_fa_N1 VDD VSS n2046 n1875 n1877 NOR3X0P5H9R
XU2445 u_mac16_top_u_mac_u_mul_st3_0_gen_csa_fa_3__u_fa_N1 VDD VSS u_mac16_top_u_mac_u_mul_r_c20__3_ u_mac16_top_u_mac_u_mul_r_s20__3_ AND2X0P5H9R
XU2446 u_mac16_top_u_mac_u_mul_st3_0_gen_csa_fa_4__u_fa_N1 VDD VSS u_mac16_top_u_mac_u_mul_r_c20__4_ u_mac16_top_u_mac_u_mul_r_s20__4_ AND2X0P5H9R
XU2447 u_mac16_top_u_mac_u_mul_st3_0_gen_csa_fa_19__u_fa_N2 VDD VSS u_mac16_top_u_mac_u_mul_r_s21__19_ u_mac16_top_u_mac_u_mul_r_s20__19_ AND2X0P5H9R
XU2448 u_mac16_top_u_mac_u_mul_st3_0_gen_csa_fa_20__u_fa_N2 VDD VSS u_mac16_top_u_mac_u_mul_r_s21__20_ u_mac16_top_u_mac_u_mul_r_s20__20_ AND2X0P5H9R
XU2449 n1848 VDD VSS n2242 INVX0P5H9R
XU2450 u_mac16_top_u_mac_u_mul_st4_0_gen_csa_fa_22__u_fa_N2 VDD VSS u_mac16_top_u_mac_u_mul_r_s31__22_ u_mac16_top_u_mac_u_mul_r_s30__22_ AND2X0P5H9R
XU2451 u_mac16_top_u_mac_u_mul_st3_1_gen_csa_fa_9__u_fa_N1 VDD VSS u_mac16_top_u_mac_u_mul_r_s22__9_ u_mac16_top_u_mac_u_mul_r_c21__9_ AND2X0P5H9R
XU2452 u_mac16_top_u_mac_u_mul_st3_1_gen_csa_fa_10__u_fa_N1 VDD VSS u_mac16_top_u_mac_u_mul_r_s22__10_ u_mac16_top_u_mac_u_mul_r_c21__10_ AND2X0P5H9R
XU2453 u_mac16_top_u_mac_u_mul_st3_1_gen_csa_fa_11__u_fa_N1 VDD VSS u_mac16_top_u_mac_u_mul_r_s22__11_ u_mac16_top_u_mac_u_mul_r_c21__11_ AND2X0P5H9R
XU2454 u_mac16_top_u_out_N21 VDD VSS n1840 u_mac16_top_mac_result_shadow__0_ AND2X0P5H9R
XU2500 u_mac16_top_u_mac_add_tmp_comb__1_ VDD VSS n1796 n1838 n1795 u_mac16_top_u_mac_mode_d AO22X0P5H9R
XU2503 u_mac16_top_u_mac_add_tmp_comb__2_ VDD VSS n1786 n1838 n1785 u_mac16_top_u_mac_mode_d AO22X0P5H9R
XU2504 u_mac16_top_u_mac_add_tmp_comb__3_ VDD VSS n1774 n1838 n1773 u_mac16_top_u_mac_mode_d AO22X0P5H9R
XU2506 u_mac16_top_u_mac_add_tmp_comb__4_ VDD VSS n1760 n1838 n1758 u_mac16_top_u_mac_mode_d AO22X0P5H9R
XU2507 n1751 VDD VSS n1750 n1749 NAND2X0P5H9R
XU2509 u_mac16_top_u_mac_add_tmp_comb__5_ VDD VSS n1748 n1838 n1747 u_mac16_top_u_mac_mode_d AO22X0P5H9R
XU2510 u_mac16_top_u_mac_add_tmp_comb__6_ VDD VSS n1732 n1838 n1731 u_mac16_top_u_mac_mode_d AO22X0P5H9R
XU2512 u_mac16_top_u_mac_add_tmp_comb__7_ VDD VSS n1716 n1838 n1715 u_mac16_top_u_mac_mode_d AO22X0P5H9R
XU2513 u_mac16_top_u_mac_add_tmp_comb__8_ VDD VSS n1694 n1838 n1693 u_mac16_top_u_mac_mode_d AO22X0P5H9R
XU2524 u_mac16_top_u_mac_add_tmp_comb__16_ VDD VSS n1595 n1838 n1594 u_mac16_top_u_mac_mode_d AO22X0P5H9R
XU2526 n2349 VDD VSS n1516 n1515 n1840 AOI21X0P5H9R
XU2527 n1515 VDD VSS n1514 u_mac16_top_u_out_bits_left__4_ u_mac16_top_u_out_bits_left__5_ OAI21X0P5H9R
XU2528 n2350 VDD VSS n1373 n926 NAND2X0P5H9R
XU2529 n2351 VDD VSS n1513 n1514 n1840 AOI21X0P5H9R
XU2530 n2352 VDD VSS n1374 n926 NAND2X0P5H9R
XU2531 u_mac16_top_u_mac_u_mul_pp_5__20_ VDD VSS n2208 n2061 NOR2X0P5H9R
XU2532 u_mac16_top_u_mac_u_mul_s11__19_ VDD VSS n1386 n1385 NOR2X0P5H9R
XU2534 n1385 VDD VSS u_mac16_top_opA_reg__15_ u_mac16_top_opB_reg__4_ u_mac16_top_opA_reg__14_ u_mac16_top_opB_reg__5_ AOI22X0P5H9R
XU2535 n2141 VDD VSS n2208 n2058 NOR2X0P5H9R
XU2537 u_mac16_top_u_mac_u_mul_s20__17_ VDD VSS n2069 n2068 XOR2X0P5H9R
XU2538 u_mac16_top_u_mac_u_mul_st1_0_gen_csa_fa_1__u_fa_N0 VDD VSS n2239 n1376 NOR2X0P5H9R
XU2539 n1376 VDD VSS u_mac16_top_opA_reg__0_ u_mac16_top_opB_reg__1_ u_mac16_top_opA_reg__1_ u_mac16_top_opB_reg__0_ AOI22X0P5H9R
XU2544 u_mac16_top_u_mac_u_mul_pp_0__0_ VDD VSS n2046 n2118 NOR2X0P5H9R
XU2547 u_mac16_top_u_mac_u_mul_c20__18_ VDD VSS n2072 n2068 n2073 OA21X0P5H9R
XU2550 n2074 VDD VSS u_mac16_top_opA_reg__15_ u_mac16_top_opB_reg__1_ u_mac16_top_opA_reg__14_ u_mac16_top_opB_reg__2_ AOI22X0P5H9R
XU2552 n1234 VDD VSS u_mac16_top_u_mac_u_mul_st1_1_gen_csa_fa_4__u_fa_N1 n1229 NOR2X0P5H9R
XU2553 n1229 VDD VSS u_mac16_top_opA_reg__0_ u_mac16_top_opB_reg__4_ u_mac16_top_opA_reg__1_ u_mac16_top_opB_reg__3_ AOI22X0P5H9R
XU2555 u_mac16_top_u_mac_u_mul_st2_0_gen_csa_fa_2__u_fa_N1 VDD VSS n2240 n2239 AND2X0P5H9R
XU2557 u_mac16_top_u_mac_u_mul_s21__23_ VDD VSS n2224 n1375 NOR2X0P5H9R
XU2558 n1375 VDD VSS u_mac16_top_opA_reg__15_ u_mac16_top_opB_reg__8_ NAND2X0P5H9R
XU2559 u_mac16_top_u_mac_u_mul_s21__21_ VDD VSS n2211 u_mac16_top_u_mac_u_mul_st2_1_gen_csa_fa_21__u_fa_N4 NOR2X0P5H9R
XU2561 n2211 VDD VSS n2210 n2209 NOR2X0P5H9R
XU2562 u_mac16_top_u_mac_u_mul_st1_1_gen_csa_fa_4__u_fa_N1 VDD VSS n1228 n1461 AND2X0P5H9R
XU2563 u_mac16_top_u_mac_u_mul_st2_1_gen_csa_fa_22__u_fa_N4 VDD VSS n2226 n2225 AND2X0P5H9R
XU2564 u_mac16_top_u_mac_u_mul_st2_1_gen_csa_fa_21__u_fa_N4 VDD VSS n2210 n2209 AND2X0P5H9R
XU2565 u_mac16_top_u_mac_u_mul_st2_1_gen_csa_fa_7__u_fa_N1 VDD VSS n2234 n2233 AND2X0P5H9R
XU2566 u_mac16_top_u_mac_u_mul_st2_1_gen_csa_fa_6__u_fa_N1 VDD VSS n2053 n1462 AND2X0P5H9R
XU2567 u_mac16_top_u_mac_u_mul_st1_3_gen_csa_fa_10__u_fa_N0 VDD VSS n2217 n1377 NOR2X0P5H9R
XU2568 n1377 VDD VSS u_mac16_top_opA_reg__0_ u_mac16_top_opB_reg__10_ u_mac16_top_opA_reg__1_ u_mac16_top_opB_reg__9_ AOI22X0P5H9R
XU2569 u_mac16_top_u_mac_u_mul_st2_2_gen_csa_fa_11__u_fa_N1 VDD VSS n2218 n2217 AND2X0P5H9R
XU2570 u_mac16_top_u_inA_N47 VDD VSS n1805 u_mac16_top_u_inA_shift_reg__13_ AND2X0P5H9R
XU2571 u_mac16_top_u_inA_N46 VDD VSS n1805 u_mac16_top_u_inA_shift_reg__12_ AND2X0P5H9R
XU2572 u_mac16_top_u_inA_N45 VDD VSS n1805 u_mac16_top_u_inA_shift_reg__11_ AND2X0P5H9R
XU2573 u_mac16_top_u_inA_N44 VDD VSS n1805 u_mac16_top_u_inA_shift_reg__10_ AND2X0P5H9R
XU2574 u_mac16_top_u_inA_N43 VDD VSS n1805 u_mac16_top_u_inA_shift_reg__9_ AND2X0P5H9R
XU2575 u_mac16_top_u_inA_N42 VDD VSS n1805 u_mac16_top_u_inA_shift_reg__8_ AND2X0P5H9R
XU2576 u_mac16_top_u_inA_N41 VDD VSS n1805 u_mac16_top_u_inA_shift_reg__7_ AND2X0P5H9R
XU2577 u_mac16_top_u_inA_N40 VDD VSS n1805 u_mac16_top_u_inA_shift_reg__6_ AND2X0P5H9R
XU2578 u_mac16_top_u_inA_N39 VDD VSS n1805 u_mac16_top_u_inA_shift_reg__5_ AND2X0P5H9R
XU2579 u_mac16_top_u_inA_N38 VDD VSS n1805 u_mac16_top_u_inA_shift_reg__4_ AND2X0P5H9R
XU2580 u_mac16_top_u_inA_N37 VDD VSS n1805 u_mac16_top_u_inA_shift_reg__3_ AND2X0P5H9R
XU2582 u_mac16_top_u_inA_N36 VDD VSS n1805 u_mac16_top_u_inA_shift_reg__2_ AND2X0P5H9R
XU2583 u_mac16_top_u_inA_N35 VDD VSS n1805 u_mac16_top_u_inA_shift_reg__1_ AND2X0P5H9R
XU2584 u_mac16_top_u_inA_N34 VDD VSS n1805 u_mac16_top_u_inA_shift_reg__0_ AND2X0P5H9R
XU2588 u_mac16_top_u_inA_N33 VDD VSS n1805 inA AND2X0P5H9R
XU2589 u_mac16_top_u_inA_N52 VDD VSS n2201 u_mac16_top_u_inA_cnt__3_ in_ready n2200 OA211X0P5H9R
XU2593 u_mac16_top_u_inA_N49 VDD VSS n1806 u_mac16_top_u_inA_cnt__0_ NOR2X0P5H9R
XU2595 n774 VDD VSS n1418 n1417 NAND2X0P5H9R
XU2598 n1417 VDD VSS n1416 u_mac16_top_opB_fifo_3__1_ n1421 u_mac16_top_opB_fifo_0__1_ AOI22X0P5H9R
XU2599 n1418 VDD VSS n1440 u_mac16_top_opB_fifo_2__1_ n2212 u_mac16_top_opB_fifo_1__1_ AOI22X0P5H9R
XU2624 n787 VDD VSS n1415 n1414 NAND2X0P5H9R
XU2625 n1414 VDD VSS n1442 u_mac16_top_opB_fifo_3__14_ n1421 u_mac16_top_opB_fifo_0__14_ AOI22X0P5H9R
XU2626 n1415 VDD VSS n1450 u_mac16_top_opB_fifo_2__14_ n1413 u_mac16_top_opB_fifo_1__14_ AOI22X0P5H9R
XU2627 u_mac16_top_N206 VDD VSS u_mac16_top_sched_cnt__1_ u_mac16_top_sched_cnt__2_ n1369 NOR3X0P5H9R
XU2628 u_mac16_top_N203 VDD VSS u_mac16_top_sched_cnt__1_ u_mac16_top_sched_cnt__0_ u_mac16_top_schedule_active n2197 OA211X0P5H9R
XU2629 u_mac16_top_N202 VDD VSS n1846 u_mac16_top_sched_cnt__0_ NOR2X0P5H9R
XU2631 u_mac16_top_u_inB_N47 VDD VSS n1801 u_mac16_top_u_inB_shift_reg__13_ AND2X0P5H9R
XU2632 u_mac16_top_u_inB_N46 VDD VSS n1801 u_mac16_top_u_inB_shift_reg__12_ AND2X0P5H9R
XU2634 u_mac16_top_u_inB_N45 VDD VSS n1801 u_mac16_top_u_inB_shift_reg__11_ AND2X0P5H9R
XU2635 u_mac16_top_u_inB_N44 VDD VSS n1801 u_mac16_top_u_inB_shift_reg__10_ AND2X0P5H9R
XU2636 u_mac16_top_u_inB_N43 VDD VSS n1801 u_mac16_top_u_inB_shift_reg__9_ AND2X0P5H9R
XU2637 u_mac16_top_u_inB_N42 VDD VSS n1801 u_mac16_top_u_inB_shift_reg__8_ AND2X0P5H9R
XU2638 u_mac16_top_u_inB_N41 VDD VSS n1801 u_mac16_top_u_inB_shift_reg__7_ AND2X0P5H9R
XU2639 u_mac16_top_u_inB_N40 VDD VSS n1801 u_mac16_top_u_inB_shift_reg__6_ AND2X0P5H9R
XU2640 u_mac16_top_u_inB_N39 VDD VSS n1801 u_mac16_top_u_inB_shift_reg__5_ AND2X0P5H9R
XU2641 u_mac16_top_u_inB_N38 VDD VSS n1801 u_mac16_top_u_inB_shift_reg__4_ AND2X0P5H9R
XU2642 u_mac16_top_u_inB_N37 VDD VSS n1801 u_mac16_top_u_inB_shift_reg__3_ AND2X0P5H9R
XU2643 u_mac16_top_u_inB_N36 VDD VSS n1801 u_mac16_top_u_inB_shift_reg__2_ AND2X0P5H9R
XU2645 u_mac16_top_u_inB_N35 VDD VSS n1801 u_mac16_top_u_inB_shift_reg__1_ AND2X0P5H9R
XU2646 u_mac16_top_u_inB_N34 VDD VSS n1801 u_mac16_top_u_inB_shift_reg__0_ AND2X0P5H9R
XU2647 u_mac16_top_u_inB_N33 VDD VSS n1801 inB AND2X0P5H9R
XU2648 u_mac16_top_u_inB_N52 VDD VSS n2199 u_mac16_top_u_inB_cnt__3_ in_ready n2198 OA211X0P5H9R
XU2650 u_mac16_top_u_inB_N49 VDD VSS n1802 u_mac16_top_u_inB_cnt__0_ NOR2X0P5H9R
Xu_mac16_top_clk_gate_fifo_count_reg_latch u_mac16_top_clk_gate_fifo_count_reg_net556 VDD VSS u_mac16_top_clk_gate_fifo_count_reg_net553 clk LATLQX0P5H9R
Xu_mac16_top_clk_gate_fifo_count_reg_test_or u_mac16_top_clk_gate_fifo_count_reg_net553 VDD VSS u_mac16_top_N117 optlc_net_102 OR2X0P5H9R
Xu_mac16_top_clk_gate_fifo_count_reg_main_gate u_mac16_top_net647 VDD VSS u_mac16_top_clk_gate_fifo_count_reg_net556 clk AND2X0P5H9R
Xu_mac16_top_clk_gate_opA_fifo_reg_3__latch u_mac16_top_clk_gate_opA_fifo_reg_3__net556 VDD VSS u_mac16_top_clk_gate_opA_fifo_reg_3__net553 clk LATLQX0P5H9R
Xu_mac16_top_clk_gate_opA_fifo_reg_3__test_or u_mac16_top_clk_gate_opA_fifo_reg_3__net553 VDD VSS u_mac16_top_N137 optlc_net_100 OR2X0P5H9R
Xu_mac16_top_clk_gate_opA_fifo_reg_3__main_gate u_mac16_top_net642 VDD VSS u_mac16_top_clk_gate_opA_fifo_reg_3__net556 clk AND2X3H9R
Xu_mac16_top_clk_gate_opA_fifo_reg_2__latch u_mac16_top_clk_gate_opA_fifo_reg_2__net556 VDD VSS u_mac16_top_clk_gate_opA_fifo_reg_2__net553 clk LATLQX0P5H9R
Xu_mac16_top_clk_gate_opA_fifo_reg_2__test_or u_mac16_top_clk_gate_opA_fifo_reg_2__net553 VDD VSS u_mac16_top_N138 optlc_net_100 OR2X0P5H9R
Xu_mac16_top_clk_gate_opA_fifo_reg_2__main_gate u_mac16_top_net637 VDD VSS u_mac16_top_clk_gate_opA_fifo_reg_2__net556 clk AND2X3H9R
Xu_mac16_top_clk_gate_opA_fifo_reg_1__latch u_mac16_top_clk_gate_opA_fifo_reg_1__net556 VDD VSS u_mac16_top_clk_gate_opA_fifo_reg_1__net553 clk LATLQX0P5H9R
Xu_mac16_top_clk_gate_opA_fifo_reg_1__test_or u_mac16_top_clk_gate_opA_fifo_reg_1__net553 VDD VSS u_mac16_top_N139 optlc_net_100 OR2X0P5H9R
Xu_mac16_top_clk_gate_opA_fifo_reg_1__main_gate u_mac16_top_net632 VDD VSS u_mac16_top_clk_gate_opA_fifo_reg_1__net556 clk AND2X3H9R
Xu_mac16_top_clk_gate_opA_fifo_reg_0__latch u_mac16_top_clk_gate_opA_fifo_reg_0__net556 VDD VSS u_mac16_top_clk_gate_opA_fifo_reg_0__net553 clk LATLQX0P5H9R
Xu_mac16_top_clk_gate_opA_fifo_reg_0__test_or u_mac16_top_clk_gate_opA_fifo_reg_0__net553 VDD VSS u_mac16_top_N140 optlc_net_100 OR2X0P5H9R
Xu_mac16_top_clk_gate_opA_fifo_reg_0__main_gate u_mac16_top_net627 VDD VSS u_mac16_top_clk_gate_opA_fifo_reg_0__net556 clk AND2X3H9R
Xu_mac16_top_clk_gate_mac_result_shadow_reg_latch u_mac16_top_clk_gate_mac_result_shadow_reg_net556 VDD VSS u_mac16_top_clk_gate_mac_result_shadow_reg_net553 clk LATLQX0P5H9R
Xu_mac16_top_clk_gate_mac_result_shadow_reg_test_or u_mac16_top_clk_gate_mac_result_shadow_reg_net553 VDD VSS u_mac16_top_N91 optlc_net_102 OR2X0P5H9R
Xu_mac16_top_clk_gate_mac_result_shadow_reg_main_gate u_mac16_top_net622 VDD VSS u_mac16_top_clk_gate_mac_result_shadow_reg_net556 clk AND2X2H9R
Xu_mac16_top_clk_gate_op_fifo_count_reg_latch u_mac16_top_clk_gate_op_fifo_count_reg_net556 VDD VSS u_mac16_top_clk_gate_op_fifo_count_reg_net553 clk LATLQX0P5H9R
Xu_mac16_top_clk_gate_op_fifo_count_reg_test_or u_mac16_top_clk_gate_op_fifo_count_reg_net553 VDD VSS u_mac16_top_net605 optlc_net_100 OR2X0P5H9R
Xu_mac16_top_clk_gate_op_fifo_count_reg_main_gate u_mac16_top_net617 VDD VSS u_mac16_top_clk_gate_op_fifo_count_reg_net556 clk AND2X0P5H9R
Xu_mac16_top_clk_gate_result_fifo_reg_3__latch u_mac16_top_clk_gate_result_fifo_reg_3__net556 VDD VSS u_mac16_top_clk_gate_result_fifo_reg_3__net553 clk LATLQX0P5H9R
Xu_mac16_top_clk_gate_result_fifo_reg_3__test_or u_mac16_top_clk_gate_result_fifo_reg_3__net553 VDD VSS u_mac16_top_N121 optlc_net_102 OR2X0P5H9R
Xu_mac16_top_clk_gate_result_fifo_reg_3__main_gate u_mac16_top_net595 VDD VSS u_mac16_top_clk_gate_result_fifo_reg_3__net556 clk AND2X2H9R
Xu_mac16_top_clk_gate_result_fifo_reg_2__latch u_mac16_top_clk_gate_result_fifo_reg_2__net556 VDD VSS u_mac16_top_clk_gate_result_fifo_reg_2__net553 clk LATLQX0P5H9R
Xu_mac16_top_clk_gate_result_fifo_reg_2__test_or u_mac16_top_clk_gate_result_fifo_reg_2__net553 VDD VSS u_mac16_top_N122 optlc_net_102 OR2X0P5H9R
Xu_mac16_top_clk_gate_result_fifo_reg_2__main_gate u_mac16_top_net590 VDD VSS u_mac16_top_clk_gate_result_fifo_reg_2__net556 clk AND2X2H9R
Xu_mac16_top_clk_gate_result_fifo_reg_1__latch u_mac16_top_clk_gate_result_fifo_reg_1__net556 VDD VSS u_mac16_top_clk_gate_result_fifo_reg_1__net553 clk LATLQX0P5H9R
Xu_mac16_top_clk_gate_result_fifo_reg_1__test_or u_mac16_top_clk_gate_result_fifo_reg_1__net553 VDD VSS u_mac16_top_N123 optlc_net_102 OR2X0P5H9R
Xu_mac16_top_clk_gate_result_fifo_reg_1__main_gate u_mac16_top_net585 VDD VSS u_mac16_top_clk_gate_result_fifo_reg_1__net556 clk AND2X2H9R
Xu_mac16_top_clk_gate_result_fifo_reg_0__latch u_mac16_top_clk_gate_result_fifo_reg_0__net556 VDD VSS u_mac16_top_clk_gate_result_fifo_reg_0__net553 clk LATLQX0P5H9R
Xu_mac16_top_clk_gate_result_fifo_reg_0__test_or u_mac16_top_clk_gate_result_fifo_reg_0__net553 VDD VSS u_mac16_top_N124 optlc_net_102 OR2X0P5H9R
Xu_mac16_top_clk_gate_result_fifo_reg_0__main_gate u_mac16_top_net580 VDD VSS u_mac16_top_clk_gate_result_fifo_reg_0__net556 clk AND2X1P4H9R
Xu_mac16_top_clk_gate_sched_cnt_reg_latch u_mac16_top_clk_gate_sched_cnt_reg_net556 VDD VSS u_mac16_top_clk_gate_sched_cnt_reg_net553 clk LATLQX0P5H9R
Xu_mac16_top_clk_gate_sched_cnt_reg_test_or u_mac16_top_clk_gate_sched_cnt_reg_net553 VDD VSS u_mac16_top_N205 optlc_net_100 OR2X0P5H9R
Xu_mac16_top_clk_gate_sched_cnt_reg_main_gate u_mac16_top_net575 VDD VSS u_mac16_top_clk_gate_sched_cnt_reg_net556 clk AND2X0P5H9R
Xu_mac16_top_clk_gate_op_fifo_rd_ptr_reg_latch u_mac16_top_clk_gate_op_fifo_rd_ptr_reg_net556 VDD VSS u_mac16_top_clk_gate_op_fifo_rd_ptr_reg_net553 clk LATLQX0P5H9R
Xu_mac16_top_clk_gate_op_fifo_rd_ptr_reg_test_or u_mac16_top_clk_gate_op_fifo_rd_ptr_reg_net553 VDD VSS n2339 optlc_net_100 OR2X0P5H9R
Xu_mac16_top_clk_gate_op_fifo_rd_ptr_reg_main_gate u_mac16_top_net570 VDD VSS u_mac16_top_clk_gate_op_fifo_rd_ptr_reg_net556 clk AND2X1H9R
Xu_mac16_top_clk_gate_opB_reg_reg_latch u_mac16_top_clk_gate_opB_reg_reg_net556 VDD VSS u_mac16_top_clk_gate_opB_reg_reg_net553 clk LATLQX0P5H9R
Xu_mac16_top_clk_gate_opB_reg_reg_test_or u_mac16_top_clk_gate_opB_reg_reg_net553 VDD VSS n2339 optlc_net_100 OR2X0P5H9R
Xu_mac16_top_clk_gate_opB_reg_reg_main_gate u_mac16_top_net564 VDD VSS u_mac16_top_clk_gate_opB_reg_reg_net556 clk AND2X1P4H9R
Xu_mac16_top_u_mac_clk_gate_last_prod_reg_latch u_mac16_top_u_mac_clk_gate_last_prod_reg_net674 VDD VSS u_mac16_top_u_mac_clk_gate_last_prod_reg_net671 clk LATLQX0P5H9R
Xu_mac16_top_u_mac_clk_gate_last_prod_reg_test_or u_mac16_top_u_mac_clk_gate_last_prod_reg_net671 VDD VSS u_mac16_top_u_mac_N59 optlc_net_101 OR2X0P5H9R
Xu_mac16_top_u_mac_clk_gate_last_prod_reg_main_gate u_mac16_top_u_mac_net693 VDD VSS u_mac16_top_u_mac_clk_gate_last_prod_reg_net674 clk AND2X1P4H9R
Xu_mac16_top_u_mac_clk_gate_sum_out_reg_latch u_mac16_top_u_mac_clk_gate_sum_out_reg_net674 VDD VSS u_mac16_top_u_mac_clk_gate_sum_out_reg_net671 clk LATLQX0P5H9R
Xu_mac16_top_u_mac_clk_gate_sum_out_reg_test_or u_mac16_top_u_mac_clk_gate_sum_out_reg_net671 VDD VSS u_mac16_top_u_mac_mult_valid optlc_net_102 OR2X0P5H9R
Xu_mac16_top_u_mac_clk_gate_sum_out_reg_main_gate u_mac16_top_u_mac_net688 VDD VSS u_mac16_top_u_mac_clk_gate_sum_out_reg_net674 clk AND2X1P4H9R
Xu_mac16_top_u_mac_clk_gate_accum_reg_reg_latch u_mac16_top_u_mac_clk_gate_accum_reg_reg_net674 VDD VSS u_mac16_top_u_mac_clk_gate_accum_reg_reg_net671 clk LATLQX0P5H9R
Xu_mac16_top_u_mac_clk_gate_accum_reg_reg_test_or u_mac16_top_u_mac_clk_gate_accum_reg_reg_net671 VDD VSS u_mac16_top_u_mac_N58 optlc_net_101 OR2X0P5H9R
Xu_mac16_top_u_mac_clk_gate_accum_reg_reg_main_gate u_mac16_top_u_mac_net682 VDD VSS u_mac16_top_u_mac_clk_gate_accum_reg_reg_net674 clk AND2X2H9R
Xu_mac16_top_u_out_clk_gate_bits_left_reg_latch u_mac16_top_u_out_clk_gate_bits_left_reg_net656 VDD VSS u_mac16_top_u_out_clk_gate_bits_left_reg_net653 clk LATLQX0P5H9R
Xu_mac16_top_u_out_clk_gate_bits_left_reg_test_or u_mac16_top_u_out_clk_gate_bits_left_reg_net653 VDD VSS n732 optlc_net_102 OR2X0P5H9R
Xu_mac16_top_u_out_clk_gate_bits_left_reg_main_gate u_mac16_top_u_out_net664 VDD VSS u_mac16_top_u_out_clk_gate_bits_left_reg_net656 clk AND2X2H9R
Xu_mac16_top_u_inB_clk_gate_data_out_reg_latch u_mac16_top_u_inB_clk_gate_data_out_reg_net795 VDD VSS u_mac16_top_u_inB_clk_gate_data_out_reg_net792 clk LATLQX0P5H9R
Xu_mac16_top_u_inB_clk_gate_data_out_reg_test_or u_mac16_top_u_inB_clk_gate_data_out_reg_net792 VDD VSS u_mac16_top_u_inB_N48 optlc_net_103 OR2X0P5H9R
Xu_mac16_top_u_inB_clk_gate_data_out_reg_main_gate u_mac16_top_u_inB_net803 VDD VSS u_mac16_top_u_inB_clk_gate_data_out_reg_net795 clk AND2X1H9R
Xu_mac16_top_u_inA_clk_gate_data_out_reg_latch u_mac16_top_u_inA_clk_gate_data_out_reg_net795 VDD VSS u_mac16_top_u_inA_clk_gate_data_out_reg_net792 clk LATLQX0P5H9R
Xu_mac16_top_u_inA_clk_gate_data_out_reg_test_or u_mac16_top_u_inA_clk_gate_data_out_reg_net792 VDD VSS u_mac16_top_u_inA_N48 optlc_net_103 OR2X0P5H9R
Xu_mac16_top_u_inA_clk_gate_data_out_reg_main_gate u_mac16_top_u_inA_net803 VDD VSS u_mac16_top_u_inA_clk_gate_data_out_reg_net795 clk AND2X1H9R
Xu_mac16_top_u_mac_u_mul_clk_gate_r_c40_reg_latch u_mac16_top_u_mac_u_mul_clk_gate_r_c40_reg_net702 VDD VSS u_mac16_top_u_mac_u_mul_clk_gate_r_c40_reg_net699 clk LATLQX0P5H9R
Xu_mac16_top_u_mac_u_mul_clk_gate_r_c40_reg_test_or u_mac16_top_u_mac_u_mul_clk_gate_r_c40_reg_net699 VDD VSS u_mac16_top_u_mac_u_mul_en_d2 optlc_net_99 OR2X0P5H9R
Xu_mac16_top_u_mac_u_mul_clk_gate_r_c40_reg_main_gate u_mac16_top_u_mac_u_mul_net786 VDD VSS u_mac16_top_u_mac_u_mul_clk_gate_r_c40_reg_net702 clk AND2X2H9R
Xu_mac16_top_u_mac_u_mul_clk_gate_r_s40_reg_latch u_mac16_top_u_mac_u_mul_clk_gate_r_s40_reg_net702 VDD VSS u_mac16_top_u_mac_u_mul_clk_gate_r_s40_reg_net699 clk LATLQX0P5H9R
Xu_mac16_top_u_mac_u_mul_clk_gate_r_s40_reg_test_or u_mac16_top_u_mac_u_mul_clk_gate_r_s40_reg_net699 VDD VSS u_mac16_top_u_mac_u_mul_en_d2 optlc_net_99 OR2X0P5H9R
Xu_mac16_top_u_mac_u_mul_clk_gate_r_s40_reg_main_gate u_mac16_top_u_mac_u_mul_net781 VDD VSS u_mac16_top_u_mac_u_mul_clk_gate_r_s40_reg_net702 clk AND2X1P4H9R
Xu_mac16_top_u_mac_u_mul_clk_gate_r_s41_reg_latch u_mac16_top_u_mac_u_mul_clk_gate_r_s41_reg_net702 VDD VSS u_mac16_top_u_mac_u_mul_clk_gate_r_s41_reg_net699 clk LATLQX0P5H9R
Xu_mac16_top_u_mac_u_mul_clk_gate_r_s41_reg_test_or u_mac16_top_u_mac_u_mul_clk_gate_r_s41_reg_net699 VDD VSS u_mac16_top_u_mac_u_mul_en_d2 optlc_net_99 OR2X0P5H9R
Xu_mac16_top_u_mac_u_mul_clk_gate_r_s41_reg_main_gate u_mac16_top_u_mac_u_mul_net771 VDD VSS u_mac16_top_u_mac_u_mul_clk_gate_r_s41_reg_net702 clk AND2X2H9R
Xu_mac16_top_u_mac_u_mul_clk_gate_r_s30_reg_latch u_mac16_top_u_mac_u_mul_clk_gate_r_s30_reg_net702 VDD VSS u_mac16_top_u_mac_u_mul_clk_gate_r_s30_reg_net699 clk LATLQX0P5H9R
Xu_mac16_top_u_mac_u_mul_clk_gate_r_s30_reg_test_or u_mac16_top_u_mac_u_mul_clk_gate_r_s30_reg_net699 VDD VSS u_mac16_top_u_mac_u_mul_en_d1 optlc_net_99 OR2X0P5H9R
Xu_mac16_top_u_mac_u_mul_clk_gate_r_s30_reg_main_gate u_mac16_top_u_mac_u_mul_net761 VDD VSS u_mac16_top_u_mac_u_mul_clk_gate_r_s30_reg_net702 clk AND2X1P4H9R
Xu_mac16_top_u_mac_u_mul_clk_gate_r_c31_reg_latch u_mac16_top_u_mac_u_mul_clk_gate_r_c31_reg_net702 VDD VSS u_mac16_top_u_mac_u_mul_clk_gate_r_c31_reg_net699 clk LATLQX0P5H9R
Xu_mac16_top_u_mac_u_mul_clk_gate_r_c31_reg_test_or u_mac16_top_u_mac_u_mul_clk_gate_r_c31_reg_net699 VDD VSS u_mac16_top_u_mac_u_mul_en_d1 optlc_net_99 OR2X0P5H9R
Xu_mac16_top_u_mac_u_mul_clk_gate_r_c31_reg_main_gate u_mac16_top_u_mac_u_mul_net756 VDD VSS u_mac16_top_u_mac_u_mul_clk_gate_r_c31_reg_net702 clk AND2X1P4H9R
Xu_mac16_top_u_mac_u_mul_clk_gate_r_s31_reg_latch u_mac16_top_u_mac_u_mul_clk_gate_r_s31_reg_net702 VDD VSS u_mac16_top_u_mac_u_mul_clk_gate_r_s31_reg_net699 clk LATLQX0P5H9R
Xu_mac16_top_u_mac_u_mul_clk_gate_r_s31_reg_test_or u_mac16_top_u_mac_u_mul_clk_gate_r_s31_reg_net699 VDD VSS u_mac16_top_u_mac_u_mul_en_d1 optlc_net_101 OR2X0P5H9R
Xu_mac16_top_u_mac_u_mul_clk_gate_r_s31_reg_main_gate u_mac16_top_u_mac_u_mul_net751 VDD VSS u_mac16_top_u_mac_u_mul_clk_gate_r_s31_reg_net702 clk AND2X1P4H9R
Xu_mac16_top_u_mac_u_mul_clk_gate_r_s22_reg_latch u_mac16_top_u_mac_u_mul_clk_gate_r_s22_reg_net702 VDD VSS u_mac16_top_u_mac_u_mul_clk_gate_r_s22_reg_net699 clk LATLQX0P5H9R
Xu_mac16_top_u_mac_u_mul_clk_gate_r_s22_reg_test_or u_mac16_top_u_mac_u_mul_clk_gate_r_s22_reg_net699 VDD VSS u_mac16_top_calc_start optlc_net_101 OR2X0P5H9R
Xu_mac16_top_u_mac_u_mul_clk_gate_r_s22_reg_main_gate u_mac16_top_u_mac_u_mul_net741 VDD VSS u_mac16_top_u_mac_u_mul_clk_gate_r_s22_reg_net702 clk AND2X3H9R
Xu_mac16_top_u_mac_u_mul_clk_gate_r_c21_reg_latch u_mac16_top_u_mac_u_mul_clk_gate_r_c21_reg_net702 VDD VSS u_mac16_top_u_mac_u_mul_clk_gate_r_c21_reg_net699 clk LATLQX0P5H9R
Xu_mac16_top_u_mac_u_mul_clk_gate_r_c21_reg_test_or u_mac16_top_u_mac_u_mul_clk_gate_r_c21_reg_net699 VDD VSS u_mac16_top_calc_start optlc_net_101 OR2X0P5H9R
Xu_mac16_top_u_mac_u_mul_clk_gate_r_c21_reg_main_gate u_mac16_top_u_mac_u_mul_net736 VDD VSS u_mac16_top_u_mac_u_mul_clk_gate_r_c21_reg_net702 clk AND2X2H9R
Xu_mac16_top_u_mac_u_mul_clk_gate_r_s21_reg_latch u_mac16_top_u_mac_u_mul_clk_gate_r_s21_reg_net702 VDD VSS u_mac16_top_u_mac_u_mul_clk_gate_r_s21_reg_net699 clk LATLQX0P5H9R
Xu_mac16_top_u_mac_u_mul_clk_gate_r_s21_reg_test_or u_mac16_top_u_mac_u_mul_clk_gate_r_s21_reg_net699 VDD VSS u_mac16_top_calc_start optlc_net_101 OR2X0P5H9R
Xu_mac16_top_u_mac_u_mul_clk_gate_r_s21_reg_main_gate u_mac16_top_u_mac_u_mul_net731 VDD VSS u_mac16_top_u_mac_u_mul_clk_gate_r_s21_reg_net702 clk AND2X3H9R
Xu_mac16_top_u_mac_u_mul_clk_gate_r_s20_reg_latch u_mac16_top_u_mac_u_mul_clk_gate_r_s20_reg_net702 VDD VSS u_mac16_top_u_mac_u_mul_clk_gate_r_s20_reg_net699 clk LATLQX0P5H9R
Xu_mac16_top_u_mac_u_mul_clk_gate_r_s20_reg_test_or u_mac16_top_u_mac_u_mul_clk_gate_r_s20_reg_net699 VDD VSS u_mac16_top_calc_start optlc_net_101 OR2X0P5H9R
Xu_mac16_top_u_mac_u_mul_clk_gate_r_s20_reg_main_gate u_mac16_top_u_mac_u_mul_net721 VDD VSS u_mac16_top_u_mac_u_mul_clk_gate_r_s20_reg_net702 clk AND2X2H9R
Xu_mac16_top_u_mac_u_mul_r_c40_reg_13_ u_mac16_top_u_mac_u_mul_r_c40__13_ VDD VSS u_mac16_top_u_mac_u_mul_net786 n2382 n2367 DFFSQNX1H9R
Xu_mac16_top_u_mac_last_prod_reg_20_ u_mac16_top_u_mac_last_prod__20_ VDD VSS u_mac16_top_u_mac_net693 u_mac16_top_u_mac_mult_result__20_ HFSNET_32 DFFRPQX0P5H9R
Xu_mac16_top_mac_result_shadow_reg_19_ u_mac16_top_mac_result_shadow__19_ VDD VSS u_mac16_top_net622 u_mac16_top_N111 HFSNET_24 DFFRPQX0P5H9R
XU1121 n1207 VDD VSS n1527 n876 NAND2X1P4H9R
XU1120 n1191 VDD VSS n1189 n1207 NOR2X0P7H9R
XU1135 n1212 VDD VSS n1182 n1183 NAND2X0P5H9R
XU1119 n892 VDD VSS n1187 n1186 NOR2X0P7H9R
XU1559 n1188 VDD VSS n892 n1212 NAND2X0P7H9R
XU1118 n1213 VDD VSS n1182 n1183 OR2X0P5H9R
XU1682 n1189 VDD VSS n1347 n1212 NAND2X1H9R
XU2308 n1190 VDD VSS n1189 n1349 n1213 n1188 OAI211X1H9R
XU1116 n863 VDD VSS n1190 n1191 NOR2X0P5H9R
XU1112 n1192 VDD VSS n1342 n1189 NOR2X1H9R
XU1111 n862 VDD VSS n1532 n1192 n1525 NAND3X0P7H9R
XU1109 n860 VDD VSS n862 n863 n846 NAND3X2H9R
XU2310 u_mac16_top_u_mac_u_mul_r_s40__22_ u_mac16_top_u_mac_u_mul_r_s41__22_ u_mac16_top_u_mac_u_mul_r_c40__22_ n1197 VDD VSS MAOI222X0P5H9R
XU1705 n1196 VDD VSS u_mac16_top_u_mac_u_mul_r_s41__23_ u_mac16_top_u_mac_u_mul_r_c40__23_ XOR2X0P5H9R
XU2092 n1198 VDD VSS n1196 u_mac16_top_u_mac_u_mul_r_s40__23_ u_mac16_top_u_mac_u_mul_r_c41__23_ XNOR3X0P5H9R
XU2297 n1193 VDD VSS u_mac16_top_u_mac_u_mul_r_c40__21_ u_mac16_top_u_mac_u_mul_r_s41__21_ u_mac16_top_u_mac_u_mul_r_s40__21_ CGENCONAX1H9R
XU1706 n1195 VDD VSS n1193 INVX0P5H9R
XU2309 n1199 VDD VSS u_mac16_top_u_mac_u_mul_r_c41__22_ n1195 n1194 CGENCONAX1H9R
XU1106 n1200 VDD VSS n1199 n1198 n1197 XNOR3X0P5H9R
XU1102 u_mac16_top_u_mac_u_mul_N56 VDD VSS n860 n1200 XOR2X1P4H9R
XU1085 n1477 VDD VSS n1132 n1131 NAND2X0P7H9R
XctmTdsLR_2_87 u_mac16_top_u_mac_u_mul_N51 VDD VSS n861 tmp_net16 XNOR2X2H9R
XU1142 n1478 VDD VSS n923 n1547 NOR2X1H9R
XU1353 n920 VDD VSS n1478 n921 n865 AOI21X2H9R
XU1097 n1546 VDD VSS n883 n1547 NAND2X1P4H9R
XU1076 n1476 VDD VSS n1132 n1131 NOR2X1P4H9R
XU1134 n872 VDD VSS n890 n1552 NAND2X2H9R
XU1086 n1532 VDD VSS n919 n920 NAND2X3H9R
XU1571 n890 VDD VSS n1553 n1551 NOR2X1P4H9R
XU1648 n1118 VDD VSS n899 n1108 NOR2X2H9R
XU1126 n2354 VDD VSS n872 n873 NAND2X1H9R
XU1088 n1545 VDD VSS n872 n873 NAND2X1P4H9R
XU1581 n1554 VDD VSS n1122 n1118 NAND2X0P7H9R
XU1603 n1550 VDD VSS n891 n1116 NAND2X1P4H9R
XU1748 n1553 VDD VSS n887 n1118 NOR2X1H9R
XU1237 n1117 VDD VSS u_mac16_top_u_mac_u_mul_r_s40__10_ u_mac16_top_u_mac_u_mul_r_s41__10_ XOR2X1H9R
XU1150 n906 VDD VSS n856 ZBUF_69_7 NAND2X1H9R
XU1605 n858 VDD VSS n1111 ZBUF_69_7 n906 OAI21X1P4H9R
XU1258 n887 VDD VSS n858 n1117 XOR2X0P7H9R
Xu_mac16_top_u_mac_u_mul_product_reg_reg_23_ u_mac16_top_u_mac_mult_result__23_ VDD VSS clk u_mac16_top_u_mac_u_mul_N56 HFSNET_32 DFFRPQX0P5H9R
Xu_mac16_top_fifo_count_reg_1_ u_mac16_top_fifo_count__1_ VDD VSS u_mac16_top_net647 n2346 HFSNET_25 DFFRPQX0P5H9R
Xu_mac16_top_u_mac_accum_reg_reg_6_ u_mac16_top_u_mac_accum_reg__6_ VDD VSS u_mac16_top_u_mac_net682 u_mac16_top_u_mac_add_tmp_comb__6_ HFSNET_20 DFFRPQX0P5H9R
Xu_mac16_top_u_mac_u_mul_r_c40_reg_10_ u_mac16_top_u_mac_u_mul_r_c40__10_ VDD VSS u_mac16_top_u_mac_u_mul_net786 n2276 HFSNET_30 DFFRPQX0P5H9R
Xu_mac16_top_u_mac_u_mul_product_reg_reg_12_ u_mac16_top_u_mac_mult_result__12_ VDD VSS clk u_mac16_top_u_mac_u_mul_N45 HFSNET_32 DFFRPQX0P5H9R
Xu_mac16_top_u_mac_u_mul_r_s41_reg_12_ u_mac16_top_u_mac_u_mul_r_s41__12_ VDD VSS u_mac16_top_u_mac_u_mul_net771 u_mac16_top_u_mac_u_mul_r_c31__12_ HFSNET_4 DFFRPQX0P5H9R
Xu_mac16_top_u_mac_u_mul_r_s22_reg_13_ u_mac16_top_u_mac_u_mul_r_s22__13_ VDD VSS u_mac16_top_u_mac_u_mul_net741 u_mac16_top_u_mac_u_mul_s22_13_ HFSNET_5 DFFRPQX0P5H9R
Xu_mac16_top_u_mac_u_mul_product_reg_reg_4_ u_mac16_top_u_mac_mult_result__4_ VDD VSS clk u_mac16_top_u_mac_u_mul_N37 HFSNET_32 DFFRPQX0P5H9R
Xu_mac16_top_u_mac_u_mul_product_reg_reg_5_ u_mac16_top_u_mac_mult_result__5_ VDD VSS clk u_mac16_top_u_mac_u_mul_N38 HFSNET_32 DFFRPQX0P5H9R
Xu_mac16_top_u_mac_u_mul_product_reg_reg_22_ u_mac16_top_u_mac_mult_result__22_ VDD VSS clk u_mac16_top_u_mac_u_mul_N55 HFSNET_32 DFFRPQX0P5H9R
Xu_mac16_top_u_mac_u_mul_r_s41_reg_22_ u_mac16_top_u_mac_u_mul_r_s41__22_ VDD VSS u_mac16_top_u_mac_u_mul_net771 u_mac16_top_u_mac_u_mul_s41__22_ HFSNET_30 DFFRPQX0P5H9R
Xu_mac16_top_u_mac_u_mul_r_s21_reg_11_ u_mac16_top_u_mac_u_mul_r_s21__11_ VDD VSS u_mac16_top_u_mac_u_mul_net731 n755 HFSNET_20 DFFRPQX0P5H9R
Xu_mac16_top_u_mac_u_mul_r_s21_reg_12_ u_mac16_top_u_mac_u_mul_r_s21__12_ VDD VSS u_mac16_top_u_mac_u_mul_net731 n754 HFSNET_18 DFFRPQX0P5H9R
Xu_mac16_top_u_mac_u_mul_r_s21_reg_13_ u_mac16_top_u_mac_u_mul_r_s21__13_ VDD VSS u_mac16_top_u_mac_u_mul_net731 n753 HFSNET_18 DFFRPQX0P5H9R
Xu_mac16_top_u_mac_u_mul_r_s41_reg_10_ u_mac16_top_u_mac_u_mul_r_s41__10_ VDD VSS u_mac16_top_u_mac_u_mul_net771 u_mac16_top_u_mac_u_mul_r_c31__10_ HFSNET_30 DFFRPQX1H9R
Xu_mac16_top_u_mac_u_mul_r_s40_reg_21_ u_mac16_top_u_mac_u_mul_r_s40__21_ VDD VSS u_mac16_top_u_mac_u_mul_net781 u_mac16_top_u_mac_u_mul_s40__21_ HFSNET_30 DFFRPQX0P5H9R
Xu_mac16_top_u_mac_u_mul_r_c40_reg_22_ u_mac16_top_u_mac_u_mul_r_c40__22_ VDD VSS u_mac16_top_u_mac_u_mul_net786 n2287 HFSNET_30 DFFRPQX0P5H9R
Xu_mac16_top_u_mac_u_mul_product_reg_reg_20_ u_mac16_top_u_mac_mult_result__20_ VDD VSS clk ZBUF_2_10 HFSNET_32 DFFRPQX0P5H9R
Xu_mac16_top_u_mac_u_mul_product_reg_reg_21_ u_mac16_top_u_mac_mult_result__21_ VDD VSS clk u_mac16_top_u_mac_u_mul_N54 HFSNET_32 DFFRPQX0P5H9R
Xu_mac16_top_u_mac_u_mul_r_c40_reg_21_ u_mac16_top_u_mac_u_mul_r_c40__21_ VDD VSS u_mac16_top_u_mac_u_mul_net786 n2286 HFSNET_30 DFFRPQX0P5H9R
Xu_mac16_top_u_mac_u_mul_r_s20_reg_5_ u_mac16_top_u_mac_u_mul_r_s20__5_ VDD VSS u_mac16_top_u_mac_u_mul_net721 n744 HFSNET_6 DFFRPQX0P5H9R
Xu_mac16_top_u_mac_last_prod_reg_4_ u_mac16_top_u_mac_last_prod__4_ VDD VSS u_mac16_top_u_mac_net693 n2384 n2367 DFFSQNX0P5H9R
Xu_mac16_top_u_mac_last_prod_reg_6_ u_mac16_top_u_mac_last_prod__6_ VDD VSS u_mac16_top_u_mac_net693 n2383 n2367 DFFSQNX0P5H9R
XU1051 u_mac16_top_u_mac_u_mul_r_s31__12_ u_mac16_top_u_mac_u_mul_r_c30__12_ u_mac16_top_u_mac_u_mul_r_s30__12_ n2382 VDD VSS MAOI222X0P5H9R
XU1059 n2383 VDD VSS u_mac16_top_u_mac_mult_result__6_ INVX0P5H9R
XU1060 n2384 VDD VSS u_mac16_top_u_mac_mult_result__4_ INVX0P5H9R
XU1061 n847 VDD VSS n1532 INVX2H9R
XU1062 n2385 VDD VSS n1130 n902 NOR2X1P4H9R
XU1065 n1480 VDD VSS n1130 n902 NOR2X1H9R
XU1075 n1111 VDD VSS ZBUF_59_10 u_mac16_top_u_mac_u_mul_r_s40__9_ NAND2X2H9R
XU1081 n1913 VDD VSS n1881 n2107 NOR2X0P7H9R
XU1087 n1881 VDD VSS u_mac16_top_opB_reg__12_ INVX0P5H9R
XU1090 n987 VDD VSS n1252 n1304 n1253 OAI21X0P5H9R
XU1094 n2365 VDD VSS u_mac16_top_u_mac_u_mul_r_c40__17_ ZBUF_17_14 u_mac16_top_u_mac_u_mul_r_s41__17_ CGENX1P4H9R
XU1098 n1173 VDD VSS n1533 n1352 n1353 OAI21X1H9R
XU1099 n1720 VDD VSS u_mac16_top_u_mac_mult_result__6_ u_mac16_top_u_mac_last_prod__6_ NAND2X0P7H9R
XU1101 n1307 VDD VSS n950 n1306 XOR2X0P5H9R
XU1103 n2072 VDD VSS n1974 n2120 NOR2X0P7H9R
XU1110 n1172 VDD VSS n1151 n1152 n1150 CGENCONAX1H9R
XU1114 n2387 VDD VSS n1489 n1169 n879 OAI21X0P5H9R
XU1128 n1168 VDD VSS n841 n1165 NAND2X1H9R
XU1146 n1489 VDD VSS n1164 n1163 NAND2X1H9R
XU1148 n1485 VDD VSS n1563 n1564 NOR2X1H9R
XU1152 n1563 VDD VSS u_mac16_top_u_mac_u_mul_r_s40__6_ u_mac16_top_u_mac_u_mul_r_c40__6_ XNOR2X0P7H9R
XU1155 n1742 VDD VSS u_mac16_top_u_mac_mult_result__5_ u_mac16_top_u_mac_accum_reg__5_ NOR2X0P5H9R
XU1165 n994 VDD VSS n1710 n1727 n1711 OAI21X0P5H9R
XU1167 n1726 VDD VSS u_mac16_top_u_mac_mult_result__6_ u_mac16_top_u_mac_accum_reg__6_ NOR2X0P7H9R
XU1179 n1524 VDD VSS n1209 INVX1P7H9R
XU1181 n1494 VDD VSS n1496 n1495 NAND2X0P5H9R
XU1188 n1740 VDD VSS u_mac16_top_u_mac_mult_result__4_ u_mac16_top_u_mac_accum_reg__4_ NOR2X0P7H9R
XU1189 n856 VDD VSS ZBUF_59_10 u_mac16_top_u_mac_u_mul_r_s40__9_ NAND2X0P7H9R
XU1193 n1547 VDD VSS n1127 n1126 XNOR2X2H9R
XU1196 n921 VDD VSS n1480 n1476 NOR2X0P5H9R
XU1198 n865 VDD VSS n2385 n1477 n922 OAI21X0P7H9R
XU1201 n922 VDD VSS n902 n1130 NAND2X0P7H9R
XU1207 n846 VDD VSS n1192 n1524 NAND2X0P5H9R
XU1221 n1719 VDD VSS u_mac16_top_u_mac_mult_result__6_ u_mac16_top_u_mac_last_prod__6_ NOR2X1H9R
XU1222 n2194 VDD VSS n2190 u_mac16_top_mac_result__23_ n2146 u_mac16_top_result_fifo_0__23_ AOI22X0P5H9R
XU1223 u_mac16_top_N111 VDD VSS n2144 n1098 n1097 n1096 OAI211X0P5H9R
XU1224 u_mac16_top_N103 VDD VSS n2144 n2188 n2186 n2187 OAI211X0P5H9R
XU1225 u_mac16_top_N100 VDD VSS n2144 n2175 n2173 n2174 OAI211X0P5H9R
XU1226 u_mac16_top_N97 VDD VSS n2144 n2166 n2165 n2164 OAI211X0P5H9R
XU1247 n1820 VDD VSS n1007 n1293 n1006 AOI21X0P5H9R
XU1250 n912 VDD VSS n1158 ZBUF_101_7 XOR2X0P7H9R
XU1252 n1163 VDD VSS n1162 n1161 NOR2X1H9R
XU1267 n851 VDD VSS n1490 n1532 NAND2X0P7H9R
XU1268 n1015 VDD VSS n999 n1662 n998 AOI21X0P5H9R
XU1269 n1662 VDD VSS n1676 n1689 n1677 OAI21X0P5H9R
XU1270 n1174 VDD VSS n1355 n1352 NOR2X1P4H9R
XU1284 n1000 VDD VSS n1021 n1610 n1022 OAI21X0P5H9R
XU1293 n1021 VDD VSS u_mac16_top_u_mac_mult_result__15_ u_mac16_top_u_mac_accum_reg__15_ NOR2X0P5H9R
XU1297 n1285 VDD VSS u_mac16_top_u_mac_mult_result__17_ u_mac16_top_u_mac_last_prod__17_ NOR2X0P5H9R
XU1308 n1027 VDD VSS n1695 n978 n977 OAI21X1H9R
XU1340 n1208 VDD VSS n1343 n1347 NAND2X0P7H9R
XU1369 u_mac16_top_N94 VDD VSS n2144 n2157 n2156 n2155 OAI211X0P5H9R
XU1491 n2156 VDD VSS n2184 u_mac16_top_mac_result__2_ n2146 u_mac16_top_result_fifo_0__2_ AOI22X0P5H9R
XU1517 n1493 VDD VSS n851 n1489 NAND2X1H9R
XU1522 n1609 VDD VSS u_mac16_top_u_mac_mult_result__14_ u_mac16_top_u_mac_accum_reg__14_ NOR2X0P5H9R
XU1550 n1112 VDD VSS u_mac16_top_u_mac_u_mul_r_s40__6_ u_mac16_top_u_mac_u_mul_r_c40__6_ AND2X2H9R
XU1560 n878 VDD VSS u_mac16_top_u_mac_u_mul_r_s40__20_ u_mac16_top_u_mac_u_mul_r_c40__20_ XOR2X1H9R
XU1562 n1113 VDD VSS ZBUF_50_13 u_mac16_top_u_mac_u_mul_r_c40__7_ NAND2X2H9R
XU1563 n1695 VDD VSS n974 n1761 n973 AOI21X0P5H9R
XU1597 n1114 VDD VSS n840 n1113 XOR2X1H9R
XU1598 n1606 VDD VSS n1633 n1627 NOR2X0P5H9R
XU1601 n1627 VDD VSS u_mac16_top_u_mac_mult_result__12_ u_mac16_top_u_mac_accum_reg__12_ NOR2X0P5H9R
XU1621 n1587 VDD VSS u_mac16_top_u_mac_mult_result__16_ u_mac16_top_u_mac_last_prod__16_ NAND2X0P5H9R
XU1627 u_mac16_top_N104 VDD VSS n2144 n1078 n1077 n1076 OAI211X0P5H9R
XU1640 u_mac16_top_N105 VDD VSS n2144 n2343 n1080 n1079 OAI211X0P5H9R
XU1642 u_mac16_top_N106 VDD VSS n2144 n1083 n1082 n1081 OAI211X0P5H9R
XU1643 u_mac16_top_N107 VDD VSS n2144 n1086 n1085 n1084 OAI211X0P5H9R
XU1644 u_mac16_top_N108 VDD VSS n2144 n1089 n1088 n1087 OAI211X0P5H9R
XU1646 n974 VDD VSS n1775 n1762 NOR2X0P5H9R
XU1649 n1676 VDD VSS u_mac16_top_u_mac_mult_result__9_ u_mac16_top_u_mac_accum_reg__9_ NOR2X0P7H9R
XU1654 n1301 VDD VSS n1285 n1587 n1286 OAI21X0P5H9R
XU1658 n1157 VDD VSS ZBUF_101_7 ZBUF_17_13 u_mac16_top_u_mac_u_mul_r_c40__15_ CGENCONAX1H9R
XU1664 n1165 VDD VSS n912 ZBUF_190_3 NAND2X0P5H9R
XU1669 n1055 VDD VSS u_mac16_top_u_mac_mult_result__11_ u_mac16_top_u_mac_last_prod__11_ NOR2X0P5H9R
XU1724 n1239 VDD VSS u_mac16_top_u_mac_mult_result__18_ u_mac16_top_u_mac_accum_reg__18_ NOR2X0P5H9R
XU1872 n1780 VDD VSS u_mac16_top_u_mac_mult_result__2_ u_mac16_top_u_mac_accum_reg__2_ NOR2X0P5H9R
XU1873 n1725 VDD VSS n1740 n1742 NOR2X0P7H9R
XU1875 n1685 VDD VSS u_mac16_top_u_mac_mult_result__8_ u_mac16_top_u_mac_last_prod__8_ NAND2X0P7H9R
XU1879 n976 VDD VSS n1719 n1700 NOR2X1H9R
XU1895 n1310 VDD VSS u_mac16_top_u_mac_mult_result__20_ u_mac16_top_u_mac_accum_reg__20_ NOR2X0P5H9R
XU2057 n1210 VDD VSS n1344 n1347 NAND2X0P5H9R
XU2062 n1343 VDD VSS n1207 n1349 NAND2X1P4H9R
XU2164 n883 VDD VSS n1128 n1129 NAND2X1H9R
XU2183 n1561 VDD VSS n1486 n1485 NAND2X1P4H9R
XU2239 n1353 VDD VSS n1171 n1172 NAND2X0P7H9R
XU2264 n1799 VDD VSS u_mac16_top_u_mac_mult_result__0_ u_mac16_top_u_mac_accum_reg__0_ NAND2X0P7H9R
XU2268 n1753 VDD VSS u_mac16_top_u_mac_mult_result__4_ u_mac16_top_u_mac_accum_reg__4_ NAND2X0P5H9R
XU2269 n1591 VDD VSS u_mac16_top_u_mac_mult_result__16_ u_mac16_top_u_mac_accum_reg__16_ NAND2X0P7H9R
XU2276 u_mac16_top_u_mac_u_mul_N49 VDD VSS n1493 n1492 XNOR2X1P4H9R
XU2280 u_mac16_top_N92 VDD VSS n2144 n2151 n2150 n2149 OAI211X0P5H9R
XU2287 n2150 VDD VSS n2184 u_mac16_top_mac_result__0_ n2146 u_mac16_top_result_fifo_0__0_ AOI22X0P5H9R
XU2303 u_mac16_top_N95 VDD VSS n2144 n2160 n2159 n2158 OAI211X0P5H9R
XU2305 n2159 VDD VSS n2184 u_mac16_top_mac_result__3_ n2146 u_mac16_top_result_fifo_0__3_ AOI22X0P5H9R
XU2307 u_mac16_top_N98 VDD VSS n2144 n2169 n2168 n2167 OAI211X0P5H9R
XU2313 n2168 VDD VSS n2184 u_mac16_top_mac_result__6_ n2146 u_mac16_top_result_fifo_0__6_ AOI22X0P5H9R
XU2475 u_mac16_top_N101 VDD VSS n2144 n2178 n2177 n2176 OAI211X0P5H9R
XU2517 n2177 VDD VSS n2184 u_mac16_top_mac_result__9_ n2146 u_mac16_top_result_fifo_0__9_ AOI22X0P5H9R
XU2518 n2187 VDD VSS n2184 u_mac16_top_mac_result__11_ n2146 u_mac16_top_result_fifo_0__11_ AOI22X0P5H9R
XU2519 n1077 VDD VSS n2190 u_mac16_top_mac_result__12_ n2146 u_mac16_top_result_fifo_0__12_ AOI22X0P5H9R
XU2523 n1085 VDD VSS n2190 u_mac16_top_mac_result__15_ n2146 u_mac16_top_result_fifo_0__15_ AOI22X0P5H9R
XU2651 u_mac16_top_N109 VDD VSS n2144 n1092 n1091 n1090 OAI211X0P5H9R
XU2652 u_mac16_top_N110 VDD VSS n2144 n1095 n1094 n1093 OAI211X0P5H9R
XU2653 n1094 VDD VSS n2190 u_mac16_top_mac_result__18_ n2146 u_mac16_top_result_fifo_0__18_ AOI22X0P5H9R
XU2654 n1097 VDD VSS n2190 u_mac16_top_mac_result__19_ n2146 u_mac16_top_result_fifo_0__19_ AOI22X0P5H9R
XU2655 u_mac16_top_N112 VDD VSS n2144 n1101 n1100 n1099 OAI211X0P5H9R
XU2672 n1100 VDD VSS n2190 u_mac16_top_mac_result__20_ n2146 u_mac16_top_result_fifo_0__20_ AOI22X0P5H9R
XU2676 u_mac16_top_u_mac_add_tmp_comb__14_ VDD VSS n1615 n1838 n1614 n1757 AO22X0P5H9R
XU2685 n1614 VDD VSS n1613 n1612 XNOR2X0P5H9R
XU2687 n1330 VDD VSS n949 n1329 XOR2X0P5H9R
.ENDS mac16

.SUBCKT INVX0P5H9R Y VDD VSS A
MI0_MXNA1 Y A VSS VSS nm1p2_svt_lp L=6e-08 W=2.1e-07
MI0_MXPA1 Y A VDD VDD pm1p2_svt_lp L=6e-08 W=2.95e-07
.ENDS

.SUBCKT INVX0P7H9R Y VDD VSS A
MI0_MXNA1 Y A VSS VSS nm1p2_svt_lp L=6e-08 W=2.95e-07
MI0_MXPA1 Y A VDD VDD pm1p2_svt_lp L=6e-08 W=4.15e-07
.ENDS

.SUBCKT INVX1H9R Y VDD VSS A
MI0_MXNA1 Y A VSS VSS nm1p2_svt_lp L=6e-08 W=4.2e-07
MI0_MXPA1 Y A VDD VDD pm1p2_svt_lp L=6e-08 W=5.85e-07
.ENDS

.SUBCKT INVX1P4H9R Y VDD VSS A
MI0_MXNA1 Y A VSS VSS nm1p2_svt_lp L=6e-08 W=2.95e-07
MI0_MXNA1_2 Y A VSS VSS nm1p2_svt_lp L=6e-08 W=2.95e-07
MI0_MXPA1 Y A VDD VDD pm1p2_svt_lp L=6e-08 W=4.15e-07
MI0_MXPA1_2 Y A VDD VDD pm1p2_svt_lp L=6e-08 W=4.15e-07
.ENDS

.SUBCKT INVX1P7H9R Y VDD VSS A
MI0_MXNA1 Y A VSS VSS nm1p2_svt_lp L=6e-08 W=3.5e-07
MI0_MXNA1_2 Y A VSS VSS nm1p2_svt_lp L=6e-08 W=3.5e-07
MI0_MXPA1 Y A VDD VDD pm1p2_svt_lp L=6e-08 W=4.9e-07
MI0_MXPA1_2 Y A VDD VDD pm1p2_svt_lp L=6e-08 W=4.9e-07
.ENDS

.SUBCKT INVX2H9R Y VDD VSS A
MI0_MXNA1 Y A VSS VSS nm1p2_svt_lp L=6e-08 W=4.2e-07
MI0_MXNA1_2 Y A VSS VSS nm1p2_svt_lp L=6e-08 W=4.2e-07
MI0_MXPA1 Y A VDD VDD pm1p2_svt_lp L=6e-08 W=5.85e-07
MI0_MXPA1_2 Y A VDD VDD pm1p2_svt_lp L=6e-08 W=5.85e-07
.ENDS

.SUBCKT BUFX0P7H9R Y VDD VSS A
MI0_MXNA1 ny A VSS VSS nm1p2_svt_lp L=6e-08 W=2.4e-07
MI1_MXNA1 Y ny VSS VSS nm1p2_svt_lp L=6e-08 W=2.95e-07
MI0_MXPA1 ny A VDD VDD pm1p2_svt_lp L=6e-08 W=3.35e-07
MI1_MXPA1 Y ny VDD VDD pm1p2_svt_lp L=6e-08 W=4.15e-07
.ENDS

.SUBCKT BUFX1H9R Y VDD VSS A
MI0_MXNA1 ny A VSS VSS nm1p2_svt_lp L=6e-08 W=3e-07
MI1_MXNA1 Y ny VSS VSS nm1p2_svt_lp L=6e-08 W=4.2e-07
MI0_MXPA1 ny A VDD VDD pm1p2_svt_lp L=6e-08 W=4.2e-07
MI1_MXPA1 Y ny VDD VDD pm1p2_svt_lp L=6e-08 W=5.85e-07
.ENDS

.SUBCKT BUFX1P4H9R Y VDD VSS A
MI0_MXNA1 ny A VSS VSS nm1p2_svt_lp L=6e-08 W=4.05e-07
MI1_MXNA1 Y ny VSS VSS nm1p2_svt_lp L=6e-08 W=2.95e-07
MI1_MXNA1_2 Y ny VSS VSS nm1p2_svt_lp L=6e-08 W=2.95e-07
MI0_MXPA1 ny A VDD VDD pm1p2_svt_lp L=6e-08 W=5.65e-07
MI1_MXPA1 Y ny VDD VDD pm1p2_svt_lp L=6e-08 W=4.15e-07
MI1_MXPA1_2 Y ny VDD VDD pm1p2_svt_lp L=6e-08 W=4.15e-07
.ENDS

.SUBCKT BUFX1P7H9R Y VDD VSS A
MI0_MXNA1 ny A VSS VSS nm1p2_svt_lp L=6e-08 W=2.45e-07
MI0_MXNA1_2 ny A VSS VSS nm1p2_svt_lp L=6e-08 W=2.45e-07
MI1_MXNA1 Y ny VSS VSS nm1p2_svt_lp L=6e-08 W=3.5e-07
MI1_MXNA1_2 Y ny VSS VSS nm1p2_svt_lp L=6e-08 W=3.5e-07
MI0_MXPA1 ny A VDD VDD pm1p2_svt_lp L=6e-08 W=3.4e-07
MI0_MXPA1_2 ny A VDD VDD pm1p2_svt_lp L=6e-08 W=3.4e-07
MI1_MXPA1 Y ny VDD VDD pm1p2_svt_lp L=6e-08 W=4.9e-07
MI1_MXPA1_2 Y ny VDD VDD pm1p2_svt_lp L=6e-08 W=4.9e-07
.ENDS

.SUBCKT BUFX2H9R Y VDD VSS A
MI0_MXNA1 ny A VSS VSS nm1p2_svt_lp L=6e-08 W=2.8e-07
MI0_MXNA1_2 ny A VSS VSS nm1p2_svt_lp L=6e-08 W=2.8e-07
MI1_MXNA1 Y ny VSS VSS nm1p2_svt_lp L=6e-08 W=4.2e-07
MI1_MXNA1_2 Y ny VSS VSS nm1p2_svt_lp L=6e-08 W=4.2e-07
MI0_MXPA1 ny A VDD VDD pm1p2_svt_lp L=6e-08 W=3.9e-07
MI0_MXPA1_2 ny A VDD VDD pm1p2_svt_lp L=6e-08 W=3.9e-07
MI1_MXPA1 Y ny VDD VDD pm1p2_svt_lp L=6e-08 W=5.85e-07
MI1_MXPA1_2 Y ny VDD VDD pm1p2_svt_lp L=6e-08 W=5.85e-07
.ENDS

.SUBCKT NAND2X0P5H9R Y VDD VSS A B
MI0_MXNA2 XI0_n1 B VSS VSS nm1p2_svt_lp L=6e-08 W=2.5e-07
MI0_MXNA1 Y A XI0_n1 VSS nm1p2_svt_lp L=6e-08 W=2.5e-07
MI0_MXPA2 Y B VDD VDD pm1p2_svt_lp L=6e-08 W=2e-07
MI0_MXPA1 Y A VDD VDD pm1p2_svt_lp L=6e-08 W=2e-07
.ENDS

.SUBCKT NAND2X0P7H9R Y VDD VSS A B
MI0_MXNA2 XI0_n1 B VSS VSS nm1p2_svt_lp L=6e-08 W=3.5e-07
MI0_MXNA1 Y A XI0_n1 VSS nm1p2_svt_lp L=6e-08 W=3.5e-07
MI0_MXPA2 Y B VDD VDD pm1p2_svt_lp L=6e-08 W=2.8e-07
MI0_MXPA1 Y A VDD VDD pm1p2_svt_lp L=6e-08 W=2.8e-07
.ENDS

.SUBCKT NAND2X1H9R Y VDD VSS A B
MI0_MXNA2 XI0_n1 B VSS VSS nm1p2_svt_lp L=6e-08 W=4.95e-07
MI0_MXNA1 Y A XI0_n1 VSS nm1p2_svt_lp L=6e-08 W=4.95e-07
MI0_MXPA2 Y B VDD VDD pm1p2_svt_lp L=6e-08 W=3.95e-07
MI0_MXPA1 Y A VDD VDD pm1p2_svt_lp L=6e-08 W=3.95e-07
.ENDS

.SUBCKT NAND2X1P4H9R Y VDD VSS A B
MI0_MXNA2_2 XI0_n1__2 B VSS VSS nm1p2_svt_lp L=6e-08 W=3.5e-07
MI0_MXNA1_2 Y A XI0_n1__2 VSS nm1p2_svt_lp L=6e-08 W=3.5e-07
MI0_MXNA1 Y A XI0_n1 VSS nm1p2_svt_lp L=6e-08 W=3.5e-07
MI0_MXNA2 XI0_n1 B VSS VSS nm1p2_svt_lp L=6e-08 W=3.5e-07
MI0_MXPA1 Y A VDD VDD pm1p2_svt_lp L=6e-08 W=5.6e-07
MI0_MXPA2 Y B VDD VDD pm1p2_svt_lp L=6e-08 W=5.6e-07
.ENDS

.SUBCKT NAND2X2H9R Y VDD VSS A B
MI0_MXNA2_2 XI0_n1__2 B VSS VSS nm1p2_svt_lp L=6e-08 W=4.95e-07
MI0_MXNA1_2 Y A XI0_n1__2 VSS nm1p2_svt_lp L=6e-08 W=4.95e-07
MI0_MXNA1 Y A XI0_n1 VSS nm1p2_svt_lp L=6e-08 W=4.95e-07
MI0_MXNA2 XI0_n1 B VSS VSS nm1p2_svt_lp L=6e-08 W=4.95e-07
MI0_MXPA2 Y B VDD VDD pm1p2_svt_lp L=6e-08 W=3.95e-07
MI0_MXPA1 Y A VDD VDD pm1p2_svt_lp L=6e-08 W=3.95e-07
MI0_MXPA1_2 Y A VDD VDD pm1p2_svt_lp L=6e-08 W=3.95e-07
MI0_MXPA2_2 Y B VDD VDD pm1p2_svt_lp L=6e-08 W=3.95e-07
.ENDS

.SUBCKT NAND2X3H9R Y VDD VSS A B
MI0_MXNA2_2 XI0_n1__2 B VSS VSS nm1p2_svt_lp L=6e-08 W=4.95e-07
MI0_MXNA1_2 Y A XI0_n1__2 VSS nm1p2_svt_lp L=6e-08 W=4.95e-07
MI0_MXNA1_3 Y A XI0_n1__3 VSS nm1p2_svt_lp L=6e-08 W=4.95e-07
MI0_MXNA2_3 XI0_n1__3 B VSS VSS nm1p2_svt_lp L=6e-08 W=4.95e-07
MI0_MXNA2 XI0_n1 B VSS VSS nm1p2_svt_lp L=6e-08 W=4.95e-07
MI0_MXNA1 Y A XI0_n1 VSS nm1p2_svt_lp L=6e-08 W=4.95e-07
MI0_MXPA2 Y B VDD VDD pm1p2_svt_lp L=6e-08 W=3.95e-07
MI0_MXPA1 Y A VDD VDD pm1p2_svt_lp L=6e-08 W=3.95e-07
MI0_MXPA1_2 Y A VDD VDD pm1p2_svt_lp L=6e-08 W=3.95e-07
MI0_MXPA2_2 Y B VDD VDD pm1p2_svt_lp L=6e-08 W=3.95e-07
MI0_MXPA2_3 Y B VDD VDD pm1p2_svt_lp L=6e-08 W=3.95e-07
MI0_MXPA1_3 Y A VDD VDD pm1p2_svt_lp L=6e-08 W=3.95e-07
.ENDS

.SUBCKT NAND2BX0P5H9R Y VDD VSS AN B
MI0_MXNA1 a AN VSS VSS nm1p2_svt_lp L=6e-08 W=1.5e-07
MI1_MXNA2 XI1_n1 B VSS VSS nm1p2_svt_lp L=6e-08 W=2.5e-07
MI1_MXNA1 Y a XI1_n1 VSS nm1p2_svt_lp L=6e-08 W=2.5e-07
MI0_MXPA1 a AN VDD VDD pm1p2_svt_lp L=6e-08 W=2.1e-07
MI1_MXPA2 Y B VDD VDD pm1p2_svt_lp L=6e-08 W=2e-07
MI1_MXPA1 Y a VDD VDD pm1p2_svt_lp L=6e-08 W=2e-07
.ENDS

.SUBCKT NAND2BX0P7H9R Y VDD VSS AN B
MI0_MXNA1 a AN VSS VSS nm1p2_svt_lp L=6e-08 W=1.5e-07
MI1_MXNA2 XI1_n1 B VSS VSS nm1p2_svt_lp L=6e-08 W=3.5e-07
MI1_MXNA1 Y a XI1_n1 VSS nm1p2_svt_lp L=6e-08 W=3.5e-07
MI0_MXPA1 a AN VDD VDD pm1p2_svt_lp L=6e-08 W=2.1e-07
MI1_MXPA2 Y B VDD VDD pm1p2_svt_lp L=6e-08 W=2.8e-07
MI1_MXPA1 Y a VDD VDD pm1p2_svt_lp L=6e-08 W=2.8e-07
.ENDS

.SUBCKT NAND2BX1P4H9R Y VDD VSS AN B
MI0_MXNA1 a AN VSS VSS nm1p2_svt_lp L=6e-08 W=1.85e-07
MI1_MXNA2_2 XI1_n1__2 B VSS VSS nm1p2_svt_lp L=6e-08 W=3.5e-07
MI1_MXNA1_2 Y a XI1_n1__2 VSS nm1p2_svt_lp L=6e-08 W=3.5e-07
MI1_MXNA1 Y a XI1_n1 VSS nm1p2_svt_lp L=6e-08 W=3.5e-07
MI1_MXNA2 XI1_n1 B VSS VSS nm1p2_svt_lp L=6e-08 W=3.5e-07
MI0_MXPA1 a AN VDD VDD pm1p2_svt_lp L=6e-08 W=2.6e-07
MI1_MXPA2 Y B VDD VDD pm1p2_svt_lp L=6e-08 W=2.8e-07
MI1_MXPA1 Y a VDD VDD pm1p2_svt_lp L=6e-08 W=2.8e-07
MI1_MXPA1_2 Y a VDD VDD pm1p2_svt_lp L=6e-08 W=2.8e-07
MI1_MXPA2_2 Y B VDD VDD pm1p2_svt_lp L=6e-08 W=2.8e-07
.ENDS

.SUBCKT NAND2XBX0P5H9R Y VDD VSS A BN
MI0_MXNA1 b BN VSS VSS nm1p2_svt_lp L=6e-08 W=1.5e-07
MI1_MXNA2 XI1_n1 b VSS VSS nm1p2_svt_lp L=6e-08 W=2.5e-07
MI1_MXNA1 Y A XI1_n1 VSS nm1p2_svt_lp L=6e-08 W=2.5e-07
MI0_MXPA1 b BN VDD VDD pm1p2_svt_lp L=6e-08 W=2.1e-07
MI1_MXPA2 Y b VDD VDD pm1p2_svt_lp L=6e-08 W=2e-07
MI1_MXPA1 Y A VDD VDD pm1p2_svt_lp L=6e-08 W=2e-07
.ENDS

.SUBCKT NAND2XBX0P7H9R Y VDD VSS A BN
MI0_MXNA1 b BN VSS VSS nm1p2_svt_lp L=6e-08 W=1.5e-07
MI1_MXNA2 XI1_n1 b VSS VSS nm1p2_svt_lp L=6e-08 W=3.5e-07
MI1_MXNA1 Y A XI1_n1 VSS nm1p2_svt_lp L=6e-08 W=3.5e-07
MI0_MXPA1 b BN VDD VDD pm1p2_svt_lp L=6e-08 W=2.1e-07
MI1_MXPA2 Y b VDD VDD pm1p2_svt_lp L=6e-08 W=2.8e-07
MI1_MXPA1 Y A VDD VDD pm1p2_svt_lp L=6e-08 W=2.8e-07
.ENDS

.SUBCKT NAND3X0P5H9R Y VDD VSS A B C
MI0_MXNA3 XI0_n1 C VSS VSS nm1p2_svt_lp L=6e-08 W=2.5e-07
MI0_MXNA2 XI0_n2 B XI0_n1 VSS nm1p2_svt_lp L=6e-08 W=2.5e-07
MI0_MXNA1 Y A XI0_n2 VSS nm1p2_svt_lp L=6e-08 W=2.5e-07
MI0_MXPA3 Y C VDD VDD pm1p2_svt_lp L=6e-08 W=1.55e-07
MI0_MXPA2 Y B VDD VDD pm1p2_svt_lp L=6e-08 W=1.55e-07
MI0_MXPA1 Y A VDD VDD pm1p2_svt_lp L=6e-08 W=1.55e-07
.ENDS

.SUBCKT NAND3X0P7H9R Y VDD VSS A B C
MI0_MXNA3 XI0_n1 C VSS VSS nm1p2_svt_lp L=6e-08 W=3.5e-07
MI0_MXNA2 XI0_n2 B XI0_n1 VSS nm1p2_svt_lp L=6e-08 W=3.5e-07
MI0_MXNA1 Y A XI0_n2 VSS nm1p2_svt_lp L=6e-08 W=3.5e-07
MI0_MXPA3 Y C VDD VDD pm1p2_svt_lp L=6e-08 W=2.15e-07
MI0_MXPA2 Y B VDD VDD pm1p2_svt_lp L=6e-08 W=2.15e-07
MI0_MXPA1 Y A VDD VDD pm1p2_svt_lp L=6e-08 W=2.15e-07
.ENDS

.SUBCKT NAND3X2H9R Y VDD VSS A B C
MI0_MXNA3_2 XI0_n1__2 C VSS VSS nm1p2_svt_lp L=6e-08 W=4.95e-07
MI0_MXNA2_2 XI0_n2__2 B XI0_n1__2 VSS nm1p2_svt_lp L=6e-08 W=4.95e-07
MI0_MXNA1_2 Y A XI0_n2__2 VSS nm1p2_svt_lp L=6e-08 W=4.95e-07
MI0_MXNA1 Y A XI0_n2 VSS nm1p2_svt_lp L=6e-08 W=4.95e-07
MI0_MXNA2 XI0_n2 B XI0_n1 VSS nm1p2_svt_lp L=6e-08 W=4.95e-07
MI0_MXNA3 XI0_n1 C VSS VSS nm1p2_svt_lp L=6e-08 W=4.95e-07
MI0_MXPA3 Y C VDD VDD pm1p2_svt_lp L=6e-08 W=3.05e-07
MI0_MXPA2 Y B VDD VDD pm1p2_svt_lp L=6e-08 W=3.05e-07
MI0_MXPA1 Y A VDD VDD pm1p2_svt_lp L=6e-08 W=3.05e-07
MI0_MXPA1_2 Y A VDD VDD pm1p2_svt_lp L=6e-08 W=3.05e-07
MI0_MXPA2_2 Y B VDD VDD pm1p2_svt_lp L=6e-08 W=3.05e-07
MI0_MXPA3_2 Y C VDD VDD pm1p2_svt_lp L=6e-08 W=3.05e-07
.ENDS

.SUBCKT NAND3BX0P5H9R Y VDD VSS AN B C
MI0_MXNA1 a AN VSS VSS nm1p2_svt_lp L=6e-08 W=1.5e-07
MI1_MXNA3 XI1_n1 C VSS VSS nm1p2_svt_lp L=6e-08 W=2.5e-07
MI1_MXNA2 XI1_n2 B XI1_n1 VSS nm1p2_svt_lp L=6e-08 W=2.5e-07
MI1_MXNA1 Y a XI1_n2 VSS nm1p2_svt_lp L=6e-08 W=2.5e-07
MI0_MXPA1 a AN VDD VDD pm1p2_svt_lp L=6e-08 W=2.1e-07
MI1_MXPA3 Y C VDD VDD pm1p2_svt_lp L=6e-08 W=1.55e-07
MI1_MXPA2 Y B VDD VDD pm1p2_svt_lp L=6e-08 W=1.55e-07
MI1_MXPA1 Y a VDD VDD pm1p2_svt_lp L=6e-08 W=1.55e-07
.ENDS

.SUBCKT NAND3XXBX1H9R Y VDD VSS A B CN
MI0_MXNA1 c CN VSS VSS nm1p2_svt_lp L=6e-08 W=1.5e-07
MI1_MXNA3 XI1_n1 c VSS VSS nm1p2_svt_lp L=6e-08 W=4.95e-07
MI1_MXNA2 XI1_n2 B XI1_n1 VSS nm1p2_svt_lp L=6e-08 W=4.95e-07
MI1_MXNA1 Y A XI1_n2 VSS nm1p2_svt_lp L=6e-08 W=4.95e-07
MI0_MXPA1 c CN VDD VDD pm1p2_svt_lp L=6e-08 W=2.1e-07
MI1_MXPA3 Y c VDD VDD pm1p2_svt_lp L=6e-08 W=3.05e-07
MI1_MXPA2 Y B VDD VDD pm1p2_svt_lp L=6e-08 W=3.05e-07
MI1_MXPA1 Y A VDD VDD pm1p2_svt_lp L=6e-08 W=3.05e-07
.ENDS

.SUBCKT NAND4X0P5H9R Y VDD VSS A B C D
MI0_MXNA4 XI0_n1 D VSS VSS nm1p2_svt_lp L=6e-08 W=3.15e-07
MI0_MXNA3 XI0_n2 C XI0_n1 VSS nm1p2_svt_lp L=6e-08 W=3.15e-07
MI0_MXNA2 XI0_n3 B XI0_n2 VSS nm1p2_svt_lp L=6e-08 W=3.15e-07
MI0_MXNA1 Y A XI0_n3 VSS nm1p2_svt_lp L=6e-08 W=3.15e-07
MI0_MXPA4 Y D VDD VDD pm1p2_svt_lp L=6e-08 W=1.5e-07
MI0_MXPA3 Y C VDD VDD pm1p2_svt_lp L=6e-08 W=1.5e-07
MI0_MXPA2 Y B VDD VDD pm1p2_svt_lp L=6e-08 W=1.5e-07
MI0_MXPA1 Y A VDD VDD pm1p2_svt_lp L=6e-08 W=1.5e-07
.ENDS

.SUBCKT NAND4X1H9R Y VDD VSS A B C D
MI0_MXNA4 XI0_n1 D VSS VSS nm1p2_svt_lp L=6e-08 W=4.95e-07
MI0_MXNA3 XI0_n2 C XI0_n1 VSS nm1p2_svt_lp L=6e-08 W=4.95e-07
MI0_MXNA2 XI0_n3 B XI0_n2 VSS nm1p2_svt_lp L=6e-08 W=4.95e-07
MI0_MXNA1 Y A XI0_n3 VSS nm1p2_svt_lp L=6e-08 W=4.95e-07
MI0_MXPA4 Y D VDD VDD pm1p2_svt_lp L=6e-08 W=2.35e-07
MI0_MXPA3 Y C VDD VDD pm1p2_svt_lp L=6e-08 W=2.35e-07
MI0_MXPA2 Y B VDD VDD pm1p2_svt_lp L=6e-08 W=2.35e-07
MI0_MXPA1 Y A VDD VDD pm1p2_svt_lp L=6e-08 W=2.35e-07
.ENDS

.SUBCKT NAND4XXXBX2H9R Y VDD VSS A B C DN
MI0_MXNA1 d DN VSS VSS nm1p2_svt_lp L=6e-08 W=2.05e-07
MI1_MXNA3_2 XI1_n2 C XI1_n1__2 VSS nm1p2_svt_lp L=6e-08 W=4.95e-07
MI1_MXNA4_2 XI1_n1__2 d VSS VSS nm1p2_svt_lp L=6e-08 W=4.95e-07
MI1_MXNA4 XI1_n1 d VSS VSS nm1p2_svt_lp L=6e-08 W=4.95e-07
MI1_MXNA3 XI1_n2 C XI1_n1 VSS nm1p2_svt_lp L=6e-08 W=4.95e-07
MI1_MXNA2_2 XI1_n3__2 B XI1_n2 VSS nm1p2_svt_lp L=6e-08 W=4.95e-07
MI1_MXNA1_2 Y A XI1_n3__2 VSS nm1p2_svt_lp L=6e-08 W=4.95e-07
MI1_MXNA1 Y A XI1_n3 VSS nm1p2_svt_lp L=6e-08 W=4.95e-07
MI1_MXNA2 XI1_n3 B XI1_n2 VSS nm1p2_svt_lp L=6e-08 W=4.95e-07
MI0_MXPA1 d DN VDD VDD pm1p2_svt_lp L=6e-08 W=2.9e-07
MI1_MXPA3 Y C VDD VDD pm1p2_svt_lp L=6e-08 W=4.7e-07
MI1_MXPA4 Y d VDD VDD pm1p2_svt_lp L=6e-08 W=4.7e-07
MI1_MXPA2 Y B VDD VDD pm1p2_svt_lp L=6e-08 W=4.7e-07
MI1_MXPA1 Y A VDD VDD pm1p2_svt_lp L=6e-08 W=4.7e-07
.ENDS

.SUBCKT AND2X0P5H9R Y VDD VSS A B
MI0_MXNA1 ny A XI0_n1 VSS nm1p2_svt_lp L=6e-08 W=1.9e-07
MI0_MXNA2 XI0_n1 B VSS VSS nm1p2_svt_lp L=6e-08 W=1.9e-07
MI1_MXNA1 Y ny VSS VSS nm1p2_svt_lp L=6e-08 W=2.1e-07
MI0_MXPA1 ny A VDD VDD pm1p2_svt_lp L=6e-08 W=1.55e-07
MI0_MXPA2 ny B VDD VDD pm1p2_svt_lp L=6e-08 W=1.55e-07
MI1_MXPA1 Y ny VDD VDD pm1p2_svt_lp L=6e-08 W=2.95e-07
.ENDS

.SUBCKT AND2X1H9R Y VDD VSS A B
MI0_MXNA1 ny A XI0_n1 VSS nm1p2_svt_lp L=6e-08 W=2.8e-07
MI0_MXNA2 XI0_n1 B VSS VSS nm1p2_svt_lp L=6e-08 W=2.8e-07
MI1_MXNA1 Y ny VSS VSS nm1p2_svt_lp L=6e-08 W=4.2e-07
MI0_MXPA1 ny A VDD VDD pm1p2_svt_lp L=6e-08 W=2.35e-07
MI0_MXPA2 ny B VDD VDD pm1p2_svt_lp L=6e-08 W=2.35e-07
MI1_MXPA1 Y ny VDD VDD pm1p2_svt_lp L=6e-08 W=5.85e-07
.ENDS

.SUBCKT AND2X1P4H9R Y VDD VSS A B
MI0_MXNA1 ny A XI0_n1 VSS nm1p2_svt_lp L=6e-08 W=3.75e-07
MI0_MXNA2 XI0_n1 B VSS VSS nm1p2_svt_lp L=6e-08 W=3.75e-07
MI1_MXNA1 Y ny VSS VSS nm1p2_svt_lp L=6e-08 W=2.95e-07
MI1_MXNA1_2 Y ny VSS VSS nm1p2_svt_lp L=6e-08 W=2.95e-07
MI0_MXPA1 ny A VDD VDD pm1p2_svt_lp L=6e-08 W=3.1e-07
MI0_MXPA2 ny B VDD VDD pm1p2_svt_lp L=6e-08 W=3.1e-07
MI1_MXPA1 Y ny VDD VDD pm1p2_svt_lp L=6e-08 W=4.15e-07
MI1_MXPA1_2 Y ny VDD VDD pm1p2_svt_lp L=6e-08 W=4.15e-07
.ENDS

.SUBCKT AND2X2H9R Y VDD VSS A B
MI0_MXNA1 ny A XI0_n1 VSS nm1p2_svt_lp L=6e-08 W=4.85e-07
MI0_MXNA2 XI0_n1 B VSS VSS nm1p2_svt_lp L=6e-08 W=4.85e-07
MI1_MXNA1 Y ny VSS VSS nm1p2_svt_lp L=6e-08 W=4.2e-07
MI1_MXNA1_2 Y ny VSS VSS nm1p2_svt_lp L=6e-08 W=4.2e-07
MI0_MXPA1 ny A VDD VDD pm1p2_svt_lp L=6e-08 W=4e-07
MI0_MXPA2 ny B VDD VDD pm1p2_svt_lp L=6e-08 W=4e-07
MI1_MXPA1 Y ny VDD VDD pm1p2_svt_lp L=6e-08 W=5.85e-07
MI1_MXPA1_2 Y ny VDD VDD pm1p2_svt_lp L=6e-08 W=5.85e-07
.ENDS

.SUBCKT AND2X3H9R Y VDD VSS A B
MI0_MXNA2_2 XI0_n1__2 B VSS VSS nm1p2_svt_lp L=6e-08 W=3.8e-07
MI0_MXNA1_2 ny A XI0_n1__2 VSS nm1p2_svt_lp L=6e-08 W=3.8e-07
MI0_MXNA1 ny A XI0_n1 VSS nm1p2_svt_lp L=6e-08 W=3.8e-07
MI0_MXNA2 XI0_n1 B VSS VSS nm1p2_svt_lp L=6e-08 W=3.8e-07
MI1_MXNA1 Y ny VSS VSS nm1p2_svt_lp L=6e-08 W=4.2e-07
MI1_MXNA1_2 Y ny VSS VSS nm1p2_svt_lp L=6e-08 W=4.2e-07
MI1_MXNA1_3 Y ny VSS VSS nm1p2_svt_lp L=6e-08 W=4.2e-07
MI0_MXPA2 ny B VDD VDD pm1p2_svt_lp L=6e-08 W=3.15e-07
MI0_MXPA1 ny A VDD VDD pm1p2_svt_lp L=6e-08 W=3.15e-07
MI0_MXPA1_2 ny A VDD VDD pm1p2_svt_lp L=6e-08 W=3.15e-07
MI0_MXPA2_2 ny B VDD VDD pm1p2_svt_lp L=6e-08 W=3.15e-07
MI1_MXPA1 Y ny VDD VDD pm1p2_svt_lp L=6e-08 W=5.85e-07
MI1_MXPA1_2 Y ny VDD VDD pm1p2_svt_lp L=6e-08 W=5.85e-07
MI1_MXPA1_3 Y ny VDD VDD pm1p2_svt_lp L=6e-08 W=5.85e-07
.ENDS

.SUBCKT AND3X1H9R Y VDD VSS A B C
MI0_MXNA1 ny A XI0_n2 VSS nm1p2_svt_lp L=6e-08 W=4.6e-07
MI0_MXNA2 XI0_n2 B XI0_n1 VSS nm1p2_svt_lp L=6e-08 W=4.6e-07
MI0_MXNA3 XI0_n1 C VSS VSS nm1p2_svt_lp L=6e-08 W=4.6e-07
MI1_MXNA1 Y ny VSS VSS nm1p2_svt_lp L=6e-08 W=4.2e-07
MI0_MXPA1 ny A VDD VDD pm1p2_svt_lp L=6e-08 W=2.7e-07
MI0_MXPA2 ny B VDD VDD pm1p2_svt_lp L=6e-08 W=2.7e-07
MI0_MXPA3 ny C VDD VDD pm1p2_svt_lp L=6e-08 W=2.7e-07
MI1_MXPA1 Y ny VDD VDD pm1p2_svt_lp L=6e-08 W=5.85e-07
.ENDS

.SUBCKT NOR2X0P5H9R Y VDD VSS A B
MI0_MXNA2 Y B VSS VSS nm1p2_svt_lp L=6e-08 W=1.5e-07
MI0_MXNA1 Y A VSS VSS nm1p2_svt_lp L=6e-08 W=1.5e-07
MI0_MXPA2 XI0_p1 B VDD VDD pm1p2_svt_lp L=6e-08 W=3.75e-07
MI0_MXPA1 Y A XI0_p1 VDD pm1p2_svt_lp L=6e-08 W=3.75e-07
.ENDS

.SUBCKT NOR2X0P7H9R Y VDD VSS A B
MI0_MXNA2 Y B VSS VSS nm1p2_svt_lp L=6e-08 W=1.65e-07
MI0_MXNA1 Y A VSS VSS nm1p2_svt_lp L=6e-08 W=1.65e-07
MI0_MXPA2 XI0_p1 B VDD VDD pm1p2_svt_lp L=6e-08 W=4.15e-07
MI0_MXPA1 Y A XI0_p1 VDD pm1p2_svt_lp L=6e-08 W=4.15e-07
.ENDS

.SUBCKT NOR2X1H9R Y VDD VSS A B
MI0_MXNA2 Y B VSS VSS nm1p2_svt_lp L=6e-08 W=2.35e-07
MI0_MXNA1 Y A VSS VSS nm1p2_svt_lp L=6e-08 W=2.35e-07
MI0_MXPA2 XI0_p1 B VDD VDD pm1p2_svt_lp L=6e-08 W=5.85e-07
MI0_MXPA1 Y A XI0_p1 VDD pm1p2_svt_lp L=6e-08 W=5.85e-07
.ENDS

.SUBCKT NOR2X1P4H9R Y VDD VSS A B
MI0_MXNA1 Y A VSS VSS nm1p2_svt_lp L=6e-08 W=3.3e-07
MI0_MXNA2 Y B VSS VSS nm1p2_svt_lp L=6e-08 W=3.3e-07
MI0_MXPA2_2 XI0_p1__2 B VDD VDD pm1p2_svt_lp L=6e-08 W=4.15e-07
MI0_MXPA1_2 Y A XI0_p1__2 VDD pm1p2_svt_lp L=6e-08 W=4.15e-07
MI0_MXPA1 Y A XI0_p1 VDD pm1p2_svt_lp L=6e-08 W=4.15e-07
MI0_MXPA2 XI0_p1 B VDD VDD pm1p2_svt_lp L=6e-08 W=4.15e-07
.ENDS

.SUBCKT NOR2X2H9R Y VDD VSS A B
MI0_MXNA2 Y B VSS VSS nm1p2_svt_lp L=6e-08 W=2.35e-07
MI0_MXNA1 Y A VSS VSS nm1p2_svt_lp L=6e-08 W=2.35e-07
MI0_MXNA1_2 Y A VSS VSS nm1p2_svt_lp L=6e-08 W=2.35e-07
MI0_MXNA2_2 Y B VSS VSS nm1p2_svt_lp L=6e-08 W=2.35e-07
MI0_MXPA2_2 XI0_p1__2 B VDD VDD pm1p2_svt_lp L=6e-08 W=5.85e-07
MI0_MXPA1_2 Y A XI0_p1__2 VDD pm1p2_svt_lp L=6e-08 W=5.85e-07
MI0_MXPA1 Y A XI0_p1 VDD pm1p2_svt_lp L=6e-08 W=5.85e-07
MI0_MXPA2 XI0_p1 B VDD VDD pm1p2_svt_lp L=6e-08 W=5.85e-07
.ENDS

.SUBCKT NOR2BX0P5H9R Y VDD VSS AN B
MI0_MXNA1 a AN VSS VSS nm1p2_svt_lp L=6e-08 W=1.5e-07
MI1_MXNA2 Y B VSS VSS nm1p2_svt_lp L=6e-08 W=1.5e-07
MI1_MXNA1 Y a VSS VSS nm1p2_svt_lp L=6e-08 W=1.5e-07
MI0_MXPA1 a AN VDD VDD pm1p2_svt_lp L=6e-08 W=2.1e-07
MI1_MXPA2 XI1_p1 B VDD VDD pm1p2_svt_lp L=6e-08 W=3.75e-07
MI1_MXPA1 Y a XI1_p1 VDD pm1p2_svt_lp L=6e-08 W=3.75e-07
.ENDS

.SUBCKT NOR2BX1H9R Y VDD VSS AN B
MI0_MXNA1 a AN VSS VSS nm1p2_svt_lp L=6e-08 W=1.5e-07
MI1_MXNA2 Y B VSS VSS nm1p2_svt_lp L=6e-08 W=2.35e-07
MI1_MXNA1 Y a VSS VSS nm1p2_svt_lp L=6e-08 W=2.35e-07
MI0_MXPA1 a AN VDD VDD pm1p2_svt_lp L=6e-08 W=2.1e-07
MI1_MXPA2 XI1_p1 B VDD VDD pm1p2_svt_lp L=6e-08 W=5.85e-07
MI1_MXPA1 Y a XI1_p1 VDD pm1p2_svt_lp L=6e-08 W=5.85e-07
.ENDS

.SUBCKT NOR2XBX0P5H9R Y VDD VSS A BN
MI0_MXNA1 b BN VSS VSS nm1p2_svt_lp L=6e-08 W=1.5e-07
MI1_MXNA2 Y b VSS VSS nm1p2_svt_lp L=6e-08 W=1.5e-07
MI1_MXNA1 Y A VSS VSS nm1p2_svt_lp L=6e-08 W=1.5e-07
MI0_MXPA1 b BN VDD VDD pm1p2_svt_lp L=6e-08 W=2.1e-07
MI1_MXPA2 XI1_p1 b VDD VDD pm1p2_svt_lp L=6e-08 W=3.75e-07
MI1_MXPA1 Y A XI1_p1 VDD pm1p2_svt_lp L=6e-08 W=3.75e-07
.ENDS

.SUBCKT NOR2XBX1H9R Y VDD VSS A BN
MI0_MXNA1 b BN VSS VSS nm1p2_svt_lp L=6e-08 W=1.5e-07
MI1_MXNA2 Y b VSS VSS nm1p2_svt_lp L=6e-08 W=2.35e-07
MI1_MXNA1 Y A VSS VSS nm1p2_svt_lp L=6e-08 W=2.35e-07
MI0_MXPA1 b BN VDD VDD pm1p2_svt_lp L=6e-08 W=2.1e-07
MI1_MXPA2 XI1_p1 b VDD VDD pm1p2_svt_lp L=6e-08 W=5.85e-07
MI1_MXPA1 Y A XI1_p1 VDD pm1p2_svt_lp L=6e-08 W=5.85e-07
.ENDS

.SUBCKT NOR2XBX1P4H9R Y VDD VSS A BN
MI0_MXNA1 b BN VSS VSS nm1p2_svt_lp L=6e-08 W=1.75e-07
MI1_MXNA2 Y b VSS VSS nm1p2_svt_lp L=6e-08 W=1.65e-07
MI1_MXNA1 Y A VSS VSS nm1p2_svt_lp L=6e-08 W=1.65e-07
MI1_MXNA1_2 Y A VSS VSS nm1p2_svt_lp L=6e-08 W=1.65e-07
MI1_MXNA2_2 Y b VSS VSS nm1p2_svt_lp L=6e-08 W=1.65e-07
MI0_MXPA1 b BN VDD VDD pm1p2_svt_lp L=6e-08 W=2.45e-07
MI1_MXPA2_2 XI1_p1__2 b VDD VDD pm1p2_svt_lp L=6e-08 W=4.15e-07
MI1_MXPA1_2 Y A XI1_p1__2 VDD pm1p2_svt_lp L=6e-08 W=4.15e-07
MI1_MXPA1 Y A XI1_p1 VDD pm1p2_svt_lp L=6e-08 W=4.15e-07
MI1_MXPA2 XI1_p1 b VDD VDD pm1p2_svt_lp L=6e-08 W=4.15e-07
.ENDS

.SUBCKT NOR2XBX2H9R Y VDD VSS A BN
MI0_MXNA1 b BN VSS VSS nm1p2_svt_lp L=6e-08 W=2.25e-07
MI1_MXNA2 Y b VSS VSS nm1p2_svt_lp L=6e-08 W=2.35e-07
MI1_MXNA1 Y A VSS VSS nm1p2_svt_lp L=6e-08 W=2.35e-07
MI1_MXNA1_2 Y A VSS VSS nm1p2_svt_lp L=6e-08 W=2.35e-07
MI1_MXNA2_2 Y b VSS VSS nm1p2_svt_lp L=6e-08 W=2.35e-07
MI0_MXPA1 b BN VDD VDD pm1p2_svt_lp L=6e-08 W=3.15e-07
MI1_MXPA2_2 XI1_p1__2 b VDD VDD pm1p2_svt_lp L=6e-08 W=5.85e-07
MI1_MXPA1_2 Y A XI1_p1__2 VDD pm1p2_svt_lp L=6e-08 W=5.85e-07
MI1_MXPA1 Y A XI1_p1 VDD pm1p2_svt_lp L=6e-08 W=5.85e-07
MI1_MXPA2 XI1_p1 b VDD VDD pm1p2_svt_lp L=6e-08 W=5.85e-07
.ENDS

.SUBCKT NOR3X0P5H9R Y VDD VSS A B C
MI0_MXNA3 Y C VSS VSS nm1p2_svt_lp L=6e-08 W=1.5e-07
MI0_MXNA2 Y B VSS VSS nm1p2_svt_lp L=6e-08 W=1.5e-07
MI0_MXNA1 Y A VSS VSS nm1p2_svt_lp L=6e-08 W=1.5e-07
MI0_MXPA3 XI0_p1 C VDD VDD pm1p2_svt_lp L=6e-08 W=2.95e-07
MI0_MXPA2 XI0_p2 B XI0_p1 VDD pm1p2_svt_lp L=6e-08 W=2.95e-07
MI0_MXPA1 Y A XI0_p2 VDD pm1p2_svt_lp L=6e-08 W=2.95e-07
.ENDS

.SUBCKT NOR3X1H9R Y VDD VSS A B C
MI0_MXNA3 Y C VSS VSS nm1p2_svt_lp L=6e-08 W=1.65e-07
MI0_MXNA2 Y B VSS VSS nm1p2_svt_lp L=6e-08 W=1.65e-07
MI0_MXNA1 Y A VSS VSS nm1p2_svt_lp L=6e-08 W=1.65e-07
MI0_MXPA3 XI0_p1 C VDD VDD pm1p2_svt_lp L=6e-08 W=5.85e-07
MI0_MXPA2 XI0_p2 B XI0_p1 VDD pm1p2_svt_lp L=6e-08 W=5.85e-07
MI0_MXPA1 Y A XI0_p2 VDD pm1p2_svt_lp L=6e-08 W=5.85e-07
.ENDS

.SUBCKT OR2X0P5H9R Y VDD VSS A B
MI0_MXNA1 ny A VSS VSS nm1p2_svt_lp L=6e-08 W=1.5e-07
MI0_MXNA2 ny B VSS VSS nm1p2_svt_lp L=6e-08 W=1.5e-07
MI1_MXNA1 Y ny VSS VSS nm1p2_svt_lp L=6e-08 W=2.1e-07
MI0_MXPA1 ny A XI0_p1 VDD pm1p2_svt_lp L=6e-08 W=3.9e-07
MI0_MXPA2 XI0_p1 B VDD VDD pm1p2_svt_lp L=6e-08 W=3.9e-07
MI1_MXPA1 Y ny VDD VDD pm1p2_svt_lp L=6e-08 W=2.95e-07
.ENDS

.SUBCKT OR2X0P7H9R Y VDD VSS A B
MI0_MXNA1 ny A VSS VSS nm1p2_svt_lp L=6e-08 W=1.5e-07
MI0_MXNA2 ny B VSS VSS nm1p2_svt_lp L=6e-08 W=1.5e-07
MI1_MXNA1 Y ny VSS VSS nm1p2_svt_lp L=6e-08 W=2.95e-07
MI0_MXPA1 ny A XI0_p1 VDD pm1p2_svt_lp L=6e-08 W=3.9e-07
MI0_MXPA2 XI0_p1 B VDD VDD pm1p2_svt_lp L=6e-08 W=3.9e-07
MI1_MXPA1 Y ny VDD VDD pm1p2_svt_lp L=6e-08 W=4.15e-07
.ENDS

.SUBCKT OR2X1H9R Y VDD VSS A B
MI0_MXNA1 ny A VSS VSS nm1p2_svt_lp L=6e-08 W=1.7e-07
MI0_MXNA2 ny B VSS VSS nm1p2_svt_lp L=6e-08 W=1.7e-07
MI1_MXNA1 Y ny VSS VSS nm1p2_svt_lp L=6e-08 W=4.2e-07
MI0_MXPA1 ny A XI0_p1 VDD pm1p2_svt_lp L=6e-08 W=4.45e-07
MI0_MXPA2 XI0_p1 B VDD VDD pm1p2_svt_lp L=6e-08 W=4.45e-07
MI1_MXPA1 Y ny VDD VDD pm1p2_svt_lp L=6e-08 W=5.85e-07
.ENDS

.SUBCKT OR2X1P4H9R Y VDD VSS A B
MI0_MXNA1 ny A VSS VSS nm1p2_svt_lp L=6e-08 W=2.25e-07
MI0_MXNA2 ny B VSS VSS nm1p2_svt_lp L=6e-08 W=2.25e-07
MI1_MXNA1 Y ny VSS VSS nm1p2_svt_lp L=6e-08 W=2.95e-07
MI1_MXNA1_2 Y ny VSS VSS nm1p2_svt_lp L=6e-08 W=2.95e-07
MI0_MXPA1 ny A XI0_p1 VDD pm1p2_svt_lp L=6e-08 W=5.85e-07
MI0_MXPA2 XI0_p1 B VDD VDD pm1p2_svt_lp L=6e-08 W=5.85e-07
MI1_MXPA1 Y ny VDD VDD pm1p2_svt_lp L=6e-08 W=4.15e-07
MI1_MXPA1_2 Y ny VDD VDD pm1p2_svt_lp L=6e-08 W=4.15e-07
.ENDS

.SUBCKT OR3X0P5H9R Y VDD VSS A B C
MI0_MXNA1 ny A VSS VSS nm1p2_svt_lp L=6e-08 W=1.5e-07
MI0_MXNA2 ny B VSS VSS nm1p2_svt_lp L=6e-08 W=1.5e-07
MI0_MXNA3 ny C VSS VSS nm1p2_svt_lp L=6e-08 W=1.5e-07
MI1_MXNA1 Y ny VSS VSS nm1p2_svt_lp L=6e-08 W=2.1e-07
MI0_MXPA1 ny A XI0_p2 VDD pm1p2_svt_lp L=6e-08 W=5.55e-07
MI0_MXPA2 XI0_p2 B XI0_p1 VDD pm1p2_svt_lp L=6e-08 W=5.55e-07
MI0_MXPA3 XI0_p1 C VDD VDD pm1p2_svt_lp L=6e-08 W=5.55e-07
MI1_MXPA1 Y ny VDD VDD pm1p2_svt_lp L=6e-08 W=2.95e-07
.ENDS

.SUBCKT XNOR2X0P5H9R Y VDD VSS A B
MI0_MXNA1 na A VSS VSS nm1p2_svt_lp L=6e-08 W=2.8e-07
MI1_MXNA1 nb B VSS VSS nm1p2_svt_lp L=6e-08 W=2.55e-07
MI2_MXNOE Y na nb VSS nm1p2_svt_lp L=6e-08 W=2.25e-07
MI4_MXNOE Y A bb VSS nm1p2_svt_lp L=6e-08 W=2.25e-07
MI3_MXNA1 bb nb VSS VSS nm1p2_svt_lp L=6e-08 W=2.55e-07
MI0_MXPA1 na A VDD VDD pm1p2_svt_lp L=6e-08 W=3.9e-07
MI1_MXPA1 nb B VDD VDD pm1p2_svt_lp L=6e-08 W=3.15e-07
MI2_MXPOEN Y A nb VDD pm1p2_svt_lp L=6e-08 W=2.25e-07
MI4_MXPOEN Y na bb VDD pm1p2_svt_lp L=6e-08 W=2.25e-07
MI3_MXPA1 bb nb VDD VDD pm1p2_svt_lp L=6e-08 W=3.15e-07
.ENDS

.SUBCKT XNOR2X0P7H9R Y VDD VSS A B
MI0_MXNA1 na A VSS VSS nm1p2_svt_lp L=6e-08 W=3.4e-07
MI1_MXNA1 nb B VSS VSS nm1p2_svt_lp L=6e-08 W=3.15e-07
MI2_MXNOE Y na nb VSS nm1p2_svt_lp L=6e-08 W=3.15e-07
MI4_MXNOE Y A bb VSS nm1p2_svt_lp L=6e-08 W=3.15e-07
MI3_MXNA1 bb nb VSS VSS nm1p2_svt_lp L=6e-08 W=3.15e-07
MI0_MXPA1 na A VDD VDD pm1p2_svt_lp L=6e-08 W=4.75e-07
MI1_MXPA1 nb B VDD VDD pm1p2_svt_lp L=6e-08 W=4.4e-07
MI2_MXPOEN Y A nb VDD pm1p2_svt_lp L=6e-08 W=3.15e-07
MI4_MXPOEN Y na bb VDD pm1p2_svt_lp L=6e-08 W=3.15e-07
MI3_MXPA1 bb nb VDD VDD pm1p2_svt_lp L=6e-08 W=4.4e-07
.ENDS

.SUBCKT XNOR2X1P4H9R Y VDD VSS A B
MI1_MXNA1 nb B VSS VSS nm1p2_svt_lp L=6e-08 W=3.15e-07
MI1_MXNA1_2 nb B VSS VSS nm1p2_svt_lp L=6e-08 W=3.15e-07
MI0_MXNA1 na A VSS VSS nm1p2_svt_lp L=6e-08 W=2.7e-07
MI0_MXNA1_2 na A VSS VSS nm1p2_svt_lp L=6e-08 W=2.7e-07
MI2_MXNOE Y na nb VSS nm1p2_svt_lp L=6e-08 W=3.15e-07
MI2_MXNOE_2 Y na nb VSS nm1p2_svt_lp L=6e-08 W=3.15e-07
MI4_MXNOE Y A bb VSS nm1p2_svt_lp L=6e-08 W=3.15e-07
MI4_MXNOE_2 Y A bb VSS nm1p2_svt_lp L=6e-08 W=3.15e-07
MI3_MXNA1 bb nb VSS VSS nm1p2_svt_lp L=6e-08 W=3.15e-07
MI3_MXNA1_2 bb nb VSS VSS nm1p2_svt_lp L=6e-08 W=3.15e-07
MI1_MXPA1 nb B VDD VDD pm1p2_svt_lp L=6e-08 W=4.4e-07
MI1_MXPA1_2 nb B VDD VDD pm1p2_svt_lp L=6e-08 W=4.4e-07
MI0_MXPA1 na A VDD VDD pm1p2_svt_lp L=6e-08 W=3.75e-07
MI0_MXPA1_2 na A VDD VDD pm1p2_svt_lp L=6e-08 W=3.75e-07
MI4_MXPOEN Y na bb VDD pm1p2_svt_lp L=6e-08 W=3.15e-07
MI4_MXPOEN_2 Y na bb VDD pm1p2_svt_lp L=6e-08 W=3.15e-07
MI2_MXPOEN Y A nb VDD pm1p2_svt_lp L=6e-08 W=3.15e-07
MI2_MXPOEN_2 Y A nb VDD pm1p2_svt_lp L=6e-08 W=3.15e-07
MI3_MXPA1 bb nb VDD VDD pm1p2_svt_lp L=6e-08 W=4.4e-07
MI3_MXPA1_2 bb nb VDD VDD pm1p2_svt_lp L=6e-08 W=4.4e-07
.ENDS

.SUBCKT XNOR2X2H9R Y VDD VSS A B
MI1_MXNA1 nb B VSS VSS nm1p2_svt_lp L=6e-08 W=4.4e-07
MI1_MXNA1_2 nb B VSS VSS nm1p2_svt_lp L=6e-08 W=4.4e-07
MI0_MXNA1 na A VSS VSS nm1p2_svt_lp L=6e-08 W=3.2e-07
MI0_MXNA1_2 na A VSS VSS nm1p2_svt_lp L=6e-08 W=3.2e-07
MI2_MXNOE Y na nb VSS nm1p2_svt_lp L=6e-08 W=4.4e-07
MI2_MXNOE_2 Y na nb VSS nm1p2_svt_lp L=6e-08 W=4.4e-07
MI4_MXNOE Y A bb VSS nm1p2_svt_lp L=6e-08 W=4.4e-07
MI4_MXNOE_2 Y A bb VSS nm1p2_svt_lp L=6e-08 W=4.4e-07
MI3_MXNA1 bb nb VSS VSS nm1p2_svt_lp L=6e-08 W=4.4e-07
MI3_MXNA1_2 bb nb VSS VSS nm1p2_svt_lp L=6e-08 W=4.4e-07
MI1_MXPA1 nb B VDD VDD pm1p2_svt_lp L=6e-08 W=5.85e-07
MI1_MXPA1_2 nb B VDD VDD pm1p2_svt_lp L=6e-08 W=5.85e-07
MI0_MXPA1 na A VDD VDD pm1p2_svt_lp L=6e-08 W=4.45e-07
MI0_MXPA1_2 na A VDD VDD pm1p2_svt_lp L=6e-08 W=4.45e-07
MI4_MXPOEN Y na bb VDD pm1p2_svt_lp L=6e-08 W=4.4e-07
MI4_MXPOEN_2 Y na bb VDD pm1p2_svt_lp L=6e-08 W=4.4e-07
MI2_MXPOEN Y A nb VDD pm1p2_svt_lp L=6e-08 W=4.4e-07
MI2_MXPOEN_2 Y A nb VDD pm1p2_svt_lp L=6e-08 W=4.4e-07
MI3_MXPA1 bb nb VDD VDD pm1p2_svt_lp L=6e-08 W=5.85e-07
MI3_MXPA1_2 bb nb VDD VDD pm1p2_svt_lp L=6e-08 W=5.85e-07
.ENDS

.SUBCKT XNOR3X0P5H9R Y VDD VSS A B C
MI1_MXNA1 nb B VSS VSS nm1p2_svt_lp L=6e-08 W=2.8e-07
MI2_MXNA1 nc C VSS VSS nm1p2_svt_lp L=6e-08 W=2.25e-07
MI3_MXNOE bnc B nc VSS nm1p2_svt_lp L=6e-08 W=2.25e-07
MI6_MXNOE bnc nb bc VSS nm1p2_svt_lp L=6e-08 W=2.25e-07
MI5_MXNA1 bc nc VSS VSS nm1p2_svt_lp L=6e-08 W=2.25e-07
MI7_MXNA1 nbnc bnc VSS VSS nm1p2_svt_lp L=6e-08 W=2.25e-07
MI8_MXNOE ny A nbnc VSS nm1p2_svt_lp L=6e-08 W=2.25e-07
MI4_MXNOE ny na bnc VSS nm1p2_svt_lp L=6e-08 W=2.25e-07
MI0_MXNA1 na A VSS VSS nm1p2_svt_lp L=6e-08 W=1.5e-07
MI9_MXNA1 Y ny VSS VSS nm1p2_svt_lp L=6e-08 W=2.1e-07
MI1_MXPA1 nb B VDD VDD pm1p2_svt_lp L=6e-08 W=3.9e-07
MI2_MXPA1 nc C VDD VDD pm1p2_svt_lp L=6e-08 W=3.15e-07
MI3_MXPOEN bnc nb nc VDD pm1p2_svt_lp L=6e-08 W=2.25e-07
MI6_MXPOEN bnc B bc VDD pm1p2_svt_lp L=6e-08 W=2.25e-07
MI5_MXPA1 bc nc VDD VDD pm1p2_svt_lp L=6e-08 W=3.15e-07
MI7_MXPA1 nbnc bnc VDD VDD pm1p2_svt_lp L=6e-08 W=3.1e-07
MI8_MXPOEN ny na nbnc VDD pm1p2_svt_lp L=6e-08 W=2.25e-07
MI4_MXPOEN ny A bnc VDD pm1p2_svt_lp L=6e-08 W=2.25e-07
MI0_MXPA1 na A VDD VDD pm1p2_svt_lp L=6e-08 W=2.1e-07
MI9_MXPA1 Y ny VDD VDD pm1p2_svt_lp L=6e-08 W=2.95e-07
.ENDS

.SUBCKT XNOR3X1H9R Y VDD VSS A B C
MI1_MXNA1 nb B VSS VSS nm1p2_svt_lp L=6e-08 W=4.15e-07
MI2_MXNA1 nc C VSS VSS nm1p2_svt_lp L=6e-08 W=4.5e-07
MI3_MXNOE bnc B nc VSS nm1p2_svt_lp L=6e-08 W=4.5e-07
MI6_MXNOE bnc nb bc VSS nm1p2_svt_lp L=6e-08 W=4.5e-07
MI5_MXNA1 bc nc VSS VSS nm1p2_svt_lp L=6e-08 W=4.5e-07
MI7_MXNA1 nbnc bnc VSS VSS nm1p2_svt_lp L=6e-08 W=3.1e-07
MI8_MXNOE ny A nbnc VSS nm1p2_svt_lp L=6e-08 W=3.1e-07
MI4_MXNOE ny na bnc VSS nm1p2_svt_lp L=6e-08 W=3.1e-07
MI0_MXNA1 na A VSS VSS nm1p2_svt_lp L=6e-08 W=2.75e-07
MI9_MXNA1 Y ny VSS VSS nm1p2_svt_lp L=6e-08 W=4.2e-07
MI1_MXPA1 nb B VDD VDD pm1p2_svt_lp L=6e-08 W=5.85e-07
MI2_MXPA1 nc C VDD VDD pm1p2_svt_lp L=6e-08 W=5.85e-07
MI3_MXPOEN bnc nb nc VDD pm1p2_svt_lp L=6e-08 W=4.5e-07
MI6_MXPOEN bnc B bc VDD pm1p2_svt_lp L=6e-08 W=4.5e-07
MI5_MXPA1 bc nc VDD VDD pm1p2_svt_lp L=6e-08 W=5.85e-07
MI7_MXPA1 nbnc bnc VDD VDD pm1p2_svt_lp L=6e-08 W=4.4e-07
MI8_MXPOEN ny na nbnc VDD pm1p2_svt_lp L=6e-08 W=3.1e-07
MI4_MXPOEN ny A bnc VDD pm1p2_svt_lp L=6e-08 W=3.1e-07
MI0_MXPA1 na A VDD VDD pm1p2_svt_lp L=6e-08 W=3.85e-07
MI9_MXPA1 Y ny VDD VDD pm1p2_svt_lp L=6e-08 W=5.85e-07
.ENDS

.SUBCKT XNOR3X1P4H9R Y VDD VSS A B C
MI1_MXNA1 nb B VSS VSS nm1p2_svt_lp L=6e-08 W=2.7e-07
MI1_MXNA1_2 nb B VSS VSS nm1p2_svt_lp L=6e-08 W=2.7e-07
MI2_MXNA1 nc C VSS VSS nm1p2_svt_lp L=6e-08 W=3.15e-07
MI2_MXNA1_2 nc C VSS VSS nm1p2_svt_lp L=6e-08 W=3.15e-07
MI3_MXNOE bnc B nc VSS nm1p2_svt_lp L=6e-08 W=3.15e-07
MI3_MXNOE_2 bnc B nc VSS nm1p2_svt_lp L=6e-08 W=3.15e-07
MI6_MXNOE bnc nb bc VSS nm1p2_svt_lp L=6e-08 W=3.15e-07
MI6_MXNOE_2 bnc nb bc VSS nm1p2_svt_lp L=6e-08 W=3.15e-07
MI5_MXNA1 bc nc VSS VSS nm1p2_svt_lp L=6e-08 W=3.15e-07
MI5_MXNA1_2 bc nc VSS VSS nm1p2_svt_lp L=6e-08 W=3.15e-07
MI0_MXNA1 na A VSS VSS nm1p2_svt_lp L=6e-08 W=3.45e-07
MI4_MXNOE ny na bnc VSS nm1p2_svt_lp L=6e-08 W=4.1e-07
MI8_MXNOE ny A nbnc VSS nm1p2_svt_lp L=6e-08 W=4.1e-07
MI7_MXNA1 nbnc bnc VSS VSS nm1p2_svt_lp L=6e-08 W=4.1e-07
MI9_MXNA1 Y ny VSS VSS nm1p2_svt_lp L=6e-08 W=2.95e-07
MI9_MXNA1_2 Y ny VSS VSS nm1p2_svt_lp L=6e-08 W=2.95e-07
MI1_MXPA1 nb B VDD VDD pm1p2_svt_lp L=6e-08 W=3.75e-07
MI1_MXPA1_2 nb B VDD VDD pm1p2_svt_lp L=6e-08 W=3.75e-07
MI2_MXPA1 nc C VDD VDD pm1p2_svt_lp L=6e-08 W=4.4e-07
MI2_MXPA1_2 nc C VDD VDD pm1p2_svt_lp L=6e-08 W=4.4e-07
MI3_MXPOEN bnc nb nc VDD pm1p2_svt_lp L=6e-08 W=3.15e-07
MI3_MXPOEN_2 bnc nb nc VDD pm1p2_svt_lp L=6e-08 W=3.15e-07
MI6_MXPOEN bnc B bc VDD pm1p2_svt_lp L=6e-08 W=3.15e-07
MI6_MXPOEN_2 bnc B bc VDD pm1p2_svt_lp L=6e-08 W=3.15e-07
MI5_MXPA1 bc nc VDD VDD pm1p2_svt_lp L=6e-08 W=4.4e-07
MI5_MXPA1_2 bc nc VDD VDD pm1p2_svt_lp L=6e-08 W=4.4e-07
MI0_MXPA1 na A VDD VDD pm1p2_svt_lp L=6e-08 W=4.8e-07
MI4_MXPOEN ny A bnc VDD pm1p2_svt_lp L=6e-08 W=4.1e-07
MI8_MXPOEN ny na nbnc VDD pm1p2_svt_lp L=6e-08 W=4.1e-07
MI7_MXPA1 nbnc bnc VDD VDD pm1p2_svt_lp L=6e-08 W=5.7e-07
MI9_MXPA1 Y ny VDD VDD pm1p2_svt_lp L=6e-08 W=4.15e-07
MI9_MXPA1_2 Y ny VDD VDD pm1p2_svt_lp L=6e-08 W=4.15e-07
.ENDS

.SUBCKT XOR2X0P5H9R Y VDD VSS A B
MI0_MXNA1 na A VSS VSS nm1p2_svt_lp L=6e-08 W=2.8e-07
MI1_MXNA1 nb B VSS VSS nm1p2_svt_lp L=6e-08 W=2.25e-07
MI2_MXNOE Y A nb VSS nm1p2_svt_lp L=6e-08 W=2.25e-07
MI4_MXNOE Y na bb VSS nm1p2_svt_lp L=6e-08 W=2.25e-07
MI3_MXNA1 bb nb VSS VSS nm1p2_svt_lp L=6e-08 W=2.25e-07
MI0_MXPA1 na A VDD VDD pm1p2_svt_lp L=6e-08 W=3.9e-07
MI1_MXPA1 nb B VDD VDD pm1p2_svt_lp L=6e-08 W=3.15e-07
MI2_MXPOEN Y na nb VDD pm1p2_svt_lp L=6e-08 W=2.25e-07
MI4_MXPOEN Y A bb VDD pm1p2_svt_lp L=6e-08 W=2.25e-07
MI3_MXPA1 bb nb VDD VDD pm1p2_svt_lp L=6e-08 W=3.15e-07
.ENDS

.SUBCKT XOR2X0P7H9R Y VDD VSS A B
MI0_MXNA1 na A VSS VSS nm1p2_svt_lp L=6e-08 W=3.4e-07
MI1_MXNA1 nb B VSS VSS nm1p2_svt_lp L=6e-08 W=3.15e-07
MI2_MXNOE Y A nb VSS nm1p2_svt_lp L=6e-08 W=3.15e-07
MI4_MXNOE Y na bb VSS nm1p2_svt_lp L=6e-08 W=3.15e-07
MI3_MXNA1 bb nb VSS VSS nm1p2_svt_lp L=6e-08 W=3.15e-07
MI0_MXPA1 na A VDD VDD pm1p2_svt_lp L=6e-08 W=4.75e-07
MI1_MXPA1 nb B VDD VDD pm1p2_svt_lp L=6e-08 W=4.4e-07
MI2_MXPOEN Y na nb VDD pm1p2_svt_lp L=6e-08 W=3.15e-07
MI4_MXPOEN Y A bb VDD pm1p2_svt_lp L=6e-08 W=3.15e-07
MI3_MXPA1 bb nb VDD VDD pm1p2_svt_lp L=6e-08 W=4.4e-07
.ENDS

.SUBCKT XOR2X1H9R Y VDD VSS A B
MI0_MXNA1 na A VSS VSS nm1p2_svt_lp L=6e-08 W=4.15e-07
MI1_MXNA1 nb B VSS VSS nm1p2_svt_lp L=6e-08 W=4.5e-07
MI2_MXNOE Y A nb VSS nm1p2_svt_lp L=6e-08 W=4.5e-07
MI4_MXNOE Y na bb VSS nm1p2_svt_lp L=6e-08 W=4.5e-07
MI3_MXNA1 bb nb VSS VSS nm1p2_svt_lp L=6e-08 W=4.5e-07
MI0_MXPA1 na A VDD VDD pm1p2_svt_lp L=6e-08 W=5.85e-07
MI1_MXPA1 nb B VDD VDD pm1p2_svt_lp L=6e-08 W=5.85e-07
MI2_MXPOEN Y na nb VDD pm1p2_svt_lp L=6e-08 W=4.5e-07
MI4_MXPOEN Y A bb VDD pm1p2_svt_lp L=6e-08 W=4.5e-07
MI3_MXPA1 bb nb VDD VDD pm1p2_svt_lp L=6e-08 W=5.85e-07
.ENDS

.SUBCKT XOR2X1P4H9R Y VDD VSS A B
MI1_MXNA1 nb B VSS VSS nm1p2_svt_lp L=6e-08 W=3.15e-07
MI1_MXNA1_2 nb B VSS VSS nm1p2_svt_lp L=6e-08 W=3.15e-07
MI0_MXNA1 na A VSS VSS nm1p2_svt_lp L=6e-08 W=2.7e-07
MI0_MXNA1_2 na A VSS VSS nm1p2_svt_lp L=6e-08 W=2.7e-07
MI2_MXNOE Y A nb VSS nm1p2_svt_lp L=6e-08 W=3.15e-07
MI2_MXNOE_2 Y A nb VSS nm1p2_svt_lp L=6e-08 W=3.15e-07
MI4_MXNOE Y na bb VSS nm1p2_svt_lp L=6e-08 W=3.15e-07
MI4_MXNOE_2 Y na bb VSS nm1p2_svt_lp L=6e-08 W=3.15e-07
MI3_MXNA1 bb nb VSS VSS nm1p2_svt_lp L=6e-08 W=3.15e-07
MI3_MXNA1_2 bb nb VSS VSS nm1p2_svt_lp L=6e-08 W=3.15e-07
MI1_MXPA1 nb B VDD VDD pm1p2_svt_lp L=6e-08 W=4.4e-07
MI1_MXPA1_2 nb B VDD VDD pm1p2_svt_lp L=6e-08 W=4.4e-07
MI0_MXPA1 na A VDD VDD pm1p2_svt_lp L=6e-08 W=3.75e-07
MI0_MXPA1_2 na A VDD VDD pm1p2_svt_lp L=6e-08 W=3.75e-07
MI4_MXPOEN Y A bb VDD pm1p2_svt_lp L=6e-08 W=3.15e-07
MI4_MXPOEN_2 Y A bb VDD pm1p2_svt_lp L=6e-08 W=3.15e-07
MI2_MXPOEN Y na nb VDD pm1p2_svt_lp L=6e-08 W=3.15e-07
MI2_MXPOEN_2 Y na nb VDD pm1p2_svt_lp L=6e-08 W=3.15e-07
MI3_MXPA1 bb nb VDD VDD pm1p2_svt_lp L=6e-08 W=4.4e-07
MI3_MXPA1_2 bb nb VDD VDD pm1p2_svt_lp L=6e-08 W=4.4e-07
.ENDS

.SUBCKT XOR2X2H9R Y VDD VSS A B
MI1_MXNA1 nb B VSS VSS nm1p2_svt_lp L=6e-08 W=4.4e-07
MI1_MXNA1_2 nb B VSS VSS nm1p2_svt_lp L=6e-08 W=4.4e-07
MI0_MXNA1 na A VSS VSS nm1p2_svt_lp L=6e-08 W=3.2e-07
MI0_MXNA1_2 na A VSS VSS nm1p2_svt_lp L=6e-08 W=3.2e-07
MI2_MXNOE Y A nb VSS nm1p2_svt_lp L=6e-08 W=4.4e-07
MI2_MXNOE_2 Y A nb VSS nm1p2_svt_lp L=6e-08 W=4.4e-07
MI4_MXNOE Y na bb VSS nm1p2_svt_lp L=6e-08 W=4.4e-07
MI4_MXNOE_2 Y na bb VSS nm1p2_svt_lp L=6e-08 W=4.4e-07
MI3_MXNA1 bb nb VSS VSS nm1p2_svt_lp L=6e-08 W=4.4e-07
MI3_MXNA1_2 bb nb VSS VSS nm1p2_svt_lp L=6e-08 W=4.4e-07
MI1_MXPA1 nb B VDD VDD pm1p2_svt_lp L=6e-08 W=5.85e-07
MI1_MXPA1_2 nb B VDD VDD pm1p2_svt_lp L=6e-08 W=5.85e-07
MI0_MXPA1 na A VDD VDD pm1p2_svt_lp L=6e-08 W=4.45e-07
MI0_MXPA1_2 na A VDD VDD pm1p2_svt_lp L=6e-08 W=4.45e-07
MI4_MXPOEN Y A bb VDD pm1p2_svt_lp L=6e-08 W=4.4e-07
MI4_MXPOEN_2 Y A bb VDD pm1p2_svt_lp L=6e-08 W=4.4e-07
MI2_MXPOEN Y na nb VDD pm1p2_svt_lp L=6e-08 W=4.4e-07
MI2_MXPOEN_2 Y na nb VDD pm1p2_svt_lp L=6e-08 W=4.4e-07
MI3_MXPA1 bb nb VDD VDD pm1p2_svt_lp L=6e-08 W=5.85e-07
MI3_MXPA1_2 bb nb VDD VDD pm1p2_svt_lp L=6e-08 W=5.85e-07
.ENDS

.SUBCKT XOR3X0P5H9R Y VDD VSS A B C
MI1_MXNA1 nb B VSS VSS nm1p2_svt_lp L=6e-08 W=2.8e-07
MI2_MXNA1 nc C VSS VSS nm1p2_svt_lp L=6e-08 W=2.25e-07
MI3_MXNOE bnc B nc VSS nm1p2_svt_lp L=6e-08 W=2.25e-07
MI6_MXNOE bnc nb bc VSS nm1p2_svt_lp L=6e-08 W=2.25e-07
MI5_MXNA1 bc nc VSS VSS nm1p2_svt_lp L=6e-08 W=2.25e-07
MI7_MXNA1 nbnc bnc VSS VSS nm1p2_svt_lp L=6e-08 W=2.2e-07
MI8_MXNOE ny na nbnc VSS nm1p2_svt_lp L=6e-08 W=2.25e-07
MI4_MXNOE ny A bnc VSS nm1p2_svt_lp L=6e-08 W=2.25e-07
MI0_MXNA1 na A VSS VSS nm1p2_svt_lp L=6e-08 W=1.5e-07
MI9_MXNA1 Y ny VSS VSS nm1p2_svt_lp L=6e-08 W=2.1e-07
MI1_MXPA1 nb B VDD VDD pm1p2_svt_lp L=6e-08 W=3.9e-07
MI2_MXPA1 nc C VDD VDD pm1p2_svt_lp L=6e-08 W=3.15e-07
MI3_MXPOEN bnc nb nc VDD pm1p2_svt_lp L=6e-08 W=2.25e-07
MI6_MXPOEN bnc B bc VDD pm1p2_svt_lp L=6e-08 W=2.25e-07
MI5_MXPA1 bc nc VDD VDD pm1p2_svt_lp L=6e-08 W=3.15e-07
MI7_MXPA1 nbnc bnc VDD VDD pm1p2_svt_lp L=6e-08 W=3.1e-07
MI8_MXPOEN ny A nbnc VDD pm1p2_svt_lp L=6e-08 W=2.25e-07
MI4_MXPOEN ny na bnc VDD pm1p2_svt_lp L=6e-08 W=2.25e-07
MI0_MXPA1 na A VDD VDD pm1p2_svt_lp L=6e-08 W=2.1e-07
MI9_MXPA1 Y ny VDD VDD pm1p2_svt_lp L=6e-08 W=2.95e-07
.ENDS

.SUBCKT XOR3X0P7H9R Y VDD VSS A B C
MI1_MXNA1 nb B VSS VSS nm1p2_svt_lp L=6e-08 W=3.4e-07
MI2_MXNA1 nc C VSS VSS nm1p2_svt_lp L=6e-08 W=3.15e-07
MI3_MXNOE bnc B nc VSS nm1p2_svt_lp L=6e-08 W=3.15e-07
MI6_MXNOE bnc nb bc VSS nm1p2_svt_lp L=6e-08 W=3.15e-07
MI5_MXNA1 bc nc VSS VSS nm1p2_svt_lp L=6e-08 W=3.15e-07
MI7_MXNA1 nbnc bnc VSS VSS nm1p2_svt_lp L=6e-08 W=2.6e-07
MI8_MXNOE ny na nbnc VSS nm1p2_svt_lp L=6e-08 W=2.6e-07
MI4_MXNOE ny A bnc VSS nm1p2_svt_lp L=6e-08 W=2.6e-07
MI0_MXNA1 na A VSS VSS nm1p2_svt_lp L=6e-08 W=2.4e-07
MI9_MXNA1 Y ny VSS VSS nm1p2_svt_lp L=6e-08 W=2.95e-07
MI1_MXPA1 nb B VDD VDD pm1p2_svt_lp L=6e-08 W=4.75e-07
MI2_MXPA1 nc C VDD VDD pm1p2_svt_lp L=6e-08 W=4.4e-07
MI3_MXPOEN bnc nb nc VDD pm1p2_svt_lp L=6e-08 W=3.15e-07
MI6_MXPOEN bnc B bc VDD pm1p2_svt_lp L=6e-08 W=3.15e-07
MI5_MXPA1 bc nc VDD VDD pm1p2_svt_lp L=6e-08 W=4.4e-07
MI7_MXPA1 nbnc bnc VDD VDD pm1p2_svt_lp L=6e-08 W=3.65e-07
MI8_MXPOEN ny A nbnc VDD pm1p2_svt_lp L=6e-08 W=2.6e-07
MI4_MXPOEN ny na bnc VDD pm1p2_svt_lp L=6e-08 W=2.6e-07
MI0_MXPA1 na A VDD VDD pm1p2_svt_lp L=6e-08 W=3.35e-07
MI9_MXPA1 Y ny VDD VDD pm1p2_svt_lp L=6e-08 W=4.15e-07
.ENDS

.SUBCKT XOR3X1H9R Y VDD VSS A B C
MI1_MXNA1 nb B VSS VSS nm1p2_svt_lp L=6e-08 W=4.15e-07
MI2_MXNA1 nc C VSS VSS nm1p2_svt_lp L=6e-08 W=4.5e-07
MI3_MXNOE bnc B nc VSS nm1p2_svt_lp L=6e-08 W=4.5e-07
MI6_MXNOE bnc nb bc VSS nm1p2_svt_lp L=6e-08 W=4.5e-07
MI5_MXNA1 bc nc VSS VSS nm1p2_svt_lp L=6e-08 W=4.5e-07
MI7_MXNA1 nbnc bnc VSS VSS nm1p2_svt_lp L=6e-08 W=3.1e-07
MI8_MXNOE ny na nbnc VSS nm1p2_svt_lp L=6e-08 W=3.1e-07
MI4_MXNOE ny A bnc VSS nm1p2_svt_lp L=6e-08 W=3.1e-07
MI0_MXNA1 na A VSS VSS nm1p2_svt_lp L=6e-08 W=2.75e-07
MI9_MXNA1 Y ny VSS VSS nm1p2_svt_lp L=6e-08 W=4.2e-07
MI1_MXPA1 nb B VDD VDD pm1p2_svt_lp L=6e-08 W=5.85e-07
MI2_MXPA1 nc C VDD VDD pm1p2_svt_lp L=6e-08 W=5.85e-07
MI3_MXPOEN bnc nb nc VDD pm1p2_svt_lp L=6e-08 W=4.5e-07
MI6_MXPOEN bnc B bc VDD pm1p2_svt_lp L=6e-08 W=4.5e-07
MI5_MXPA1 bc nc VDD VDD pm1p2_svt_lp L=6e-08 W=5.85e-07
MI7_MXPA1 nbnc bnc VDD VDD pm1p2_svt_lp L=6e-08 W=4.4e-07
MI8_MXPOEN ny A nbnc VDD pm1p2_svt_lp L=6e-08 W=3.1e-07
MI4_MXPOEN ny na bnc VDD pm1p2_svt_lp L=6e-08 W=3.1e-07
MI0_MXPA1 na A VDD VDD pm1p2_svt_lp L=6e-08 W=3.85e-07
MI9_MXPA1 Y ny VDD VDD pm1p2_svt_lp L=6e-08 W=5.85e-07
.ENDS

.SUBCKT MUX2X0P5H9R Y VDD VSS A B S0
MI5_MXNA1 bs0 B XI5_n1 VSS nm1p2_svt_lp L=6e-08 W=1.8e-07
MI5_MXNA2 XI5_n1 S0 VSS VSS nm1p2_svt_lp L=6e-08 W=1.8e-07
MI3_MXNA2 XI3_n1 bs0 VSS VSS nm1p2_svt_lp L=6e-08 W=2.5e-07
MI3_MXNA1 Y ans0 XI3_n1 VSS nm1p2_svt_lp L=6e-08 W=2.5e-07
MI4_MXNA1 ans0 A XI4_n1 VSS nm1p2_svt_lp L=6e-08 W=1.8e-07
MI4_MXNA2 XI4_n1 ns0 VSS VSS nm1p2_svt_lp L=6e-08 W=1.8e-07
MI2_MXNA1 ns0 S0 VSS VSS nm1p2_svt_lp L=6e-08 W=1.9e-07
MI5_MXPA1 bs0 B VDD VDD pm1p2_svt_lp L=6e-08 W=2e-07
MI5_MXPA2 bs0 S0 VDD VDD pm1p2_svt_lp L=6e-08 W=2e-07
MI3_MXPA2 Y bs0 VDD VDD pm1p2_svt_lp L=6e-08 W=2e-07
MI3_MXPA1 Y ans0 VDD VDD pm1p2_svt_lp L=6e-08 W=2e-07
MI4_MXPA1 ans0 A VDD VDD pm1p2_svt_lp L=6e-08 W=2e-07
MI4_MXPA2 ans0 ns0 VDD VDD pm1p2_svt_lp L=6e-08 W=2e-07
MI2_MXPA1 ns0 S0 VDD VDD pm1p2_svt_lp L=6e-08 W=2.9e-07
.ENDS

.SUBCKT MUXIT2X0P5H9R Y VDD VSS A B S0
MI4_MXNA1 ns0 S0 VSS VSS nm1p2_svt_lp L=6e-08 W=2.8e-07
MI2_MXNA1 nb B VSS VSS nm1p2_svt_lp L=6e-08 W=2.25e-07
MI3_MXNOE Y S0 nb VSS nm1p2_svt_lp L=6e-08 W=2.25e-07
MI1_MXNOE Y ns0 na VSS nm1p2_svt_lp L=6e-08 W=2.25e-07
MI0_MXNA1 na A VSS VSS nm1p2_svt_lp L=6e-08 W=2.25e-07
MI4_MXPA1 ns0 S0 VDD VDD pm1p2_svt_lp L=6e-08 W=3.9e-07
MI2_MXPA1 nb B VDD VDD pm1p2_svt_lp L=6e-08 W=3.15e-07
MI3_MXPOEN Y ns0 nb VDD pm1p2_svt_lp L=6e-08 W=2.25e-07
MI1_MXPOEN Y S0 na VDD pm1p2_svt_lp L=6e-08 W=2.25e-07
MI0_MXPA1 na A VDD VDD pm1p2_svt_lp L=6e-08 W=3.15e-07
.ENDS

.SUBCKT AOI21X0P5H9R Y VDD VSS A0 A1 B0
MI0_MXNB2 XI0_n1 A1 VSS VSS nm1p2_svt_lp L=6e-08 W=2.65e-07
MI0_MXNB1 Y A0 XI0_n1 VSS nm1p2_svt_lp L=6e-08 W=2.65e-07
MI0_MXNA1 Y B0 VSS VSS nm1p2_svt_lp L=6e-08 W=1.5e-07
MI0_MXPB2 XI0_p1 A1 VDD VDD pm1p2_svt_lp L=6e-08 W=3.75e-07
MI0_MXPB1 XI0_p1 A0 VDD VDD pm1p2_svt_lp L=6e-08 W=3.75e-07
MI0_MXPA1 Y B0 XI0_p1 VDD pm1p2_svt_lp L=6e-08 W=3.75e-07
.ENDS

.SUBCKT AOI21X0P7H9R Y VDD VSS A0 A1 B0
MI0_MXNB2 XI0_n1 A1 VSS VSS nm1p2_svt_lp L=6e-08 W=2.9e-07
MI0_MXNB1 Y A0 XI0_n1 VSS nm1p2_svt_lp L=6e-08 W=2.9e-07
MI0_MXNA1 Y B0 VSS VSS nm1p2_svt_lp L=6e-08 W=1.65e-07
MI0_MXPB2 XI0_p1 A1 VDD VDD pm1p2_svt_lp L=6e-08 W=4.15e-07
MI0_MXPB1 XI0_p1 A0 VDD VDD pm1p2_svt_lp L=6e-08 W=4.15e-07
MI0_MXPA1 Y B0 XI0_p1 VDD pm1p2_svt_lp L=6e-08 W=4.15e-07
.ENDS

.SUBCKT AOI21X1H9R Y VDD VSS A0 A1 B0
MI0_MXNB2 XI0_n1 A1 VSS VSS nm1p2_svt_lp L=6e-08 W=4.1e-07
MI0_MXNB1 Y A0 XI0_n1 VSS nm1p2_svt_lp L=6e-08 W=4.1e-07
MI0_MXNA1 Y B0 VSS VSS nm1p2_svt_lp L=6e-08 W=2.35e-07
MI0_MXPB2 XI0_p1 A1 VDD VDD pm1p2_svt_lp L=6e-08 W=5.85e-07
MI0_MXPB1 XI0_p1 A0 VDD VDD pm1p2_svt_lp L=6e-08 W=5.85e-07
MI0_MXPA1 Y B0 XI0_p1 VDD pm1p2_svt_lp L=6e-08 W=5.85e-07
.ENDS

.SUBCKT AOI21X1P4H9R Y VDD VSS A0 A1 B0
MI0_MXNB2_2 XI0_n1__2 A1 VSS VSS nm1p2_svt_lp L=6e-08 W=2.9e-07
MI0_MXNB1_2 Y A0 XI0_n1__2 VSS nm1p2_svt_lp L=6e-08 W=2.9e-07
MI0_MXNB1 Y A0 XI0_n1 VSS nm1p2_svt_lp L=6e-08 W=2.9e-07
MI0_MXNB2 XI0_n1 A1 VSS VSS nm1p2_svt_lp L=6e-08 W=2.9e-07
MI0_MXNA1 Y B0 VSS VSS nm1p2_svt_lp L=6e-08 W=3.3e-07
MI0_MXPB2 XI0_p1 A1 VDD VDD pm1p2_svt_lp L=6e-08 W=4.15e-07
MI0_MXPB1 XI0_p1 A0 VDD VDD pm1p2_svt_lp L=6e-08 W=4.15e-07
MI0_MXPB1_2 XI0_p1 A0 VDD VDD pm1p2_svt_lp L=6e-08 W=4.15e-07
MI0_MXPB2_2 XI0_p1 A1 VDD VDD pm1p2_svt_lp L=6e-08 W=4.15e-07
MI0_MXPA1 Y B0 XI0_p1 VDD pm1p2_svt_lp L=6e-08 W=4.15e-07
MI0_MXPA1_2 Y B0 XI0_p1 VDD pm1p2_svt_lp L=6e-08 W=4.15e-07
.ENDS

.SUBCKT AOI21X2H9R Y VDD VSS A0 A1 B0
MI0_MXNB2_2 XI0_n1__2 A1 VSS VSS nm1p2_svt_lp L=6e-08 W=4.1e-07
MI0_MXNB1_2 Y A0 XI0_n1__2 VSS nm1p2_svt_lp L=6e-08 W=4.1e-07
MI0_MXNB1 Y A0 XI0_n1 VSS nm1p2_svt_lp L=6e-08 W=4.1e-07
MI0_MXNB2 XI0_n1 A1 VSS VSS nm1p2_svt_lp L=6e-08 W=4.1e-07
MI0_MXNA1 Y B0 VSS VSS nm1p2_svt_lp L=6e-08 W=4.7e-07
MI0_MXPB2 XI0_p1 A1 VDD VDD pm1p2_svt_lp L=6e-08 W=5.85e-07
MI0_MXPB1 XI0_p1 A0 VDD VDD pm1p2_svt_lp L=6e-08 W=5.85e-07
MI0_MXPB1_2 XI0_p1 A0 VDD VDD pm1p2_svt_lp L=6e-08 W=5.85e-07
MI0_MXPB2_2 XI0_p1 A1 VDD VDD pm1p2_svt_lp L=6e-08 W=5.85e-07
MI0_MXPA1 Y B0 XI0_p1 VDD pm1p2_svt_lp L=6e-08 W=5.85e-07
MI0_MXPA1_2 Y B0 XI0_p1 VDD pm1p2_svt_lp L=6e-08 W=5.85e-07
.ENDS

.SUBCKT AOI2XB1X0P5H9R Y VDD VSS A0 A1N B0
MI0_MXNA1 a1 A1N VSS VSS nm1p2_svt_lp L=6e-08 W=1.5e-07
MI1_MXNB2 XI1_n1 a1 VSS VSS nm1p2_svt_lp L=6e-08 W=2.65e-07
MI1_MXNB1 Y A0 XI1_n1 VSS nm1p2_svt_lp L=6e-08 W=2.65e-07
MI1_MXNA1 Y B0 VSS VSS nm1p2_svt_lp L=6e-08 W=1.5e-07
MI0_MXPA1 a1 A1N VDD VDD pm1p2_svt_lp L=6e-08 W=2.1e-07
MI1_MXPB2 XI1_p1 a1 VDD VDD pm1p2_svt_lp L=6e-08 W=3.75e-07
MI1_MXPB1 XI1_p1 A0 VDD VDD pm1p2_svt_lp L=6e-08 W=3.75e-07
MI1_MXPA1 Y B0 XI1_p1 VDD pm1p2_svt_lp L=6e-08 W=3.75e-07
.ENDS

.SUBCKT AOI2XB1X0P7H9R Y VDD VSS A0 A1N B0
MI0_MXNA1 a1 A1N VSS VSS nm1p2_svt_lp L=6e-08 W=1.5e-07
MI1_MXNB2 XI1_n1 a1 VSS VSS nm1p2_svt_lp L=6e-08 W=2.9e-07
MI1_MXNB1 Y A0 XI1_n1 VSS nm1p2_svt_lp L=6e-08 W=2.9e-07
MI1_MXNA1 Y B0 VSS VSS nm1p2_svt_lp L=6e-08 W=1.65e-07
MI0_MXPA1 a1 A1N VDD VDD pm1p2_svt_lp L=6e-08 W=2.1e-07
MI1_MXPB2 XI1_p1 a1 VDD VDD pm1p2_svt_lp L=6e-08 W=4.15e-07
MI1_MXPB1 XI1_p1 A0 VDD VDD pm1p2_svt_lp L=6e-08 W=4.15e-07
MI1_MXPA1 Y B0 XI1_p1 VDD pm1p2_svt_lp L=6e-08 W=4.15e-07
.ENDS

.SUBCKT AOI2XB1X1P4H9R Y VDD VSS A0 A1N B0
MI0_MXNA1 a1 A1N VSS VSS nm1p2_svt_lp L=6e-08 W=2e-07
MI1_MXNB2_2 XI1_n1__2 a1 VSS VSS nm1p2_svt_lp L=6e-08 W=2.9e-07
MI1_MXNB1_2 Y A0 XI1_n1__2 VSS nm1p2_svt_lp L=6e-08 W=2.9e-07
MI1_MXNB1 Y A0 XI1_n1 VSS nm1p2_svt_lp L=6e-08 W=2.9e-07
MI1_MXNB2 XI1_n1 a1 VSS VSS nm1p2_svt_lp L=6e-08 W=2.9e-07
MI1_MXNA1 Y B0 VSS VSS nm1p2_svt_lp L=6e-08 W=3.3e-07
MI0_MXPA1 a1 A1N VDD VDD pm1p2_svt_lp L=6e-08 W=2.8e-07
MI1_MXPB2 XI1_p1 a1 VDD VDD pm1p2_svt_lp L=6e-08 W=4.15e-07
MI1_MXPB1 XI1_p1 A0 VDD VDD pm1p2_svt_lp L=6e-08 W=4.15e-07
MI1_MXPB1_2 XI1_p1 A0 VDD VDD pm1p2_svt_lp L=6e-08 W=4.15e-07
MI1_MXPB2_2 XI1_p1 a1 VDD VDD pm1p2_svt_lp L=6e-08 W=4.15e-07
MI1_MXPA1 Y B0 XI1_p1 VDD pm1p2_svt_lp L=6e-08 W=4.15e-07
MI1_MXPA1_2 Y B0 XI1_p1 VDD pm1p2_svt_lp L=6e-08 W=4.15e-07
.ENDS

.SUBCKT AOI21BX0P5H9R Y VDD VSS A0 A1 B0N
MI1_MXNB2 XI1_n1 A1 VSS VSS nm1p2_svt_lp L=6e-08 W=2.65e-07
MI1_MXNB1 Y A0 XI1_n1 VSS nm1p2_svt_lp L=6e-08 W=2.65e-07
MI1_MXNA1 Y b0 VSS VSS nm1p2_svt_lp L=6e-08 W=1.5e-07
MI0_MXNA1 b0 B0N VSS VSS nm1p2_svt_lp L=6e-08 W=1.5e-07
MI1_MXPB2 XI1_p1 A1 VDD VDD pm1p2_svt_lp L=6e-08 W=3.75e-07
MI1_MXPB1 XI1_p1 A0 VDD VDD pm1p2_svt_lp L=6e-08 W=3.75e-07
MI1_MXPA1 Y b0 XI1_p1 VDD pm1p2_svt_lp L=6e-08 W=3.75e-07
MI0_MXPA1 b0 B0N VDD VDD pm1p2_svt_lp L=6e-08 W=2.1e-07
.ENDS

.SUBCKT AO22X0P5H9R Y VDD VSS A0 A1 B0 B1
MI0_MXNB2 XI0_n1B A1 VSS VSS nm1p2_svt_lp L=6e-08 W=2.65e-07
MI0_MXNB1 ny A0 XI0_n1B VSS nm1p2_svt_lp L=6e-08 W=2.65e-07
MI0_MXNA1 ny B0 XI0_n1A VSS nm1p2_svt_lp L=6e-08 W=2.65e-07
MI0_MXNA2 XI0_n1A B1 VSS VSS nm1p2_svt_lp L=6e-08 W=2.65e-07
MI1_MXNA1 Y ny VSS VSS nm1p2_svt_lp L=6e-08 W=2.1e-07
MI0_MXPB2 XI0_p1 A1 VDD VDD pm1p2_svt_lp L=6e-08 W=3.75e-07
MI0_MXPB1 XI0_p1 A0 VDD VDD pm1p2_svt_lp L=6e-08 W=3.75e-07
MI0_MXPA1 ny B0 XI0_p1 VDD pm1p2_svt_lp L=6e-08 W=3.75e-07
MI0_MXPA2 ny B1 XI0_p1 VDD pm1p2_svt_lp L=6e-08 W=3.75e-07
MI1_MXPA1 Y ny VDD VDD pm1p2_svt_lp L=6e-08 W=2.95e-07
.ENDS

.SUBCKT AO22X0P7H9R Y VDD VSS A0 A1 B0 B1
MI0_MXNB2 XI0_n1B A1 VSS VSS nm1p2_svt_lp L=6e-08 W=3.1e-07
MI0_MXNB1 ny A0 XI0_n1B VSS nm1p2_svt_lp L=6e-08 W=3.1e-07
MI0_MXNA1 ny B0 XI0_n1A VSS nm1p2_svt_lp L=6e-08 W=3.1e-07
MI0_MXNA2 XI0_n1A B1 VSS VSS nm1p2_svt_lp L=6e-08 W=3.1e-07
MI1_MXNA1 Y ny VSS VSS nm1p2_svt_lp L=6e-08 W=2.95e-07
MI0_MXPB2 XI0_p1 A1 VDD VDD pm1p2_svt_lp L=6e-08 W=4.4e-07
MI0_MXPB1 XI0_p1 A0 VDD VDD pm1p2_svt_lp L=6e-08 W=4.4e-07
MI0_MXPA1 ny B0 XI0_p1 VDD pm1p2_svt_lp L=6e-08 W=4.4e-07
MI0_MXPA2 ny B1 XI0_p1 VDD pm1p2_svt_lp L=6e-08 W=4.4e-07
MI1_MXPA1 Y ny VDD VDD pm1p2_svt_lp L=6e-08 W=4.15e-07
.ENDS

.SUBCKT AOI22X0P5H9R Y VDD VSS A0 A1 B0 B1
MI0_MXNB2 XI0_n1B A1 VSS VSS nm1p2_svt_lp L=6e-08 W=2.1e-07
MI0_MXNB1 Y A0 XI0_n1B VSS nm1p2_svt_lp L=6e-08 W=2.1e-07
MI0_MXNA1 Y B0 XI0_n1A VSS nm1p2_svt_lp L=6e-08 W=2.1e-07
MI0_MXNA2 XI0_n1A B1 VSS VSS nm1p2_svt_lp L=6e-08 W=2.1e-07
MI0_MXPB2 XI0_p1 A1 VDD VDD pm1p2_svt_lp L=6e-08 W=2.95e-07
MI0_MXPB1 XI0_p1 A0 VDD VDD pm1p2_svt_lp L=6e-08 W=2.95e-07
MI0_MXPA1 Y B0 XI0_p1 VDD pm1p2_svt_lp L=6e-08 W=2.95e-07
MI0_MXPA2 Y B1 XI0_p1 VDD pm1p2_svt_lp L=6e-08 W=2.95e-07
.ENDS

.SUBCKT AOI211X0P5H9R Y VDD VSS A0 A1 B0 C0
MXNA1 net17 A1 VSS VSS nm1p2_svt_lp L=6e-08 W=1.5e-07
MXNA0 Y A0 net17 VSS nm1p2_svt_lp L=6e-08 W=1.5e-07
MXNB0 Y B0 VSS VSS nm1p2_svt_lp L=6e-08 W=1.5e-07
MXNC0 Y C0 VSS VSS nm1p2_svt_lp L=6e-08 W=1.5e-07
MXPA1 p1 A1 VDD VDD pm1p2_svt_lp L=6e-08 W=2.95e-07
MXPA0 p1 A0 VDD VDD pm1p2_svt_lp L=6e-08 W=2.95e-07
MXPB0 net045 B0 p1 VDD pm1p2_svt_lp L=6e-08 W=2.95e-07
MXPC0 Y C0 net045 VDD pm1p2_svt_lp L=6e-08 W=2.95e-07
.ENDS

.SUBCKT AOI211X0P7H9R Y VDD VSS A0 A1 B0 C0
MXNA1 net17 A1 VSS VSS nm1p2_svt_lp L=6e-08 W=2.65e-07
MXNA0 Y A0 net17 VSS nm1p2_svt_lp L=6e-08 W=2.65e-07
MXNB0 Y B0 VSS VSS nm1p2_svt_lp L=6e-08 W=1.5e-07
MXNC0 Y C0 VSS VSS nm1p2_svt_lp L=6e-08 W=1.5e-07
MXPA1 p1 A1 VDD VDD pm1p2_svt_lp L=6e-08 W=5.3e-07
MXPA0 p1 A0 VDD VDD pm1p2_svt_lp L=6e-08 W=5.3e-07
MXPB0 net045 B0 p1 VDD pm1p2_svt_lp L=6e-08 W=5.3e-07
MXPC0 Y C0 net045 VDD pm1p2_svt_lp L=6e-08 W=5.3e-07
.ENDS

.SUBCKT AOI221X0P5H9R Y VDD VSS A0 A1 B0 B1 C0
MXNA1 net17 A1 VSS VSS nm1p2_svt_lp L=6e-08 W=1.5e-07
MXNA0 Y A0 net17 VSS nm1p2_svt_lp L=6e-08 W=1.5e-07
MXNB0 Y B0 net26 VSS nm1p2_svt_lp L=6e-08 W=1.5e-07
MXNB1 net26 B1 VSS VSS nm1p2_svt_lp L=6e-08 W=1.5e-07
MXNC0 Y C0 VSS VSS nm1p2_svt_lp L=6e-08 W=1.5e-07
MXPA1 p1 A1 VDD VDD pm1p2_svt_lp L=6e-08 W=2.95e-07
MXPA0 p1 A0 VDD VDD pm1p2_svt_lp L=6e-08 W=2.95e-07
MXPB0 p2 B0 p1 VDD pm1p2_svt_lp L=6e-08 W=2.95e-07
MXPB1 p2 B1 p1 VDD pm1p2_svt_lp L=6e-08 W=2.95e-07
MXPC0 Y C0 p2 VDD pm1p2_svt_lp L=6e-08 W=2.95e-07
.ENDS

.SUBCKT AOI31X0P5H9R Y VDD VSS A0 A1 A2 B0
MI0_MXNB3 XI0_n1 A2 VSS VSS nm1p2_svt_lp L=6e-08 W=3.45e-07
MI0_MXNB2 XI0_n2 A1 XI0_n1 VSS nm1p2_svt_lp L=6e-08 W=3.45e-07
MI0_MXNB1 Y A0 XI0_n2 VSS nm1p2_svt_lp L=6e-08 W=3.45e-07
MI0_MXNA1 Y B0 VSS VSS nm1p2_svt_lp L=6e-08 W=1.5e-07
MI0_MXPB3 XI0_p1 A2 VDD VDD pm1p2_svt_lp L=6e-08 W=3.75e-07
MI0_MXPB2 XI0_p1 A1 VDD VDD pm1p2_svt_lp L=6e-08 W=3.75e-07
MI0_MXPB1 XI0_p1 A0 VDD VDD pm1p2_svt_lp L=6e-08 W=3.75e-07
MI0_MXPA1 Y B0 XI0_p1 VDD pm1p2_svt_lp L=6e-08 W=3.75e-07
.ENDS

.SUBCKT AOI31X1H9R Y VDD VSS A0 A1 A2 B0
MI0_MXNB3 XI0_n1 A2 VSS VSS nm1p2_svt_lp L=6e-08 W=4.95e-07
MI0_MXNB2 XI0_n2 A1 XI0_n1 VSS nm1p2_svt_lp L=6e-08 W=4.95e-07
MI0_MXNB1 Y A0 XI0_n2 VSS nm1p2_svt_lp L=6e-08 W=4.95e-07
MI0_MXNA1 Y B0 VSS VSS nm1p2_svt_lp L=6e-08 W=2.15e-07
MI0_MXPB3 XI0_p1 A2 VDD VDD pm1p2_svt_lp L=6e-08 W=5.4e-07
MI0_MXPB2 XI0_p1 A1 VDD VDD pm1p2_svt_lp L=6e-08 W=5.4e-07
MI0_MXPB1 XI0_p1 A0 VDD VDD pm1p2_svt_lp L=6e-08 W=5.4e-07
MI0_MXPA1 Y B0 XI0_p1 VDD pm1p2_svt_lp L=6e-08 W=5.4e-07
.ENDS

.SUBCKT OA21X0P5H9R Y VDD VSS A0 A1 B0
MI0_MXNB2 XI0_n1 A1 VSS VSS nm1p2_svt_lp L=6e-08 W=2.5e-07
MI0_MXNB1 XI0_n1 A0 VSS VSS nm1p2_svt_lp L=6e-08 W=2.5e-07
MI0_MXNA1 ny B0 XI0_n1 VSS nm1p2_svt_lp L=6e-08 W=2.5e-07
MI1_MXNA1 Y ny VSS VSS nm1p2_svt_lp L=6e-08 W=2.1e-07
MI0_MXPB2 XI0_p1 A1 VDD VDD pm1p2_svt_lp L=6e-08 W=3.55e-07
MI0_MXPB1 ny A0 XI0_p1 VDD pm1p2_svt_lp L=6e-08 W=3.55e-07
MI0_MXPA1 ny B0 VDD VDD pm1p2_svt_lp L=6e-08 W=2e-07
MI1_MXPA1 Y ny VDD VDD pm1p2_svt_lp L=6e-08 W=2.95e-07
.ENDS

.SUBCKT OA21X1H9R Y VDD VSS A0 A1 B0
MI0_MXNB2 XI0_n1 A1 VSS VSS nm1p2_svt_lp L=6e-08 W=3.65e-07
MI0_MXNB1 XI0_n1 A0 VSS VSS nm1p2_svt_lp L=6e-08 W=3.65e-07
MI0_MXNA1 ny B0 XI0_n1 VSS nm1p2_svt_lp L=6e-08 W=3.65e-07
MI1_MXNA1 Y ny VSS VSS nm1p2_svt_lp L=6e-08 W=4.2e-07
MI0_MXPB2 XI0_p1 A1 VDD VDD pm1p2_svt_lp L=6e-08 W=5.15e-07
MI0_MXPB1 ny A0 XI0_p1 VDD pm1p2_svt_lp L=6e-08 W=5.15e-07
MI0_MXPA1 ny B0 VDD VDD pm1p2_svt_lp L=6e-08 W=2.9e-07
MI1_MXPA1 Y ny VDD VDD pm1p2_svt_lp L=6e-08 W=5.85e-07
.ENDS

.SUBCKT OAI21X0P5H9R Y VDD VSS A0 A1 B0
MI0_MXNB2 XI0_n1 A1 VSS VSS nm1p2_svt_lp L=6e-08 W=2.1e-07
MI0_MXNB1 XI0_n1 A0 VSS VSS nm1p2_svt_lp L=6e-08 W=2.1e-07
MI0_MXNA1 Y B0 XI0_n1 VSS nm1p2_svt_lp L=6e-08 W=2.1e-07
MI0_MXPB2 XI0_p1 A1 VDD VDD pm1p2_svt_lp L=6e-08 W=2.95e-07
MI0_MXPB1 Y A0 XI0_p1 VDD pm1p2_svt_lp L=6e-08 W=2.95e-07
MI0_MXPA1 Y B0 VDD VDD pm1p2_svt_lp L=6e-08 W=1.65e-07
.ENDS

.SUBCKT OAI21X0P7H9R Y VDD VSS A0 A1 B0
MI0_MXNB2 XI0_n1 A1 VSS VSS nm1p2_svt_lp L=6e-08 W=2.9e-07
MI0_MXNB1 XI0_n1 A0 VSS VSS nm1p2_svt_lp L=6e-08 W=2.9e-07
MI0_MXNA1 Y B0 XI0_n1 VSS nm1p2_svt_lp L=6e-08 W=2.9e-07
MI0_MXPB2 XI0_p1 A1 VDD VDD pm1p2_svt_lp L=6e-08 W=4.15e-07
MI0_MXPB1 Y A0 XI0_p1 VDD pm1p2_svt_lp L=6e-08 W=4.15e-07
MI0_MXPA1 Y B0 VDD VDD pm1p2_svt_lp L=6e-08 W=2.35e-07
.ENDS

.SUBCKT OAI21X1H9R Y VDD VSS A0 A1 B0
MI0_MXNB2 XI0_n1 A1 VSS VSS nm1p2_svt_lp L=6e-08 W=4.1e-07
MI0_MXNB1 XI0_n1 A0 VSS VSS nm1p2_svt_lp L=6e-08 W=4.1e-07
MI0_MXNA1 Y B0 XI0_n1 VSS nm1p2_svt_lp L=6e-08 W=4.1e-07
MI0_MXPB2 XI0_p1 A1 VDD VDD pm1p2_svt_lp L=6e-08 W=5.85e-07
MI0_MXPB1 Y A0 XI0_p1 VDD pm1p2_svt_lp L=6e-08 W=5.85e-07
MI0_MXPA1 Y B0 VDD VDD pm1p2_svt_lp L=6e-08 W=3.3e-07
.ENDS

.SUBCKT OAI21X1P4H9R Y VDD VSS A0 A1 B0
MI0_MXNB2 XI0_n1 A1 VSS VSS nm1p2_svt_lp L=6e-08 W=2.9e-07
MI0_MXNB1 XI0_n1 A0 VSS VSS nm1p2_svt_lp L=6e-08 W=2.9e-07
MI0_MXNB1_2 XI0_n1 A0 VSS VSS nm1p2_svt_lp L=6e-08 W=2.9e-07
MI0_MXNB2_2 XI0_n1 A1 VSS VSS nm1p2_svt_lp L=6e-08 W=2.9e-07
MI0_MXNA1 Y B0 XI0_n1 VSS nm1p2_svt_lp L=6e-08 W=2.9e-07
MI0_MXNA1_2 Y B0 XI0_n1 VSS nm1p2_svt_lp L=6e-08 W=2.9e-07
MI0_MXPB2_2 XI0_p1__2 A1 VDD VDD pm1p2_svt_lp L=6e-08 W=4.15e-07
MI0_MXPB1_2 Y A0 XI0_p1__2 VDD pm1p2_svt_lp L=6e-08 W=4.15e-07
MI0_MXPB1 Y A0 XI0_p1 VDD pm1p2_svt_lp L=6e-08 W=4.15e-07
MI0_MXPB2 XI0_p1 A1 VDD VDD pm1p2_svt_lp L=6e-08 W=4.15e-07
MI0_MXPA1 Y B0 VDD VDD pm1p2_svt_lp L=6e-08 W=2.35e-07
MI0_MXPA1_2 Y B0 VDD VDD pm1p2_svt_lp L=6e-08 W=2.35e-07
.ENDS

.SUBCKT OAI21X2H9R Y VDD VSS A0 A1 B0
MI0_MXNB2 XI0_n1 A1 VSS VSS nm1p2_svt_lp L=6e-08 W=4.1e-07
MI0_MXNB1 XI0_n1 A0 VSS VSS nm1p2_svt_lp L=6e-08 W=4.1e-07
MI0_MXNB1_2 XI0_n1 A0 VSS VSS nm1p2_svt_lp L=6e-08 W=4.1e-07
MI0_MXNB2_2 XI0_n1 A1 VSS VSS nm1p2_svt_lp L=6e-08 W=4.1e-07
MI0_MXNA1 Y B0 XI0_n1 VSS nm1p2_svt_lp L=6e-08 W=4.1e-07
MI0_MXNA1_2 Y B0 XI0_n1 VSS nm1p2_svt_lp L=6e-08 W=4.1e-07
MI0_MXPB2_2 XI0_p1__2 A1 VDD VDD pm1p2_svt_lp L=6e-08 W=5.85e-07
MI0_MXPB1_2 Y A0 XI0_p1__2 VDD pm1p2_svt_lp L=6e-08 W=5.85e-07
MI0_MXPB1 Y A0 XI0_p1 VDD pm1p2_svt_lp L=6e-08 W=5.85e-07
MI0_MXPB2 XI0_p1 A1 VDD VDD pm1p2_svt_lp L=6e-08 W=5.85e-07
MI0_MXPA1 Y B0 VDD VDD pm1p2_svt_lp L=6e-08 W=3.3e-07
MI0_MXPA1_2 Y B0 VDD VDD pm1p2_svt_lp L=6e-08 W=3.3e-07
.ENDS

.SUBCKT OAI2XB1X0P5H9R Y VDD VSS A0 A1N B0
MI0_MXNA1 a1 A1N VSS VSS nm1p2_svt_lp L=6e-08 W=1.5e-07
MI1_MXNB2 XI1_n1 a1 VSS VSS nm1p2_svt_lp L=6e-08 W=2.1e-07
MI1_MXNB1 XI1_n1 A0 VSS VSS nm1p2_svt_lp L=6e-08 W=2.1e-07
MI1_MXNA1 Y B0 XI1_n1 VSS nm1p2_svt_lp L=6e-08 W=2.1e-07
MI0_MXPA1 a1 A1N VDD VDD pm1p2_svt_lp L=6e-08 W=2.1e-07
MI1_MXPB2 XI1_p1 a1 VDD VDD pm1p2_svt_lp L=6e-08 W=2.95e-07
MI1_MXPB1 Y A0 XI1_p1 VDD pm1p2_svt_lp L=6e-08 W=2.95e-07
MI1_MXPA1 Y B0 VDD VDD pm1p2_svt_lp L=6e-08 W=1.65e-07
.ENDS

.SUBCKT OAI21BX0P5H9R Y VDD VSS A0 A1 B0N
MI1_MXNB2 XI1_n1 A1 VSS VSS nm1p2_svt_lp L=6e-08 W=2.1e-07
MI1_MXNB1 XI1_n1 A0 VSS VSS nm1p2_svt_lp L=6e-08 W=2.1e-07
MI1_MXNA1 Y b0 XI1_n1 VSS nm1p2_svt_lp L=6e-08 W=2.1e-07
MI0_MXNA1 b0 B0N VSS VSS nm1p2_svt_lp L=6e-08 W=1.5e-07
MI1_MXPB2 XI1_p1 A1 VDD VDD pm1p2_svt_lp L=6e-08 W=2.95e-07
MI1_MXPB1 Y A0 XI1_p1 VDD pm1p2_svt_lp L=6e-08 W=2.95e-07
MI1_MXPA1 Y b0 VDD VDD pm1p2_svt_lp L=6e-08 W=1.65e-07
MI0_MXPA1 b0 B0N VDD VDD pm1p2_svt_lp L=6e-08 W=2.1e-07
.ENDS

.SUBCKT OAI22X0P5H9R Y VDD VSS A0 A1 B0 B1
MI0_MXNB2 XI0_n1 A1 VSS VSS nm1p2_svt_lp L=6e-08 W=2.1e-07
MI0_MXNB1 XI0_n1 A0 VSS VSS nm1p2_svt_lp L=6e-08 W=2.1e-07
MI0_MXNA1 Y B0 XI0_n1 VSS nm1p2_svt_lp L=6e-08 W=2.1e-07
MI0_MXNA2 Y B1 XI0_n1 VSS nm1p2_svt_lp L=6e-08 W=2.1e-07
MI0_MXPB2 XI0_p1B A1 VDD VDD pm1p2_svt_lp L=6e-08 W=2.95e-07
MI0_MXPB1 Y A0 XI0_p1B VDD pm1p2_svt_lp L=6e-08 W=2.95e-07
MI0_MXPA1 Y B0 XI0_p1A VDD pm1p2_svt_lp L=6e-08 W=2.95e-07
MI0_MXPA2 XI0_p1A B1 VDD VDD pm1p2_svt_lp L=6e-08 W=2.95e-07
.ENDS

.SUBCKT OA211X0P5H9R Y VDD VSS A0 A1 B0 C0
MI0_MXNC2 XI0_n1 A1 VSS VSS nm1p2_svt_lp L=6e-08 W=3.7e-07
MI0_MXNC1 XI0_n1 A0 VSS VSS nm1p2_svt_lp L=6e-08 W=3.7e-07
MI0_MXNB1 XI0_n2 B0 XI0_n1 VSS nm1p2_svt_lp L=6e-08 W=3.7e-07
MI0_MXNA1 ny C0 XI0_n2 VSS nm1p2_svt_lp L=6e-08 W=3.7e-07
MI1_MXNA1 Y ny VSS VSS nm1p2_svt_lp L=6e-08 W=2.1e-07
MI0_MXPC2 XI0_p1 A1 VDD VDD pm1p2_svt_lp L=6e-08 W=4.05e-07
MI0_MXPC1 ny A0 XI0_p1 VDD pm1p2_svt_lp L=6e-08 W=4.05e-07
MI0_MXPB1 ny B0 VDD VDD pm1p2_svt_lp L=6e-08 W=2.3e-07
MI0_MXPA1 ny C0 VDD VDD pm1p2_svt_lp L=6e-08 W=2.3e-07
MI1_MXPA1 Y ny VDD VDD pm1p2_svt_lp L=6e-08 W=2.95e-07
.ENDS

.SUBCKT OA211X0P7H9R Y VDD VSS A0 A1 B0 C0
MI0_MXNC2 XI0_n1 A1 VSS VSS nm1p2_svt_lp L=6e-08 W=4.4e-07
MI0_MXNC1 XI0_n1 A0 VSS VSS nm1p2_svt_lp L=6e-08 W=4.4e-07
MI0_MXNB1 XI0_n2 B0 XI0_n1 VSS nm1p2_svt_lp L=6e-08 W=4.4e-07
MI0_MXNA1 ny C0 XI0_n2 VSS nm1p2_svt_lp L=6e-08 W=4.4e-07
MI1_MXNA1 Y ny VSS VSS nm1p2_svt_lp L=6e-08 W=2.95e-07
MI0_MXPC2 XI0_p1 A1 VDD VDD pm1p2_svt_lp L=6e-08 W=4.8e-07
MI0_MXPC1 ny A0 XI0_p1 VDD pm1p2_svt_lp L=6e-08 W=4.8e-07
MI0_MXPB1 ny B0 VDD VDD pm1p2_svt_lp L=6e-08 W=2.7e-07
MI0_MXPA1 ny C0 VDD VDD pm1p2_svt_lp L=6e-08 W=2.7e-07
MI1_MXPA1 Y ny VDD VDD pm1p2_svt_lp L=6e-08 W=4.15e-07
.ENDS

.SUBCKT OAI211X0P5H9R Y VDD VSS A0 A1 B0 C0
MI0_MXNC2 XI0_n1 A1 VSS VSS nm1p2_svt_lp L=6e-08 W=2.5e-07
MI0_MXNC1 XI0_n1 A0 VSS VSS nm1p2_svt_lp L=6e-08 W=2.5e-07
MI0_MXNB1 XI0_n2 B0 XI0_n1 VSS nm1p2_svt_lp L=6e-08 W=2.5e-07
MI0_MXNA1 Y C0 XI0_n2 VSS nm1p2_svt_lp L=6e-08 W=2.5e-07
MI0_MXPC2 XI0_p1 A1 VDD VDD pm1p2_svt_lp L=6e-08 W=2.7e-07
MI0_MXPC1 Y A0 XI0_p1 VDD pm1p2_svt_lp L=6e-08 W=2.7e-07
MI0_MXPB1 Y B0 VDD VDD pm1p2_svt_lp L=6e-08 W=1.5e-07
MI0_MXPA1 Y C0 VDD VDD pm1p2_svt_lp L=6e-08 W=1.5e-07
.ENDS

.SUBCKT OAI211X1H9R Y VDD VSS A0 A1 B0 C0
MI0_MXNC2 XI0_n1 A1 VSS VSS nm1p2_svt_lp L=6e-08 W=4.95e-07
MI0_MXNC1 XI0_n1 A0 VSS VSS nm1p2_svt_lp L=6e-08 W=4.95e-07
MI0_MXNB1 XI0_n2 B0 XI0_n1 VSS nm1p2_svt_lp L=6e-08 W=4.95e-07
MI0_MXNA1 Y C0 XI0_n2 VSS nm1p2_svt_lp L=6e-08 W=4.95e-07
MI0_MXPC2 XI0_p1 A1 VDD VDD pm1p2_svt_lp L=6e-08 W=5.4e-07
MI0_MXPC1 Y A0 XI0_p1 VDD pm1p2_svt_lp L=6e-08 W=5.4e-07
MI0_MXPB1 Y B0 VDD VDD pm1p2_svt_lp L=6e-08 W=3.05e-07
MI0_MXPA1 Y C0 VDD VDD pm1p2_svt_lp L=6e-08 W=3.05e-07
.ENDS

.SUBCKT OAI221X0P5H9R Y VDD VSS A0 A1 B0 B1 C0
MI0_MXNC2 XI0_n1 A1 VSS VSS nm1p2_svt_lp L=6e-08 W=2.5e-07
MI0_MXNC1 XI0_n1 A0 VSS VSS nm1p2_svt_lp L=6e-08 W=2.5e-07
MI0_MXNB1 XI0_n2 B0 XI0_n1 VSS nm1p2_svt_lp L=6e-08 W=2.5e-07
MI0_MXNB2 XI0_n2 B1 XI0_n1 VSS nm1p2_svt_lp L=6e-08 W=2.5e-07
MI0_MXNA1 Y C0 XI0_n2 VSS nm1p2_svt_lp L=6e-08 W=2.5e-07
MI0_MXPC2 XI0_p1C A1 VDD VDD pm1p2_svt_lp L=6e-08 W=2.7e-07
MI0_MXPC1 Y A0 XI0_p1C VDD pm1p2_svt_lp L=6e-08 W=2.7e-07
MI0_MXPB1 Y B0 XI0_p1B VDD pm1p2_svt_lp L=6e-08 W=2.7e-07
MI0_MXPB2 XI0_p1B B1 VDD VDD pm1p2_svt_lp L=6e-08 W=2.7e-07
MI0_MXPA1 Y C0 VDD VDD pm1p2_svt_lp L=6e-08 W=1.5e-07
.ENDS

.SUBCKT OAI31X0P5H9R Y VDD VSS A0 A1 A2 B0
MXNA2 n1 A2 VSS VSS nm1p2_svt_lp L=6e-08 W=1.5e-07
MXNA1 n1 A1 VSS VSS nm1p2_svt_lp L=6e-08 W=1.5e-07
MXNA0 n1 A0 VSS VSS nm1p2_svt_lp L=6e-08 W=1.5e-07
MXNB0 Y B0 n1 VSS nm1p2_svt_lp L=6e-08 W=1.5e-07
MXPA2 net46 A2 VDD VDD pm1p2_svt_lp L=6e-08 W=2.95e-07
MXPA1 net38 A1 net46 VDD pm1p2_svt_lp L=6e-08 W=2.95e-07
MXPA0 Y A0 net38 VDD pm1p2_svt_lp L=6e-08 W=2.95e-07
MXPB0 Y B0 VDD VDD pm1p2_svt_lp L=6e-08 W=1.5e-07
.ENDS

.SUBCKT OAI31X2H9R Y VDD VSS A0 A1 A2 B0
MXNA2 n1 A2 VSS VSS nm1p2_svt_lp L=6e-08 W=2.95e-07
MXNA2_2 n1 A2 VSS VSS nm1p2_svt_lp L=6e-08 W=2.95e-07
MXNA1 n1 A1 VSS VSS nm1p2_svt_lp L=6e-08 W=2.95e-07
MXNA0 n1 A0 VSS VSS nm1p2_svt_lp L=6e-08 W=2.95e-07
MXNA0_2 n1 A0 VSS VSS nm1p2_svt_lp L=6e-08 W=2.95e-07
MXNA1_2 n1 A1 VSS VSS nm1p2_svt_lp L=6e-08 W=2.95e-07
MXNB0 Y B0 n1 VSS nm1p2_svt_lp L=6e-08 W=2.95e-07
MXNB0_2 Y B0 n1 VSS nm1p2_svt_lp L=6e-08 W=2.95e-07
MXPA2 net42 A2 VDD VDD pm1p2_svt_lp L=6e-08 W=5.85e-07
MXPA2_2 net42 A2 VDD VDD pm1p2_svt_lp L=6e-08 W=5.85e-07
MXPA1_2 net039__2 A1 net42 VDD pm1p2_svt_lp L=6e-08 W=5.85e-07
MXPA0_2 Y A0 net039__2 VDD pm1p2_svt_lp L=6e-08 W=5.85e-07
MXPA0 Y A0 net039 VDD pm1p2_svt_lp L=6e-08 W=5.85e-07
MXPA1 net039 A1 net42 VDD pm1p2_svt_lp L=6e-08 W=5.85e-07
MXPB0 Y B0 VDD VDD pm1p2_svt_lp L=6e-08 W=4.7e-07
.ENDS

.SUBCKT ADDFX1H9R CO S VDD VSS A B CI
MI0_MXNA1 CO nco VSS VSS nm1p2_svt_lp L=6e-08 W=4.2e-07
MXN1 n1 A VSS VSS nm1p2_svt_lp L=6e-08 W=3.6e-07
MXN2 n1 B VSS VSS nm1p2_svt_lp L=6e-08 W=3.6e-07
MXN4 net34 B VSS VSS nm1p2_svt_lp L=6e-08 W=3.6e-07
MXN3 nco A net34 VSS nm1p2_svt_lp L=6e-08 W=3.6e-07
MXN0 nco CI n1 VSS nm1p2_svt_lp L=6e-08 W=3.6e-07
MXN6 n2 CI VSS VSS nm1p2_svt_lp L=6e-08 W=2.7e-07
MXN7 n2 A VSS VSS nm1p2_svt_lp L=6e-08 W=2.7e-07
MXN8 n2 B VSS VSS nm1p2_svt_lp L=6e-08 W=2.7e-07
MXN5 ns nco n2 VSS nm1p2_svt_lp L=6e-08 W=2.7e-07
MXN9 ns CI net49 VSS nm1p2_svt_lp L=6e-08 W=3.2e-07
MXN10 net49 A net46 VSS nm1p2_svt_lp L=6e-08 W=3.2e-07
MXN11 net46 B VSS VSS nm1p2_svt_lp L=6e-08 W=3.2e-07
MI1_MXNA1 S ns VSS VSS nm1p2_svt_lp L=6e-08 W=4.2e-07
MI0_MXPA1 CO nco VDD VDD pm1p2_svt_lp L=6e-08 W=5.85e-07
MXP1 p1 A VDD VDD pm1p2_svt_lp L=6e-08 W=5e-07
MXP2 p1 B VDD VDD pm1p2_svt_lp L=6e-08 W=5e-07
MXP4 net69 B VDD VDD pm1p2_svt_lp L=6e-08 W=5e-07
MXP3 nco A net69 VDD pm1p2_svt_lp L=6e-08 W=5e-07
MXP0 nco CI p1 VDD pm1p2_svt_lp L=6e-08 W=5e-07
MXP6 p2 CI VDD VDD pm1p2_svt_lp L=6e-08 W=3.6e-07
MXP7 p2 A VDD VDD pm1p2_svt_lp L=6e-08 W=3.6e-07
MXP8 p2 B VDD VDD pm1p2_svt_lp L=6e-08 W=3.6e-07
MXP5 ns nco p2 VDD pm1p2_svt_lp L=6e-08 W=3.6e-07
MXP9 ns CI net87 VDD pm1p2_svt_lp L=6e-08 W=4.2e-07
MXP10 net87 A net84 VDD pm1p2_svt_lp L=6e-08 W=4.2e-07
MXP11 net84 B VDD VDD pm1p2_svt_lp L=6e-08 W=4.2e-07
MI1_MXPA1 S ns VDD VDD pm1p2_svt_lp L=6e-08 W=5.85e-07
.ENDS

.SUBCKT CGENX1H9R CO VDD VSS A B CI
MXN0 nco CI n1 VSS nm1p2_svt_lp L=6e-08 W=4e-07
MXN3 nco A n2 VSS nm1p2_svt_lp L=6e-08 W=4e-07
MXN4 n2 B VSS VSS nm1p2_svt_lp L=6e-08 W=4e-07
MXN2 n1 B VSS VSS nm1p2_svt_lp L=6e-08 W=4e-07
MXN1 n1 A VSS VSS nm1p2_svt_lp L=6e-08 W=4e-07
MI0_MXNA1 CO nco VSS VSS nm1p2_svt_lp L=6e-08 W=4.2e-07
MXP0 nco CI p1 VDD pm1p2_svt_lp L=6e-08 W=5.65e-07
MXP3 nco A p2 VDD pm1p2_svt_lp L=6e-08 W=5.65e-07
MXP4 p2 B VDD VDD pm1p2_svt_lp L=6e-08 W=5.65e-07
MXP2 p1 B VDD VDD pm1p2_svt_lp L=6e-08 W=5.65e-07
MXP1 p1 A VDD VDD pm1p2_svt_lp L=6e-08 W=5.65e-07
MI0_MXPA1 CO nco VDD VDD pm1p2_svt_lp L=6e-08 W=5.85e-07
.ENDS

.SUBCKT CGENX1P4H9R CO VDD VSS A B CI
MXN0 nco CI n1 VSS nm1p2_svt_lp L=6e-08 W=4e-07
MXN3 nco A n2 VSS nm1p2_svt_lp L=6e-08 W=4e-07
MXN4 n2 B VSS VSS nm1p2_svt_lp L=6e-08 W=4e-07
MXN2 n1 B VSS VSS nm1p2_svt_lp L=6e-08 W=4e-07
MXN1 n1 A VSS VSS nm1p2_svt_lp L=6e-08 W=4e-07
MI0_MXNA1 CO nco VSS VSS nm1p2_svt_lp L=6e-08 W=2.95e-07
MI0_MXNA1_2 CO nco VSS VSS nm1p2_svt_lp L=6e-08 W=2.95e-07
MXP0 nco CI p1 VDD pm1p2_svt_lp L=6e-08 W=5.65e-07
MXP3 nco A p2 VDD pm1p2_svt_lp L=6e-08 W=5.65e-07
MXP4 p2 B VDD VDD pm1p2_svt_lp L=6e-08 W=5.65e-07
MXP2 p1 B VDD VDD pm1p2_svt_lp L=6e-08 W=5.65e-07
MXP1 p1 A VDD VDD pm1p2_svt_lp L=6e-08 W=5.65e-07
MI0_MXPA1 CO nco VDD VDD pm1p2_svt_lp L=6e-08 W=4.1e-07
MI0_MXPA1_2 CO nco VDD VDD pm1p2_svt_lp L=6e-08 W=4.1e-07
.ENDS

.SUBCKT CGENCONAX1H9R CON VDD VSS A B CI
MXN1 n1 A VSS VSS nm1p2_svt_lp L=6e-08 W=4e-07
MXN2 n1 B VSS VSS nm1p2_svt_lp L=6e-08 W=4e-07
MXN3 n2 B VSS VSS nm1p2_svt_lp L=6e-08 W=4e-07
MXN4 CON A n2 VSS nm1p2_svt_lp L=6e-08 W=4e-07
MXN0 CON CI n1 VSS nm1p2_svt_lp L=6e-08 W=4e-07
MXP0 p1 A VDD VDD pm1p2_svt_lp L=6e-08 W=5.85e-07
MXP1 p1 B VDD VDD pm1p2_svt_lp L=6e-08 W=5.85e-07
MXP4 p2 B VDD VDD pm1p2_svt_lp L=6e-08 W=5.85e-07
MXP3 CON A p2 VDD pm1p2_svt_lp L=6e-08 W=5.85e-07
MXP2 CON CI p1 VDD pm1p2_svt_lp L=6e-08 W=5.85e-07
.ENDS

.SUBCKT LATLQX0P5H9R Q VDD VSS D GN
MI72_MXNA1 nclk_ GN VSS VSS nm1p2_svt_lp L=6e-08 W=1.5e-07
MI74_MXNA1 nd D VSS VSS nm1p2_svt_lp L=6e-08 W=1.5e-07
MI70_MXNOE nm nclk_ nd VSS nm1p2_svt_lp L=6e-08 W=1.5e-07
MI71_MXNOE nm GN XI71_n1 VSS nm1p2_svt_lp L=6e-08 W=1.5e-07
MI71_MXNA1 XI71_n1 m VSS VSS nm1p2_svt_lp L=6e-08 W=1.5e-07
MI69_MXNA1 m nm VSS VSS nm1p2_svt_lp L=6e-08 W=1.2e-07
MI75_MXNA1 Q nm VSS VSS nm1p2_svt_lp L=6e-08 W=2.1e-07
MI72_MXPA1 nclk_ GN VDD VDD pm1p2_svt_lp L=6e-08 W=2e-07
MI74_MXPA1 nd D VDD VDD pm1p2_svt_lp L=6e-08 W=2.2e-07
MI70_MXPOEN nm GN nd VDD pm1p2_svt_lp L=6e-08 W=1.5e-07
MI71_MXPOEN nm nclk_ XI71_p1 VDD pm1p2_svt_lp L=6e-08 W=1.5e-07
MI71_MXPA1 XI71_p1 m VDD VDD pm1p2_svt_lp L=6e-08 W=1.5e-07
MI69_MXPA1 m nm VDD VDD pm1p2_svt_lp L=6e-08 W=1.2e-07
MI75_MXPA1 Q nm VDD VDD pm1p2_svt_lp L=6e-08 W=2.95e-07
.ENDS

.SUBCKT FREEICGX0P5H9R ECK VDD VSS CK
MXN4 lo hi VSS VSS nm1p2_svt_lp L=6e-08 W=1.5e-07
MXN1 n1 hi VSS VSS nm1p2_svt_lp L=6e-08 W=1.5e-07
MXN0 neck CK n1 VSS nm1p2_svt_lp L=6e-08 W=1.5e-07
MI8_MXNA1 ECK neck VSS VSS nm1p2_svt_lp L=6e-08 W=1.5e-07
MXP4 hi lo VDD VDD pm1p2_svt_lp L=6e-08 W=1.5e-07
MXP5 hi hi VDD VDD pm1p2_svt_lp L=6e-08 W=2.1e-07
MXP0 neck hi VDD VDD pm1p2_svt_lp L=6e-08 W=1.5e-07
MXP1 neck CK VDD VDD pm1p2_svt_lp L=6e-08 W=2.3e-07
MI8_MXPA1 ECK neck VDD VDD pm1p2_svt_lp L=6e-08 W=2.95e-07
.ENDS

.SUBCKT FREEICGX0P6H9R ECK VDD VSS CK
MXN4 lo hi VSS VSS nm1p2_svt_lp L=6e-08 W=1.5e-07
MXN1 n1 hi VSS VSS nm1p2_svt_lp L=6e-08 W=1.5e-07
MXN0 neck CK n1 VSS nm1p2_svt_lp L=6e-08 W=1.5e-07
MI8_MXNA1 ECK neck VSS VSS nm1p2_svt_lp L=6e-08 W=1.5e-07
MXP4 hi lo VDD VDD pm1p2_svt_lp L=6e-08 W=1.5e-07
MXP5 hi hi VDD VDD pm1p2_svt_lp L=6e-08 W=2.1e-07
MXP0 neck hi VDD VDD pm1p2_svt_lp L=6e-08 W=1.5e-07
MXP1 neck CK VDD VDD pm1p2_svt_lp L=6e-08 W=2.5e-07
MI8_MXPA1 ECK neck VDD VDD pm1p2_svt_lp L=6e-08 W=3.7e-07
.ENDS

.SUBCKT FREEICGX0P7H9R ECK VDD VSS CK
MXN4 lo hi VSS VSS nm1p2_svt_lp L=6e-08 W=1.5e-07
MXN1 n1 hi VSS VSS nm1p2_svt_lp L=6e-08 W=1.5e-07
MXN0 neck CK n1 VSS nm1p2_svt_lp L=6e-08 W=1.5e-07
MI8_MXNA1 ECK neck VSS VSS nm1p2_svt_lp L=6e-08 W=1.65e-07
MXP4 hi lo VDD VDD pm1p2_svt_lp L=6e-08 W=1.5e-07
MXP5 hi hi VDD VDD pm1p2_svt_lp L=6e-08 W=2.1e-07
MXP0 neck hi VDD VDD pm1p2_svt_lp L=6e-08 W=1.5e-07
MXP1 neck CK VDD VDD pm1p2_svt_lp L=6e-08 W=2.5e-07
MI8_MXPA1 ECK neck VDD VDD pm1p2_svt_lp L=6e-08 W=4.15e-07
.ENDS

.SUBCKT FREEICGX0P8H9R ECK VDD VSS CK
MXN4 lo hi VSS VSS nm1p2_svt_lp L=6e-08 W=1.5e-07
MXN1 n1 hi VSS VSS nm1p2_svt_lp L=6e-08 W=1.5e-07
MXN0 neck CK n1 VSS nm1p2_svt_lp L=6e-08 W=1.5e-07
MI8_MXNA1 ECK neck VSS VSS nm1p2_svt_lp L=6e-08 W=2e-07
MXP4 hi lo VDD VDD pm1p2_svt_lp L=6e-08 W=1.5e-07
MXP5 hi hi VDD VDD pm1p2_svt_lp L=6e-08 W=2.1e-07
MXP0 neck hi VDD VDD pm1p2_svt_lp L=6e-08 W=1.5e-07
MXP1 neck CK VDD VDD pm1p2_svt_lp L=6e-08 W=2.5e-07
MI8_MXPA1 ECK neck VDD VDD pm1p2_svt_lp L=6e-08 W=4.9e-07
.ENDS

.SUBCKT FREEICGX1P2H9R ECK VDD VSS CK
MXN4 lo hi VSS VSS nm1p2_svt_lp L=6e-08 W=1.5e-07
MXN1 n1 hi VSS VSS nm1p2_svt_lp L=6e-08 W=1.8e-07
MXN0 neck CK n1 VSS nm1p2_svt_lp L=6e-08 W=1.8e-07
MI8_MXNA1 ECK neck VSS VSS nm1p2_svt_lp L=6e-08 W=2.8e-07
MXP4 hi lo VDD VDD pm1p2_svt_lp L=6e-08 W=1.5e-07
MXP5 hi hi VDD VDD pm1p2_svt_lp L=6e-08 W=2.1e-07
MXP0 neck hi VDD VDD pm1p2_svt_lp L=6e-08 W=1.5e-07
MXP1 neck CK VDD VDD pm1p2_svt_lp L=6e-08 W=2.9e-07
MI8_MXPA1 ECK neck VDD VDD pm1p2_svt_lp L=6e-08 W=3.5e-07
MI8_MXPA1_2 ECK neck VDD VDD pm1p2_svt_lp L=6e-08 W=3.5e-07
.ENDS

.SUBCKT FREEICGX2H9R ECK VDD VSS CK
MXN4 lo hi VSS VSS nm1p2_svt_lp L=6e-08 W=1.5e-07
MXN1 n1 hi VSS VSS nm1p2_svt_lp L=6e-08 W=2.45e-07
MXN0 neck CK n1 VSS nm1p2_svt_lp L=6e-08 W=2.45e-07
MI8_MXNA1 ECK neck VSS VSS nm1p2_svt_lp L=6e-08 W=4.7e-07
MXP4 hi lo VDD VDD pm1p2_svt_lp L=6e-08 W=1.5e-07
MXP5 hi hi VDD VDD pm1p2_svt_lp L=6e-08 W=2.1e-07
MXP0 neck hi VDD VDD pm1p2_svt_lp L=6e-08 W=1.5e-07
MXP1 neck CK VDD VDD pm1p2_svt_lp L=6e-08 W=4.1e-07
MI8_MXPA1 ECK neck VDD VDD pm1p2_svt_lp L=6e-08 W=5.85e-07
MI8_MXPA1_2 ECK neck VDD VDD pm1p2_svt_lp L=6e-08 W=5.85e-07
.ENDS

.SUBCKT FREEICGX2P5H9R ECK VDD VSS CK
MXN4 lo hi VSS VSS nm1p2_svt_lp L=6e-08 W=1.5e-07
MXN1 n1 hi VSS VSS nm1p2_svt_lp L=6e-08 W=3.4e-07
MXN0 neck CK n1 VSS nm1p2_svt_lp L=6e-08 W=3.4e-07
MI8_MXNA1 ECK neck VSS VSS nm1p2_svt_lp L=6e-08 W=3e-07
MI8_MXNA1_2 ECK neck VSS VSS nm1p2_svt_lp L=6e-08 W=3e-07
MXP4 hi lo VDD VDD pm1p2_svt_lp L=6e-08 W=1.5e-07
MXP5 hi hi VDD VDD pm1p2_svt_lp L=6e-08 W=2.1e-07
MXP0 neck hi VDD VDD pm1p2_svt_lp L=6e-08 W=1.5e-07
MXP1 neck CK VDD VDD pm1p2_svt_lp L=6e-08 W=5.45e-07
MI8_MXPA1 ECK neck VDD VDD pm1p2_svt_lp L=6e-08 W=4.9e-07
MI8_MXPA1_2 ECK neck VDD VDD pm1p2_svt_lp L=6e-08 W=4.9e-07
MI8_MXPA1_3 ECK neck VDD VDD pm1p2_svt_lp L=6e-08 W=4.9e-07
.ENDS

.SUBCKT DFFRPQX0P5H9R Q VDD VSS CK D R
MI22_MXNA1 nclk CK VSS VSS nm1p2_svt_lp L=6e-08 W=1.5e-07
MI23_MXNA1 bclk nclk VSS VSS nm1p2_svt_lp L=6e-08 W=1.5e-07
MI78_MXNA1 nd D VSS VSS nm1p2_svt_lp L=6e-08 W=2.4e-07
MI33_MXNOE nm nclk nd VSS nm1p2_svt_lp L=6e-08 W=1.5e-07
MI31_MXNOE nm bclk XI31_n1 VSS nm1p2_svt_lp L=6e-08 W=1.5e-07
MI31_MXNA1 XI31_n1 m VSS VSS nm1p2_svt_lp L=6e-08 W=1.5e-07
MI0_MXNA2 m nm VSS VSS nm1p2_svt_lp L=6e-08 W=1.5e-07
MI0_MXNA1 m R VSS VSS nm1p2_svt_lp L=6e-08 W=1.5e-07
MI20_MXNOE s bclk m VSS nm1p2_svt_lp L=6e-08 W=1.5e-07
MXN4 s nclk net45 VSS nm1p2_svt_lp L=6e-08 W=1.5e-07
MXN0 net45 ns VSS VSS nm1p2_svt_lp L=6e-08 W=1.5e-07
MXN1 s R VSS VSS nm1p2_svt_lp L=6e-08 W=1.5e-07
MI28_MXNA1 ns s VSS VSS nm1p2_svt_lp L=6e-08 W=1.5e-07
MI8_MXNA1 Q ns VSS VSS nm1p2_svt_lp L=6e-08 W=2.1e-07
MI22_MXPA1 nclk CK VDD VDD pm1p2_svt_lp L=6e-08 W=1.7e-07
MI23_MXPA1 bclk nclk VDD VDD pm1p2_svt_lp L=6e-08 W=1.9e-07
MI78_MXPA1 nd D VDD VDD pm1p2_svt_lp L=6e-08 W=1.7e-07
MI33_MXPOEN nm bclk nd VDD pm1p2_svt_lp L=6e-08 W=1.5e-07
MI31_MXPOEN nm nclk XI31_p1 VDD pm1p2_svt_lp L=6e-08 W=1.5e-07
MI31_MXPA1 XI31_p1 m VDD VDD pm1p2_svt_lp L=6e-08 W=1.5e-07
MI0_MXPA2 XI0_p1 nm VDD VDD pm1p2_svt_lp L=6e-08 W=3e-07
MI0_MXPA1 m R XI0_p1 VDD pm1p2_svt_lp L=6e-08 W=3e-07
MI20_MXPOEN s nclk m VDD pm1p2_svt_lp L=6e-08 W=1.5e-07
MXP1 s bclk net80 VDD pm1p2_svt_lp L=6e-08 W=2e-07
MXP0 net80 ns net72 VDD pm1p2_svt_lp L=6e-08 W=2e-07
MXP5 net72 R VDD VDD pm1p2_svt_lp L=6e-08 W=2e-07
MI28_MXPA1 ns s VDD VDD pm1p2_svt_lp L=6e-08 W=2.1e-07
MI8_MXPA1 Q ns VDD VDD pm1p2_svt_lp L=6e-08 W=2.95e-07
.ENDS

.SUBCKT DFFRPQX1H9R Q VDD VSS CK D R
MI22_MXNA1 nclk CK VSS VSS nm1p2_svt_lp L=6e-08 W=1.7e-07
MI23_MXNA1 bclk nclk VSS VSS nm1p2_svt_lp L=6e-08 W=1.5e-07
MI78_MXNA1 nd D VSS VSS nm1p2_svt_lp L=6e-08 W=3.2e-07
MI33_MXNOE nm nclk nd VSS nm1p2_svt_lp L=6e-08 W=2.6e-07
MI31_MXNOE nm bclk XI31_n1 VSS nm1p2_svt_lp L=6e-08 W=1.5e-07
MI31_MXNA1 XI31_n1 m VSS VSS nm1p2_svt_lp L=6e-08 W=1.5e-07
MI0_MXNA2 m nm VSS VSS nm1p2_svt_lp L=6e-08 W=2e-07
MI0_MXNA1 m R VSS VSS nm1p2_svt_lp L=6e-08 W=2e-07
MI20_MXNOE s bclk m VSS nm1p2_svt_lp L=6e-08 W=2.6e-07
MXN4 s nclk net45 VSS nm1p2_svt_lp L=6e-08 W=1.5e-07
MXN0 net45 ns VSS VSS nm1p2_svt_lp L=6e-08 W=1.5e-07
MXN1 s R VSS VSS nm1p2_svt_lp L=6e-08 W=1.5e-07
MI28_MXNA1 ns s VSS VSS nm1p2_svt_lp L=6e-08 W=2.6e-07
MI8_MXNA1 Q ns VSS VSS nm1p2_svt_lp L=6e-08 W=4.2e-07
MI22_MXPA1 nclk CK VDD VDD pm1p2_svt_lp L=6e-08 W=1.9e-07
MI23_MXPA1 bclk nclk VDD VDD pm1p2_svt_lp L=6e-08 W=3e-07
MI78_MXPA1 nd D VDD VDD pm1p2_svt_lp L=6e-08 W=2.5e-07
MI33_MXPOEN nm bclk nd VDD pm1p2_svt_lp L=6e-08 W=2.6e-07
MI31_MXPOEN nm nclk XI31_p1 VDD pm1p2_svt_lp L=6e-08 W=1.5e-07
MI31_MXPA1 XI31_p1 m VDD VDD pm1p2_svt_lp L=6e-08 W=1.5e-07
MI0_MXPA2 XI0_p1 nm VDD VDD pm1p2_svt_lp L=6e-08 W=4.5e-07
MI0_MXPA1 m R XI0_p1 VDD pm1p2_svt_lp L=6e-08 W=4.5e-07
MI20_MXPOEN s nclk m VDD pm1p2_svt_lp L=6e-08 W=2.6e-07
MXP1 s bclk net80 VDD pm1p2_svt_lp L=6e-08 W=2e-07
MXP0 net80 ns net72 VDD pm1p2_svt_lp L=6e-08 W=2e-07
MXP5 net72 R VDD VDD pm1p2_svt_lp L=6e-08 W=2e-07
MI28_MXPA1 ns s VDD VDD pm1p2_svt_lp L=6e-08 W=3.4e-07
MI8_MXPA1 Q ns VDD VDD pm1p2_svt_lp L=6e-08 W=5.85e-07
.ENDS

.SUBCKT DFFRPQNX0P5H9R QN VDD VSS CK D R
MI83_MXNA1 nd D VSS VSS nm1p2_svt_lp L=6e-08 W=2e-07
MI33_MXNOE nm nclk nd VSS nm1p2_svt_lp L=6e-08 W=1.5e-07
MI31_MXNOE nm bclk XI31_n1 VSS nm1p2_svt_lp L=6e-08 W=1.5e-07
MI31_MXNA1 XI31_n1 m VSS VSS nm1p2_svt_lp L=6e-08 W=1.5e-07
MI0_MXNA2 m nm VSS VSS nm1p2_svt_lp L=6e-08 W=1.5e-07
MI0_MXNA1 m R VSS VSS nm1p2_svt_lp L=6e-08 W=1.5e-07
MI20_MXNOE s bclk m VSS nm1p2_svt_lp L=6e-08 W=1.5e-07
MXN6 s nclk net53 VSS nm1p2_svt_lp L=6e-08 W=1.5e-07
MXN5 net53 ns VSS VSS nm1p2_svt_lp L=6e-08 W=1.5e-07
MXN7 s R VSS VSS nm1p2_svt_lp L=6e-08 W=1.5e-07
MI78_MXNA1 ns s VSS VSS nm1p2_svt_lp L=6e-08 W=1.2e-07
MI8_MXNA1 QN s VSS VSS nm1p2_svt_lp L=6e-08 W=2.1e-07
MI23_MXNA1 bclk nclk VSS VSS nm1p2_svt_lp L=6e-08 W=1.5e-07
MI22_MXNA1 nclk CK VSS VSS nm1p2_svt_lp L=6e-08 W=1.5e-07
MI83_MXPA1 nd D VDD VDD pm1p2_svt_lp L=6e-08 W=1.5e-07
MI33_MXPOEN nm bclk nd VDD pm1p2_svt_lp L=6e-08 W=1.5e-07
MI31_MXPOEN nm nclk XI31_p1 VDD pm1p2_svt_lp L=6e-08 W=1.5e-07
MI31_MXPA1 XI31_p1 m VDD VDD pm1p2_svt_lp L=6e-08 W=1.5e-07
MI0_MXPA2 XI0_p1 nm VDD VDD pm1p2_svt_lp L=6e-08 W=3.2e-07
MI0_MXPA1 m R XI0_p1 VDD pm1p2_svt_lp L=6e-08 W=3.2e-07
MI20_MXPOEN s nclk m VDD pm1p2_svt_lp L=6e-08 W=1.5e-07
MXP7 s bclk net74 VDD pm1p2_svt_lp L=6e-08 W=2e-07
MXP4 net74 ns net78 VDD pm1p2_svt_lp L=6e-08 W=2e-07
MXP6 net78 R VDD VDD pm1p2_svt_lp L=6e-08 W=2e-07
MI78_MXPA1 ns s VDD VDD pm1p2_svt_lp L=6e-08 W=1.2e-07
MI8_MXPA1 QN s VDD VDD pm1p2_svt_lp L=6e-08 W=2.95e-07
MI23_MXPA1 bclk nclk VDD VDD pm1p2_svt_lp L=6e-08 W=1.9e-07
MI22_MXPA1 nclk CK VDD VDD pm1p2_svt_lp L=6e-08 W=1.7e-07
.ENDS

.SUBCKT DFFSQNX0P5H9R QN VDD VSS CK D SN
MI83_MXNA1 nd D VSS VSS nm1p2_svt_lp L=6e-08 W=2.6e-07
MI33_MXNOE nm nclk nd VSS nm1p2_svt_lp L=6e-08 W=1.5e-07
MI31_MXNOE nm bclk XI31_n1 VSS nm1p2_svt_lp L=6e-08 W=1.5e-07
MI31_MXNA1 XI31_n1 m VSS VSS nm1p2_svt_lp L=6e-08 W=1.5e-07
MI0_MXNA2 XI0_n1 nm VSS VSS nm1p2_svt_lp L=6e-08 W=2.5e-07
MI0_MXNA1 m SN XI0_n1 VSS nm1p2_svt_lp L=6e-08 W=2.5e-07
MI20_MXNOE s bclk m VSS nm1p2_svt_lp L=6e-08 W=1.5e-07
MXN4 s nclk net58 VSS nm1p2_svt_lp L=6e-08 W=2e-07
MXN0 net58 ns net54 VSS nm1p2_svt_lp L=6e-08 W=2e-07
MXN1 net54 SN VSS VSS nm1p2_svt_lp L=6e-08 W=2e-07
MI28_MXNA1 ns s VSS VSS nm1p2_svt_lp L=6e-08 W=1.2e-07
MI8_MXNA1 QN s VSS VSS nm1p2_svt_lp L=6e-08 W=2.1e-07
MI23_MXNA1 bclk nclk VSS VSS nm1p2_svt_lp L=6e-08 W=1.5e-07
MI22_MXNA1 nclk CK VSS VSS nm1p2_svt_lp L=6e-08 W=1.5e-07
MI83_MXPA1 nd D VDD VDD pm1p2_svt_lp L=6e-08 W=1.55e-07
MI33_MXPOEN nm bclk nd VDD pm1p2_svt_lp L=6e-08 W=1.5e-07
MI31_MXPOEN nm nclk XI31_p1 VDD pm1p2_svt_lp L=6e-08 W=1.5e-07
MI31_MXPA1 XI31_p1 m VDD VDD pm1p2_svt_lp L=6e-08 W=1.5e-07
MI0_MXPA2 m nm VDD VDD pm1p2_svt_lp L=6e-08 W=1.5e-07
MI0_MXPA1 m SN VDD VDD pm1p2_svt_lp L=6e-08 W=1.5e-07
MI20_MXPOEN s nclk m VDD pm1p2_svt_lp L=6e-08 W=1.5e-07
MXP1 s bclk net79 VDD pm1p2_svt_lp L=6e-08 W=1.5e-07
MXP0 net79 ns VDD VDD pm1p2_svt_lp L=6e-08 W=1.5e-07
MXP4 s SN VDD VDD pm1p2_svt_lp L=6e-08 W=1.5e-07
MI28_MXPA1 ns s VDD VDD pm1p2_svt_lp L=6e-08 W=1.2e-07
MI8_MXPA1 QN s VDD VDD pm1p2_svt_lp L=6e-08 W=2.95e-07
MI23_MXPA1 bclk nclk VDD VDD pm1p2_svt_lp L=6e-08 W=1.9e-07
MI22_MXPA1 nclk CK VDD VDD pm1p2_svt_lp L=6e-08 W=1.7e-07
.ENDS

.SUBCKT DFFSQNX1H9R QN VDD VSS CK D SN
MI83_MXNA1 nd D VSS VSS nm1p2_svt_lp L=6e-08 W=4.1e-07
MI33_MXNOE nm nclk nd VSS nm1p2_svt_lp L=6e-08 W=2.6e-07
MI31_MXNOE nm bclk XI31_n1 VSS nm1p2_svt_lp L=6e-08 W=1.5e-07
MI31_MXNA1 XI31_n1 m VSS VSS nm1p2_svt_lp L=6e-08 W=1.5e-07
MI0_MXNA2 XI0_n1 nm VSS VSS nm1p2_svt_lp L=6e-08 W=3.2e-07
MI0_MXNA1 m SN XI0_n1 VSS nm1p2_svt_lp L=6e-08 W=3.2e-07
MI20_MXNOE s bclk m VSS nm1p2_svt_lp L=6e-08 W=2.6e-07
MXN4 s nclk net58 VSS nm1p2_svt_lp L=6e-08 W=2e-07
MXN0 net58 ns net54 VSS nm1p2_svt_lp L=6e-08 W=2e-07
MXN1 net54 SN VSS VSS nm1p2_svt_lp L=6e-08 W=2e-07
MI28_MXNA1 ns s VSS VSS nm1p2_svt_lp L=6e-08 W=1.2e-07
MI8_MXNA1 QN s VSS VSS nm1p2_svt_lp L=6e-08 W=4.2e-07
MI23_MXNA1 bclk nclk VSS VSS nm1p2_svt_lp L=6e-08 W=1.5e-07
MI22_MXNA1 nclk CK VSS VSS nm1p2_svt_lp L=6e-08 W=1.7e-07
MI83_MXPA1 nd D VDD VDD pm1p2_svt_lp L=6e-08 W=2.7e-07
MI33_MXPOEN nm bclk nd VDD pm1p2_svt_lp L=6e-08 W=2.6e-07
MI31_MXPOEN nm nclk XI31_p1 VDD pm1p2_svt_lp L=6e-08 W=1.5e-07
MI31_MXPA1 XI31_p1 m VDD VDD pm1p2_svt_lp L=6e-08 W=1.5e-07
MI0_MXPA2 m nm VDD VDD pm1p2_svt_lp L=6e-08 W=2.4e-07
MI0_MXPA1 m SN VDD VDD pm1p2_svt_lp L=6e-08 W=2.4e-07
MI20_MXPOEN s nclk m VDD pm1p2_svt_lp L=6e-08 W=2.6e-07
MXP1 s bclk net79 VDD pm1p2_svt_lp L=6e-08 W=1.5e-07
MXP0 net79 ns VDD VDD pm1p2_svt_lp L=6e-08 W=1.5e-07
MXP4 s SN VDD VDD pm1p2_svt_lp L=6e-08 W=1.5e-07
MI28_MXPA1 ns s VDD VDD pm1p2_svt_lp L=6e-08 W=1.2e-07
MI8_MXPA1 QN s VDD VDD pm1p2_svt_lp L=6e-08 W=5.85e-07
MI23_MXPA1 bclk nclk VDD VDD pm1p2_svt_lp L=6e-08 W=3e-07
MI22_MXPA1 nclk CK VDD VDD pm1p2_svt_lp L=6e-08 W=1.9e-07
.ENDS

.SUBCKT SDFFRPQX0P5H9R Q VDD VSS CK D R SE SI
MI57_MXNA1 nse SE VSS VSS nm1p2_svt_lp L=6e-08 W=1.5e-07
MI14_MXNOE nmux SE XI14_n1 VSS nm1p2_svt_lp L=6e-08 W=1.5e-07
MI14_MXNA1 XI14_n1 SI VSS VSS nm1p2_svt_lp L=6e-08 W=1.5e-07
MXN3 n1 nse VSS VSS nm1p2_svt_lp L=6e-08 W=1.5e-07
MXN2 nmux D n1 VSS nm1p2_svt_lp L=6e-08 W=1.5e-07
MI33_MXNOE nm nclk nmux VSS nm1p2_svt_lp L=6e-08 W=1.5e-07
MI31_MXNOE nm bclk XI31_n1 VSS nm1p2_svt_lp L=6e-08 W=1.5e-07
MI31_MXNA1 XI31_n1 m VSS VSS nm1p2_svt_lp L=6e-08 W=1.5e-07
MI0_MXNA2 m nm VSS VSS nm1p2_svt_lp L=6e-08 W=1.5e-07
MI0_MXNA1 m R VSS VSS nm1p2_svt_lp L=6e-08 W=1.5e-07
MI20_MXNOE s bclk m VSS nm1p2_svt_lp L=6e-08 W=1.5e-07
MXN4 s nclk net62 VSS nm1p2_svt_lp L=6e-08 W=1.5e-07
MXN0 net62 ns VSS VSS nm1p2_svt_lp L=6e-08 W=1.5e-07
MXN1 s R VSS VSS nm1p2_svt_lp L=6e-08 W=1.5e-07
MI28_MXNA1 ns s VSS VSS nm1p2_svt_lp L=6e-08 W=2.6e-07
MI8_MXNA1 Q ns VSS VSS nm1p2_svt_lp L=6e-08 W=2.1e-07
MI23_MXNA1 bclk nclk VSS VSS nm1p2_svt_lp L=6e-08 W=1.5e-07
MI22_MXNA1 nclk CK VSS VSS nm1p2_svt_lp L=6e-08 W=1.5e-07
MI57_MXPA1 nse SE VDD VDD pm1p2_svt_lp L=6e-08 W=2e-07
MI14_MXPOEN nmux nse XI14_p1 VDD pm1p2_svt_lp L=6e-08 W=1.5e-07
MI14_MXPA1 XI14_p1 SI VDD VDD pm1p2_svt_lp L=6e-08 W=1.5e-07
MXP2 p1 SE VDD VDD pm1p2_svt_lp L=6e-08 W=2e-07
MXP3 nmux D p1 VDD pm1p2_svt_lp L=6e-08 W=2e-07
MI33_MXPOEN nm bclk nmux VDD pm1p2_svt_lp L=6e-08 W=1.5e-07
MI31_MXPOEN nm nclk XI31_p1 VDD pm1p2_svt_lp L=6e-08 W=1.5e-07
MI31_MXPA1 XI31_p1 m VDD VDD pm1p2_svt_lp L=6e-08 W=1.5e-07
MI0_MXPA2 XI0_p1 nm VDD VDD pm1p2_svt_lp L=6e-08 W=3e-07
MI0_MXPA1 m R XI0_p1 VDD pm1p2_svt_lp L=6e-08 W=3e-07
MI20_MXPOEN s nclk m VDD pm1p2_svt_lp L=6e-08 W=1.5e-07
MXP1 s bclk net85 VDD pm1p2_svt_lp L=6e-08 W=2e-07
MXP0 net85 ns net77 VDD pm1p2_svt_lp L=6e-08 W=2e-07
MXP5 net77 R VDD VDD pm1p2_svt_lp L=6e-08 W=2e-07
MI28_MXPA1 ns s VDD VDD pm1p2_svt_lp L=6e-08 W=2.2e-07
MI8_MXPA1 Q ns VDD VDD pm1p2_svt_lp L=6e-08 W=2.95e-07
MI23_MXPA1 bclk nclk VDD VDD pm1p2_svt_lp L=6e-08 W=1.9e-07
MI22_MXPA1 nclk CK VDD VDD pm1p2_svt_lp L=6e-08 W=1.7e-07
.ENDS

.SUBCKT TIELOX1H9R Y VDD VSS
MXNhi1 lo hi VSS VSS nm1p2_svt_lp L=6e-08 W=1.5e-07
MXNhi2 Y hi VSS VSS nm1p2_svt_lp L=6e-08 W=4.2e-07
MXPlo hi lo VDD VDD pm1p2_svt_lp L=6e-08 W=1.5e-07
MXPhi hi hi VDD VDD pm1p2_svt_lp L=6e-08 W=1.5e-07
.ENDS

.SUBCKT DLY2X0P5H9R Y VDD VSS A
MI0_MXNA1 XI0_n1 A VSS VSS nm1p2_svt_lp L=6e-08 W=1.5e-07
MI0_MXNOE ny A XI0_n1 VSS nm1p2_svt_lp L=6e-08 W=1.5e-07
MXN0 VSS ny VSS VSS nm1p2_svt_lp L=6e-08 W=1.6e-07
MI1_MXNA1 Y ny VSS VSS nm1p2_svt_lp L=6e-08 W=2.05e-07
MI0_MXPOEN ny A XI0_p1 VDD pm1p2_svt_lp L=6e-08 W=2.1e-07
MI0_MXPA1 XI0_p1 A VDD VDD pm1p2_svt_lp L=6e-08 W=2.1e-07
MI1_MXPA1 Y ny VDD VDD pm1p2_svt_lp L=6e-08 W=2.85e-07
MXP0 VDD ny VDD VDD pm1p2_svt_lp L=6e-08 W=1.7e-07
.ENDS

.SUBCKT DLY2X1H9R Y VDD VSS A
MI0_MXNA1 XI0_n1 A VSS VSS nm1p2_svt_lp L=6e-08 W=1.8e-07
MI0_MXNOE ny A XI0_n1 VSS nm1p2_svt_lp L=6e-08 W=1.8e-07
MXN0 VSS ny VSS VSS nm1p2_svt_lp L=6e-08 W=1.8e-07
MI1_MXNA1 Y ny VSS VSS nm1p2_svt_lp L=6e-08 W=4.2e-07
MI0_MXPOEN ny A XI0_p1 VDD pm1p2_svt_lp L=6e-08 W=2.25e-07
MI0_MXPA1 XI0_p1 A VDD VDD pm1p2_svt_lp L=6e-08 W=2.25e-07
MXP0 VDD ny VDD VDD pm1p2_svt_lp L=6e-08 W=2.25e-07
MI1_MXPA1 Y ny VDD VDD pm1p2_svt_lp L=6e-08 W=5.85e-07
.ENDS

.SUBCKT AOI2BB1X0P5H9R A1 A2 B ZN VDD VSS
MM3 net24 A1 VSS VSS nm1p2_svt_lp W=200.00n L=60.00n
MM2 net24 A2 VSS VSS nm1p2_svt_lp W=200.00n L=60.00n
MM0 ZN B VSS VSS nm1p2_svt_lp W=200.00n L=60.00n
MMN1 ZN net24 VSS VSS nm1p2_svt_lp W=200.00n L=60.00n
MM4 net24 A1 net056 VDD pm1p2_svt_lp W=300.00n L=60.00n
MM5 net056 A2 VDD VDD pm1p2_svt_lp W=300.00n L=60.00n
MM1 ZN net24 net064 VDD pm1p2_svt_lp W=300.00n L=60.00n
MMP1 net064 B VDD VDD pm1p2_svt_lp W=300.00n L=60.00n
.ENDS

.SUBCKT AO211X0P5H9R A1 A2 B C Z VDD VSS
MM6 net1 B VSS VSS nm1p2_svt_lp W=200.00n L=60.00n
MM1 net1 A1 net4 VSS nm1p2_svt_lp W=200.00n L=60.00n
MM2 Z net1 VSS VSS nm1p2_svt_lp W=200.00n L=60.00n
MM4 net1 C VSS VSS nm1p2_svt_lp W=200.00n L=60.00n
MMN1 net4 A2 VSS VSS nm1p2_svt_lp W=200.00n L=60.00n
MM7 net3 A1 VDD VDD pm1p2_svt_lp W=300.00n L=60.00n
MM5 net3 A2 VDD VDD pm1p2_svt_lp W=300.00n L=60.00n
MM3 Z net1 VDD VDD pm1p2_svt_lp W=300.00n L=60.00n
MM0 net2 B net3 VDD pm1p2_svt_lp W=300.00n L=60.00n
MMP1 net1 C net2 VDD pm1p2_svt_lp W=300.00n L=60.00n
.ENDS

.SUBCKT MAOI222X0P5H9R A B C ZN VDD VSS
MM6 ZN C net4 VSS nm1p2_svt_lp W=200.00n L=60.00n
MM10 net4 B VSS VSS nm1p2_svt_lp W=200.00n L=60.00n
MM9 net5 C VSS VSS nm1p2_svt_lp W=200.00n L=60.00n
MM1 ZN A net6 VSS nm1p2_svt_lp W=200.00n L=60.00n
MM4 ZN A net5 VSS nm1p2_svt_lp W=200.00n L=60.00n
MMN1 net6 B VSS VSS nm1p2_svt_lp W=200.00n L=60.00n
MM8 net2 C net1 VDD pm1p2_svt_lp W=300.0n L=60.00n
MM11 ZN B net2 VDD pm1p2_svt_lp W=300.0n L=60.00n
MM7 net1 B VDD VDD pm1p2_svt_lp W=300.0n L=60.00n
MM5 net1 C VDD VDD pm1p2_svt_lp W=300.0n L=60.00n
MM0 net2 A net1 VDD pm1p2_svt_lp W=300.0n L=60.00n
MMP1 ZN A net2 VDD pm1p2_svt_lp W=300.0n L=60.00n
.ENDS

.SUBCKT OAOI211X0P5H9R A1 A2 B C ZN VDD VSS
MM3 ZN C net18 VDD pm1p2_svt_lp W=250.00n L=60.00n
MM4 net18 B VDD VDD pm1p2_svt_lp W=250.00n L=60.00n
MM0 net21 A2 VDD VDD pm1p2_svt_lp W=250.00n L=60.00n
MMP1 net18 A1 net21 VDD pm1p2_svt_lp W=250.00n L=60.00n
MM5 ZN C VSS VSS nm1p2_svt_lp W=200.00n L=60.00n
MM2 ZN B net30 VSS nm1p2_svt_lp W=200.00n L=60.00n
MM1 net30 A1 VSS VSS nm1p2_svt_lp W=200.00n L=60.00n
MMN1 net30 A2 VSS VSS nm1p2_svt_lp W=200.00n L=60.00n
.ENDS

.SUBCKT OAOI211X2H9R A1 A2 B C ZN VDD VSS
MMN1 net10 A2 VSS VSS nm1p2_svt_lp W=430.00n L=60.00n
MM1 net10 A1 VSS VSS nm1p2_svt_lp W=430.00n L=60.00n
MM2 ZN B net10 VSS nm1p2_svt_lp W=430.00n L=60.00n
MM5 ZN C VSS VSS nm1p2_svt_lp W=430.00n L=60.00n
MMP1 net22 A1 net25 VDD pm1p2_svt_lp W=540.00n L=60.00n
MM0 net25 A2 VDD VDD pm1p2_svt_lp W=540.00n L=60.00n
MM4 net22 B VDD VDD pm1p2_svt_lp W=540.00n L=60.00n
MM3 ZN C net22 VDD pm1p2_svt_lp W=540.00n L=60.00n
.ENDS

.SUBCKT DFFRX1H9R CK D Q QN RDN VDD VSS
MM45 QN net43 VSS VSS nm1p2_svt_lp W=290.00n L=60.00n
MM3 net_0154 c net43 VSS nm1p2_svt_lp W=290.00n L=60.00n
MM44 net_0104 RDN VSS VSS nm1p2_svt_lp W=290.00n L=60.00n
MM42 VSS RDN net_0119 VSS nm1p2_svt_lp W=200.00n L=60.00n
MM39 s net43 net_099 VSS nm1p2_svt_lp W=290.00n L=60.00n
MM40 net_099 RDN VSS VSS nm1p2_svt_lp W=290.00n L=60.00n
MM30 c cn VSS VSS nm1p2_svt_lp W=200.00n L=60.00n
MM27 cn CK VSS VSS nm1p2_svt_lp W=200.00n L=60.00n
MM24 net48 cn net43 VSS nm1p2_svt_lp W=200.00n L=60.00n
MM23 VSS s net48 VSS nm1p2_svt_lp W=200.00n L=60.00n
MM19 Q s VSS VSS nm1p2_svt_lp W=290.00n L=60.00n
MM12 net52 c pm VSS nm1p2_svt_lp W=200.00n L=60.00n
MM11 net_0119 net_0154 net52 VSS nm1p2_svt_lp W=200.00n L=60.00n
MM9 pm cn net69 VSS nm1p2_svt_lp W=290.00n L=60.00n
MM7 net69 D net_0104 VSS nm1p2_svt_lp W=290.00n L=60.00n
MM0 net_0154 pm VSS VSS nm1p2_svt_lp W=290.00n L=60.00n
MM46 QN net43 VDD VDD pm1p2_svt_lp W=440.00n L=60.00n
MM43 pm RDN VDD VDD pm1p2_svt_lp W=300.00n L=60.00n
MM38 s net43 VDD VDD pm1p2_svt_lp W=300.00n L=60.00n
MM41 s RDN VDD VDD pm1p2_svt_lp W=300.00n L=60.00n
MM29 c cn VDD VDD pm1p2_svt_lp W=300.00n L=60.00n
MM28 cn CK VDD VDD pm1p2_svt_lp W=300.00n L=60.00n
MM26 VDD s net109 VDD pm1p2_svt_lp W=300.00n L=60.00n
MM25 net109 c net43 VDD pm1p2_svt_lp W=300.00n L=60.00n
MM20 Q s VDD VDD pm1p2_svt_lp W=440.00n L=60.00n
MM4 net_0154 cn net43 VDD pm1p2_svt_lp W=440.00n L=60.00n
MM14 net117 cn pm VDD pm1p2_svt_lp W=300.00n L=60.00n
MM13 VDD net_0154 net117 VDD pm1p2_svt_lp W=300.00n L=60.00n
MM10 pm c net128 VDD pm1p2_svt_lp W=300.00n L=60.00n
MM8 net128 D VDD VDD pm1p2_svt_lp W=300.00n L=60.00n
MM1 net_0154 pm VDD VDD pm1p2_svt_lp W=440.00n L=60.00n
.ENDS

.SUBCKT DFFRQX1H9R CK D Q RDN VDD VSS
MM3 net_0154 c net43 VSS nm1p2_svt_lp W=290.00n L=60.00n
MM44 net_0104 RDN VSS VSS nm1p2_svt_lp W=290.00n L=60.00n
MM42 VSS RDN net_0119 VSS nm1p2_svt_lp W=200.00n L=60.00n
MM39 s net43 net_099 VSS nm1p2_svt_lp W=290.00n L=60.00n
MM40 net_099 RDN VSS VSS nm1p2_svt_lp W=290.00n L=60.00n
MM30 c cn VSS VSS nm1p2_svt_lp W=200.00n L=60.00n
MM27 cn CK VSS VSS nm1p2_svt_lp W=200.00n L=60.00n
MM24 net48 cn net43 VSS nm1p2_svt_lp W=200.00n L=60.00n
MM23 VSS s net48 VSS nm1p2_svt_lp W=200.00n L=60.00n
MM19 Q s VSS VSS nm1p2_svt_lp W=290.00n L=60.00n
MM12 net52 c pm VSS nm1p2_svt_lp W=200.00n L=60.00n
MM11 net_0119 net_0154 net52 VSS nm1p2_svt_lp W=200.00n L=60.00n
MM9 pm cn net69 VSS nm1p2_svt_lp W=290.00n L=60.00n
MM7 net69 D net_0104 VSS nm1p2_svt_lp W=290.00n L=60.00n
MM0 net_0154 pm VSS VSS nm1p2_svt_lp W=290.00n L=60.00n
MM43 pm RDN VDD VDD pm1p2_svt_lp W=300.00n L=60.00n
MM38 s net43 VDD VDD pm1p2_svt_lp W=300.00n L=60.00n
MM41 s RDN VDD VDD pm1p2_svt_lp W=300.00n L=60.00n
MM29 c cn VDD VDD pm1p2_svt_lp W=300.00n L=60.00n
MM28 cn CK VDD VDD pm1p2_svt_lp W=300.00n L=60.00n
MM26 VDD s net109 VDD pm1p2_svt_lp W=300.00n L=60.00n
MM25 net109 c net43 VDD pm1p2_svt_lp W=300.00n L=60.00n
MM20 Q s VDD VDD pm1p2_svt_lp W=440.00n L=60.00n
MM4 net_0154 cn net43 VDD pm1p2_svt_lp W=440.00n L=60.00n
MM14 net117 cn pm VDD pm1p2_svt_lp W=300.00n L=60.00n
MM13 VDD net_0154 net117 VDD pm1p2_svt_lp W=300.00n L=60.00n
MM10 pm c net128 VDD pm1p2_svt_lp W=300.00n L=60.00n
MM8 net128 D VDD VDD pm1p2_svt_lp W=300.00n L=60.00n
MM1 net_0154 pm VDD VDD pm1p2_svt_lp W=440.00n L=60.00n
.ENDS
