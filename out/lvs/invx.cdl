.GLOBAL VDD VSS
.SUBCKT INVX0P5H9R Y VDD VSS A
MI0_MXNA1 Y A VSS VSS nm1p2_svt_lp L=6e-08 W=2.1e-07
MI0_MXPA1 Y A VDD VDD pm1p2_svt_lp L=6e-08 W=2.95e-07
.ENDS
.END
